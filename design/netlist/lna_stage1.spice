* lna_stage1 subcircuit, exported by xschem from design/lna_stage1.sch via 'klt netlist --block'
* tools: XSCHEM V3.4.7; klt 0.9.2.dev1022+g2a9c52b27ce7; sources sha256 (lna_stage1.sch then lna_stage1.sym concatenated): c6c82d72a0e711158ae6fc75a4d4f7e6293eba6b75819432d08b29b52eda64c2
* DERIVED FILE: regenerate with design/export_netlist.sh, never edit by hand.
* Matching elements (Cshunt, Lin, Lfeed, Cm) and the emitter-degeneration inductor Le1 are IDEAL lossless L/C: no PDK inductor model exists.
** klt-netlist-inputs: {"pdk_variant": "ihp-sg13cmos5l", "rcfile": "xschemrc", "xschem_version": "3.4.7"}
** sch_path: design/lna_stage1.sch
.subckt lna_stage1 in out vdd gnd
*.ipin in
*.opin out
*.iopin vdd
*.iopin gnd
Rref vdd nr 8k m=1
Xqr nr br er gnd npn13G2 Nx=1
Rbr nr br 60.9k m=1
Rer er gnd 24 m=1
Rbias nr b1 10k m=1
Lfeed vdd oc 0.962n m=1
Rd vdd oc 465 m=1
Xq2 oc b2 c1 gnd npn13G2 Nx=8
Xq1 c1 b1 e1 gnd npn13G2 Nx=8
Le1 e1 e1d 67p m=1
Re1 e1d gnd 3 m=1
R1b vdd b2 1.5k m=1
R2b b2 gnd 7k m=1
Cb2 b2 gnd 10p m=1
Cshunt in gnd 170f m=1
Lin in in2 1.41n m=1
Cblk_in in2 b1 1n m=1
Cm oc out 57.8f m=1
.ends
