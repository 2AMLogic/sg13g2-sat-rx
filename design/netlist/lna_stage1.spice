* lna_stage1 subcircuit, exported by xschem from design/lna_stage1.sch via 'klt netlist --block'
* tools: XSCHEM V3.4.4; klt 0.7.0+g5e5b55992a7f; sources sha256 (lna_stage1.sch then lna_stage1.sym concatenated): c1a3c91f0ec775b4287c195dee05f305f8b1bf34e5b6ee27e83021a884ff46d4
* DERIVED FILE: regenerate with design/export_netlist.sh, never edit by hand.
* Matching elements (Cshunt, Lin, Lfeed, Cm) are IDEAL lossless L/C: no PDK inductor model exists.
** sch_path: design/lna_stage1.sch
.subckt lna_stage1 in out vdd gnd
*.ipin in
*.opin out
*.iopin vdd
*.iopin gnd
Rref vdd nr 8k m=1
Xqr nr nr er gnd npn13G2 Nx=1
Rer er gnd 24 m=1
Rbias nr b1 2k m=1
Lfeed vdd oc 0.962n m=1
Rd vdd oc 465 m=1
Xq2 oc b2 c1 gnd npn13G2 Nx=8
Xq1 c1 b1 e1 gnd npn13G2 Nx=8
Re1 e1 gnd 3 m=1
R1b vdd b2 1.5k m=1
R2b b2 gnd 7k m=1
Cb2 b2 gnd 10p m=1
Cshunt in gnd 170f m=1
Lin in in2 1.41n m=1
Cblk_in in2 b1 1n m=1
Cm oc out 57.8f m=1
.ends
