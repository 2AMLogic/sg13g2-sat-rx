* tb_lna_stage1 netlist, exported by xschem from design/{lna_stage1.sch,lna_stage1.sym,tb_lna_stage1.sch}
* tool: XSCHEM V3.4.4; sources sha256 (concatenated in that order): febf1b239c3b215aee65d6ec947b0a3c3d3ea66c1930b8c2902b25895c7417d7
* DERIVED FILE: regenerate with design/export_netlist.sh, never edit by hand.
** sch_path: tb_lna_stage1.sch
**.subckt tb_lna_stage1
xdut in out vdd gnd lna_stage1
Vdd vdd gnd 2.5
Rs1 in gnd 50 m=1
Rs2 out gnd 50 m=1
**.ends
* expanding   symbol:  lna_stage1.sym # of pins=4
** sch_path: lna_stage1.sch
.subckt lna_stage1 in out vdd gnd
*.ipin in
*.opin out
*.iopin vdd
*.iopin gnd
Rref vdd nr 8k m=1
Xqr nr nr er gnd npn13G2 Nx=1
Rer er gnd 24 m=1
Rbias nr b1 2k m=1
Lfeed vdd oc 0.962n m=1
Rd vdd oc 465 m=1
Xq2 oc b2 c1 gnd npn13G2 Nx=8
Xq1 c1 b1 e1 gnd npn13G2 Nx=8
Re1 e1 gnd 3 m=1
R1b vdd b2 1.5k m=1
R2b b2 gnd 7k m=1
Cb2 b2 gnd 10p m=1
Cshunt in gnd 170f m=1
Lin in in2 1.41n m=1
Cblk_in in2 b1 1n m=1
Cm oc out 57.8f m=1
.ends
.GLOBAL GND
.end
