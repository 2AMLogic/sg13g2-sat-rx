* lna-sparam-nf: klt sim body, lna-headroom stage-2 candidate C08, supply 2.5 V -- GENERATED by sim/lna-headroom/run.py, do not edit
.param vdd_nom=2.5
.param vdd_val=2.5
.param mag1=1
.param mag2=0

* LNA first-stage (lna_stage1) S-parameter / noise-figure two-port fixture (issue #28).
*
* DUT: design/lna_stage1.sch -- npn13G2 cascode (Q1 common-emitter with a small
* emitter resistor, Q2 common-base), diode-mirror bias for Q1, divider bias for
* Q2, ideal lossless L/C input and output matching. Embedded below verbatim
* from design/netlist/lna_stage1.spice (xschem export).
*
* IDEAL / BEHAVIORAL MATCHING: Cshunt, Lin (input) and Lfeed, Cm (output) are
* ideal lossless ngspice L and C. No SG13G2 inductor model exists, so no loss,
* Q, self-resonance or layout parasitic is represented; every S11/S22/S21/NF
* number from this fixture is an upper bound for what a real passive match
* allows and is a FEASIBILITY figure only. Nothing here claims a spec row.
*
* Two-port test method: unchanged from lna_ce_placeholder.spice (power-wave
* injection through a Thevenin Z0 = 50 ohm source per port, forward/reverse by
* alterparam + reset, S = 2*V(port) - 1 for the driven port and 2*V(other)
* for the transmission term; Rs1 noiseless with the source noise added
* analytically at T0 = 300.15 K, issue #22). The DUT has its own DC blocks
* (Cblk_in, Cblk_out), so the ports connect directly.
*
* Ports: p1 = input, p2 = output, vdd = the PVT supply rail (vdd_val).

* ==== BEGIN design/netlist/lna_stage1.spice (verbatim; do not edit here) ====
* EXPERIMENTAL VARIANT C08 of design/netlist/lna_stage1.spice (issue #132): R1b=1200 R2b=7300 Rd=200 ohm; everything else is the committed DUT.
* GENERATED by sim/lna-headroom/run.py; NOT a production schematic; do not edit.
* lna_stage1 subcircuit, exported by xschem from design/lna_stage1.sch via 'klt netlist --block'
* tools: XSCHEM V3.4.4; klt 0.7.0+g5e5b55992a7f; sources sha256 (lna_stage1.sch then lna_stage1.sym concatenated): c1a3c91f0ec775b4287c195dee05f305f8b1bf34e5b6ee27e83021a884ff46d4
* DERIVED FILE: regenerate with design/export_netlist.sh, never edit by hand.
* Matching elements (Cshunt, Lin, Lfeed, Cm) are IDEAL lossless L/C: no PDK inductor model exists.
** sch_path: design/lna_stage1.sch
.subckt lna_stage1 in out vdd gnd
*.ipin in
*.opin out
*.iopin vdd
*.iopin gnd
Rref vdd nr 8k m=1
Xqr nr nr er gnd npn13G2 Nx=1
Rer er gnd 24 m=1
Rbias nr b1 2k m=1
Lfeed vdd oc 0.962n m=1
Rd vdd oc 200 m=1
Xq2 oc b2 c1 gnd npn13G2 Nx=8
Xq1 c1 b1 e1 gnd npn13G2 Nx=8
Re1 e1 gnd 3 m=1
R1b vdd b2 1200 m=1
R2b b2 gnd 7300 m=1
Cb2 b2 gnd 10p m=1
Cshunt in gnd 170f m=1
Lin in in2 1.41n m=1
Cblk_in in2 b1 1n m=1
Cm oc out 57.8f m=1
.ends
* ==== END design/netlist/lna_stage1.spice ====

.param z0=50
.param mag1=1 mag2=0

Vdd vdd 0 DC {vdd_val}
Xdut p1 p2 vdd 0 lna_stage1

Vs1 s1n 0 DC 0 AC {mag1}
Rs1 s1n p1 {z0} noisy=0

Vs2 s2n 0 DC 0 AC {mag2}
Rs2 s2n p2 {z0}

.control
set numdgt=10
set noaskquit
  op
  let q1_vce = v(xdut.c1) - v(xdut.e1)
  let q1_vbe = v(xdut.b1) - v(xdut.e1)
  let q1_ic = @q.xdut.xq1.qnpn13g2[ic]
  let q1_icfrac = @q.xdut.xq1.qnpn13g2[ic]/(3e-3*8)
  let q1_dtj = v(xdut.xq1.t)
  let q1_ft = @q.xdut.xq1.qnpn13g2[gm]/(2*3.14159265358979*(@q.xdut.xq1.qnpn13g2[cbe]+@q.xdut.xq1.qnpn13g2[cbex]+@q.xdut.xq1.qnpn13g2[cbc]+@q.xdut.xq1.qnpn13g2[cbcx]+@q.xdut.xq1.qnpn13g2[cbep]+@q.xdut.xq1.qnpn13g2[cbcp]))/1e9
  let q2_vce = v(xdut.oc) - v(xdut.c1)
  let q2_vbe = v(xdut.b2) - v(xdut.c1)
  let q2_ic = @q.xdut.xq2.qnpn13g2[ic]
  let q2_icfrac = @q.xdut.xq2.qnpn13g2[ic]/(3e-3*8)
  let q2_dtj = v(xdut.xq2.t)
  let q2_ft = @q.xdut.xq2.qnpn13g2[gm]/(2*3.14159265358979*(@q.xdut.xq2.qnpn13g2[cbe]+@q.xdut.xq2.qnpn13g2[cbex]+@q.xdut.xq2.qnpn13g2[cbc]+@q.xdut.xq2.qnpn13g2[cbcx]+@q.xdut.xq2.qnpn13g2[cbep]+@q.xdut.xq2.qnpn13g2[cbcp]))/1e9
  let qr_vce = v(xdut.nr) - v(xdut.er)
  let qr_vbe = v(xdut.nr) - v(xdut.er)
  let qr_ic = @q.xdut.xqr.qnpn13g2[ic]
  let qr_icfrac = @q.xdut.xqr.qnpn13g2[ic]/(3e-3*1)
  let qr_dtj = v(xdut.xqr.t)
  let qr_ft = @q.xdut.xqr.qnpn13g2[gm]/(2*3.14159265358979*(@q.xdut.xqr.qnpn13g2[cbe]+@q.xdut.xqr.qnpn13g2[cbex]+@q.xdut.xqr.qnpn13g2[cbc]+@q.xdut.xqr.qnpn13g2[cbcx]+@q.xdut.xqr.qnpn13g2[cbep]+@q.xdut.xqr.qnpn13g2[cbcp]))/1e9
  let idd_ma = -i(vdd)*1e3
  let pdc_mw = -i(vdd)*v(vdd)*1e3
  ac lin 3 17.7e9 21.2e9
  alterparam mag1 = 0
  alterparam mag2 = 1
  reset
  ac lin 3 17.7e9 21.2e9
  alterparam mag1 = 1
  alterparam mag2 = 0
  reset
  noise v(p2) vs1 lin 3 17.7e9 21.2e9
  ac dec 100 1e9 1e11
  alterparam mag1 = 0
  alterparam mag2 = 1
  reset
  ac dec 100 1e9 1e11
  alterparam mag1 = 1
  alterparam mag2 = 0
  reset
  let s11 = 2*ac1.v(p1) - 1
  let s21 = 2*ac1.v(p2)
  let s22 = 2*ac2.v(p2) - 1
  let s12 = 2*ac2.v(p1)
  let delta_det = s11*s22 - s12*s21
  let kfactor = (1 - mag(s11)*mag(s11) - mag(s22)*mag(s22) + mag(delta_det)*mag(delta_det)) / (2*mag(s12)*mag(s21))
  let w11 = 2*ac3.v(p1) - 1
  let w21 = 2*ac3.v(p2)
  let w22 = 2*ac4.v(p2) - 1
  let w12 = 2*ac4.v(p1)
  let wdel = w11*w22 - w12*w21
  let wf = real(ac3.frequency)
  let wk = real((1 - mag(w11)*mag(w11) - mag(w22)*mag(w22) + mag(wdel)*mag(wdel)) / (2*mag(w12)*mag(w21)))
  let wd = mag(wdel)
  let wmu = (1 - mag(w11)*mag(w11)) / (mag(w22 - wdel*conj(w11)) + mag(w12*w21))
  let wunst = pos(1 - wk) + pos(wd - 1) - pos(1 - wk)*pos(wd - 1)
  let whi = pos(wf - 21.2e9)
  let wlo = pos(17.7e9 - wf)
  let wk_hi = wk + 1e6*(1 - whi)
  let wk_lo = wk + 1e6*(1 - wlo)
  let wkmin = vecmin(wk)
  let wfk = vecmax((1 - pos(wk - wkmin))*wf)
  let wmu_min = vecmin(wmu)
  let wdmax = vecmax(wd)
  let wnunst = mean(wunst)*length(wk)
  let d_all = mag(delta_det)
  let mu_den = mag(s22 - delta_det*conj(s11)) + mag(s12*s21)
  let mu_all = (1 - mag(s11)*mag(s11)) / mu_den
  let msg_all = mag(s21)/mag(s12)
  set width = 200
  set height = 100000
  echo SWEEP_BEGIN
  print wf wk wd wmu
  echo SWEEP_END
  let m_s11_db_lo = db(s11)[0]
  let m_s11_db_mid = db(s11)[1]
  let m_s11_db_hi = db(s11)[2]
  let m_s21_db_lo = db(s21)[0]
  let m_s21_db_mid = db(s21)[1]
  let m_s21_db_hi = db(s21)[2]
  let m_s22_db_lo = db(s22)[0]
  let m_s22_db_mid = db(s22)[1]
  let m_s22_db_hi = db(s22)[2]
  let m_s12_db_lo = db(s12)[0]
  let m_s12_db_mid = db(s12)[1]
  let m_s12_db_hi = db(s12)[2]
  let m_k_lo = real(kfactor[0])
  let m_k_mid = real(kfactor[1])
  let m_k_hi = real(kfactor[2])
  let m_nf_db_lo = 10*log10(1+(noise2.inoise_spectrum[0]*noise2.inoise_spectrum[0])/(4*1.380649e-23*300.15*50))
  let m_nf_db_mid = 10*log10(1+(noise2.inoise_spectrum[1]*noise2.inoise_spectrum[1])/(4*1.380649e-23*300.15*50))
  let m_nf_db_hi = 10*log10(1+(noise2.inoise_spectrum[2]*noise2.inoise_spectrum[2])/(4*1.380649e-23*300.15*50))
  let m_q1_vce = op1.q1_vce
  let m_q1_vbe = op1.q1_vbe
  let m_q1_ic = op1.q1_ic
  let m_q1_icfrac = op1.q1_icfrac
  let m_q1_dtj = op1.q1_dtj
  let m_q1_ft = op1.q1_ft
  let m_q2_vce = op1.q2_vce
  let m_q2_vbe = op1.q2_vbe
  let m_q2_ic = op1.q2_ic
  let m_q2_icfrac = op1.q2_icfrac
  let m_q2_dtj = op1.q2_dtj
  let m_q2_ft = op1.q2_ft
  let m_qr_vce = op1.qr_vce
  let m_qr_vbe = op1.qr_vbe
  let m_qr_ic = op1.qr_ic
  let m_qr_icfrac = op1.qr_icfrac
  let m_qr_dtj = op1.qr_dtj
  let m_qr_ft = op1.qr_ft
  let m_idd_ma = op1.idd_ma
  let m_pdc_mw = op1.pdc_mw
  let m_d_lo = real(d_all[0])
  let m_mu_lo = real(mu_all[0])
  let m_msg_db_lo = db(msg_all[0])
  let m_d_mid = real(d_all[1])
  let m_mu_mid = real(mu_all[1])
  let m_msg_db_mid = db(msg_all[1])
  let m_d_hi = real(d_all[2])
  let m_mu_hi = real(mu_all[2])
  let m_msg_db_hi = db(msg_all[2])
  let m_sw_n = length(wk)
  let m_sw_kmin = wkmin
  let m_sw_fkmin_ghz = wfk/1e9
  let m_sw_kmin_hi = vecmin(wk_hi)
  let m_sw_kmin_lo = vecmin(wk_lo)
  let m_sw_dmax = wdmax
  let m_sw_mumin = wmu_min
  let m_sw_nunst = wnunst
  print m_s11_db_lo
  print m_s11_db_mid
  print m_s11_db_hi
  print m_s21_db_lo
  print m_s21_db_mid
  print m_s21_db_hi
  print m_s22_db_lo
  print m_s22_db_mid
  print m_s22_db_hi
  print m_s12_db_lo
  print m_s12_db_mid
  print m_s12_db_hi
  print m_k_lo
  print m_k_mid
  print m_k_hi
  print m_nf_db_lo
  print m_nf_db_mid
  print m_nf_db_hi
  print m_q1_vce
  print m_q1_vbe
  print m_q1_ic
  print m_q1_icfrac
  print m_q1_dtj
  print m_q1_ft
  print m_q2_vce
  print m_q2_vbe
  print m_q2_ic
  print m_q2_icfrac
  print m_q2_dtj
  print m_q2_ft
  print m_qr_vce
  print m_qr_vbe
  print m_qr_ic
  print m_qr_icfrac
  print m_qr_dtj
  print m_qr_ft
  print m_idd_ma
  print m_pdc_mw
  print m_d_lo
  print m_mu_lo
  print m_msg_db_lo
  print m_d_mid
  print m_mu_mid
  print m_msg_db_mid
  print m_d_hi
  print m_mu_hi
  print m_msg_db_hi
  print m_sw_n
  print m_sw_kmin
  print m_sw_fkmin_ghz
  print m_sw_kmin_hi
  print m_sw_kmin_lo
  print m_sw_dmax
  print m_sw_mumin
  print m_sw_nunst
.endc
