* lna-headroom C10 -- GENERATED by sim/lna-headroom/run.py, do not edit
.param z0=50
.param va1=0 va2=0

* EXPERIMENTAL VARIANT C10 of design/netlist/lna_stage1.spice (issue #123): R1b=1050 R2b=7450 Rd=300 ohm; everything else is the committed DUT.
* GENERATED by sim/lna-headroom/run.py; NOT a production schematic; do not edit.
* lna_stage1 subcircuit, exported by xschem from design/lna_stage1.sch via 'klt netlist --block'
* tools: XSCHEM V3.4.4; klt 0.7.0+g5e5b55992a7f; sources sha256 (lna_stage1.sch then lna_stage1.sym concatenated): c1a3c91f0ec775b4287c195dee05f305f8b1bf34e5b6ee27e83021a884ff46d4
* DERIVED FILE: regenerate with design/export_netlist.sh, never edit by hand.
* Matching elements (Cshunt, Lin, Lfeed, Cm) are IDEAL lossless L/C: no PDK inductor model exists.
** sch_path: design/lna_stage1.sch
.subckt lna_stage1 in out vdd gnd
*.ipin in
*.opin out
*.iopin vdd
*.iopin gnd
Rref vdd nr 8k m=1
Xqr nr nr er gnd npn13G2 Nx=1
Rer er gnd 24 m=1
Rbias nr b1 2k m=1
Lfeed vdd oc 0.962n m=1
Rd vdd oc 300 m=1
Xq2 oc b2 c1 gnd npn13G2 Nx=8
Xq1 c1 b1 e1 gnd npn13G2 Nx=8
Re1 e1 gnd 3 m=1
R1b vdd b2 1050 m=1
R2b b2 gnd 7450 m=1
Cb2 b2 gnd 10p m=1
Cshunt in gnd 170f m=1
Lin in in2 1.41n m=1
Cblk_in in2 b1 1n m=1
Cm oc out 57.8f m=1
.ends

.param vdd_val=2.5
Vdd vdd 0 DC {vdd_val}
Xdut p1 p2 vdd 0 lna_stage1
.options reltol=1e-06
.param fq1=1e10 fq2=1e10
Bs n2 0 V = (time<5e-09 ? 0.5*(1-cos(pi*time/5e-09)) : 1)*({va1}*sin(2*pi*{fq1}*time) + {va2}*sin(2*pi*{fq2}*time))
Rs n2 p1 {z0}
RL p2 0 {z0}

.control
set numdgt=12
set noaskquit
  * DC allocation of the candidate (operating point before any transient)
  op
  let m_dc_vc1 = v(xdut.c1)
  let m_dc_ve1 = v(xdut.e1)
  let m_dc_vb1 = v(xdut.b1)
  let m_dc_vb2 = v(xdut.b2)
  let m_dc_voc = v(xdut.oc)
  let m_dc_idd = -i(Vdd)
  print m_dc_vc1 m_dc_ve1 m_dc_vb1 m_dc_vb2 m_dc_voc m_dc_idd
  * run low_b_one00: one-tone, available power -56 dBm per tone
  alterparam fq1 = 17950000000.0
  alterparam fq2 = 17950000000.0
  alterparam va1 = 0.00100237446725455
  alterparam va2 = 0.0
  reset
  save all @q.xdut.xq1.qnpn13g2[ic] @q.xdut.xq2.qnpn13g2[ic]
  tran 1e-12 6e-08 0 1e-12
  linearize v(p2) v(xdut.c1) v(xdut.e1) v(xdut.oc) v(xdut.b1) v(xdut.b2) @q.xdut.xq1.qnpn13g2[ic] @q.xdut.xq2.qnpn13g2[ic]
  let tt = time[40000,59999]
  let xo = v(p2)[40000,59999]
  let m_low_b_one00_n = length(xo)
  let m_low_b_one00_t0 = tt[0]
  let m_low_b_one00_t1 = tt[19999]
  let m_low_b_one00_f0_c = 2*mean(xo*cos(2*pi*17950000000.0*tt))
  let m_low_b_one00_f0_s = 2*mean(xo*sin(2*pi*17950000000.0*tt))
  let m_low_b_one00_fl_lo_c = 2*mean(xo*cos(2*pi*17900000000.0*tt))
  let m_low_b_one00_fl_lo_s = 2*mean(xo*sin(2*pi*17900000000.0*tt))
  let m_low_b_one00_fl_hi_c = 2*mean(xo*cos(2*pi*18000000000.0*tt))
  let m_low_b_one00_fl_hi_s = 2*mean(xo*sin(2*pi*18000000000.0*tt))
  let m_low_b_one00_vce_q1_max = maximum(v(xdut.c1)[40000,59999] - v(xdut.e1)[40000,59999])
  let m_low_b_one00_vce_q1_min = minimum(v(xdut.c1)[40000,59999] - v(xdut.e1)[40000,59999])
  let m_low_b_one00_vce_q2_max = maximum(v(xdut.oc)[40000,59999] - v(xdut.c1)[40000,59999])
  let m_low_b_one00_vce_q2_min = minimum(v(xdut.oc)[40000,59999] - v(xdut.c1)[40000,59999])
  let m_low_b_one00_vbe_q1_max = maximum(v(xdut.b1)[40000,59999] - v(xdut.e1)[40000,59999])
  let m_low_b_one00_vbe_q1_min = minimum(v(xdut.b1)[40000,59999] - v(xdut.e1)[40000,59999])
  let m_low_b_one00_vbe_q2_max = maximum(v(xdut.b2)[40000,59999] - v(xdut.c1)[40000,59999])
  let m_low_b_one00_vbe_q2_min = minimum(v(xdut.b2)[40000,59999] - v(xdut.c1)[40000,59999])
  let w_low_b_one00_ic_q1 = @q.xdut.xq1.qnpn13g2[ic][40000,59999]
  let m_low_b_one00_ic_q1_max = maximum(w_low_b_one00_ic_q1)
  let m_low_b_one00_ic_q1_min = minimum(w_low_b_one00_ic_q1)
  let w_low_b_one00_ic_q2 = @q.xdut.xq2.qnpn13g2[ic][40000,59999]
  let m_low_b_one00_ic_q2_max = maximum(w_low_b_one00_ic_q2)
  let m_low_b_one00_ic_q2_min = minimum(w_low_b_one00_ic_q2)
  print m_low_b_one00_n m_low_b_one00_t0 m_low_b_one00_t1 m_low_b_one00_f0_c m_low_b_one00_f0_s m_low_b_one00_fl_lo_c
  print m_low_b_one00_fl_lo_s m_low_b_one00_fl_hi_c m_low_b_one00_fl_hi_s m_low_b_one00_vce_q1_max m_low_b_one00_vce_q1_min m_low_b_one00_vce_q2_max
  print m_low_b_one00_vce_q2_min m_low_b_one00_vbe_q1_max m_low_b_one00_vbe_q1_min m_low_b_one00_vbe_q2_max m_low_b_one00_vbe_q2_min m_low_b_one00_ic_q1_max
  print m_low_b_one00_ic_q1_min m_low_b_one00_ic_q2_max m_low_b_one00_ic_q2_min
  * run low_b_one01: one-tone, available power -54 dBm per tone
  alterparam fq1 = 17950000000.0
  alterparam fq2 = 17950000000.0
  alterparam va1 = 0.00126191468896039
  alterparam va2 = 0.0
  reset
  save all @q.xdut.xq1.qnpn13g2[ic] @q.xdut.xq2.qnpn13g2[ic]
  tran 1e-12 6e-08 0 1e-12
  linearize v(p2) v(xdut.c1) v(xdut.e1) v(xdut.oc) v(xdut.b1) v(xdut.b2) @q.xdut.xq1.qnpn13g2[ic] @q.xdut.xq2.qnpn13g2[ic]
  let tt = time[40000,59999]
  let xo = v(p2)[40000,59999]
  let m_low_b_one01_n = length(xo)
  let m_low_b_one01_t0 = tt[0]
  let m_low_b_one01_t1 = tt[19999]
  let m_low_b_one01_f0_c = 2*mean(xo*cos(2*pi*17950000000.0*tt))
  let m_low_b_one01_f0_s = 2*mean(xo*sin(2*pi*17950000000.0*tt))
  let m_low_b_one01_fl_lo_c = 2*mean(xo*cos(2*pi*17900000000.0*tt))
  let m_low_b_one01_fl_lo_s = 2*mean(xo*sin(2*pi*17900000000.0*tt))
  let m_low_b_one01_fl_hi_c = 2*mean(xo*cos(2*pi*18000000000.0*tt))
  let m_low_b_one01_fl_hi_s = 2*mean(xo*sin(2*pi*18000000000.0*tt))
  let m_low_b_one01_vce_q1_max = maximum(v(xdut.c1)[40000,59999] - v(xdut.e1)[40000,59999])
  let m_low_b_one01_vce_q1_min = minimum(v(xdut.c1)[40000,59999] - v(xdut.e1)[40000,59999])
  let m_low_b_one01_vce_q2_max = maximum(v(xdut.oc)[40000,59999] - v(xdut.c1)[40000,59999])
  let m_low_b_one01_vce_q2_min = minimum(v(xdut.oc)[40000,59999] - v(xdut.c1)[40000,59999])
  let m_low_b_one01_vbe_q1_max = maximum(v(xdut.b1)[40000,59999] - v(xdut.e1)[40000,59999])
  let m_low_b_one01_vbe_q1_min = minimum(v(xdut.b1)[40000,59999] - v(xdut.e1)[40000,59999])
  let m_low_b_one01_vbe_q2_max = maximum(v(xdut.b2)[40000,59999] - v(xdut.c1)[40000,59999])
  let m_low_b_one01_vbe_q2_min = minimum(v(xdut.b2)[40000,59999] - v(xdut.c1)[40000,59999])
  let w_low_b_one01_ic_q1 = @q.xdut.xq1.qnpn13g2[ic][40000,59999]
  let m_low_b_one01_ic_q1_max = maximum(w_low_b_one01_ic_q1)
  let m_low_b_one01_ic_q1_min = minimum(w_low_b_one01_ic_q1)
  let w_low_b_one01_ic_q2 = @q.xdut.xq2.qnpn13g2[ic][40000,59999]
  let m_low_b_one01_ic_q2_max = maximum(w_low_b_one01_ic_q2)
  let m_low_b_one01_ic_q2_min = minimum(w_low_b_one01_ic_q2)
  print m_low_b_one01_n m_low_b_one01_t0 m_low_b_one01_t1 m_low_b_one01_f0_c m_low_b_one01_f0_s m_low_b_one01_fl_lo_c
  print m_low_b_one01_fl_lo_s m_low_b_one01_fl_hi_c m_low_b_one01_fl_hi_s m_low_b_one01_vce_q1_max m_low_b_one01_vce_q1_min m_low_b_one01_vce_q2_max
  print m_low_b_one01_vce_q2_min m_low_b_one01_vbe_q1_max m_low_b_one01_vbe_q1_min m_low_b_one01_vbe_q2_max m_low_b_one01_vbe_q2_min m_low_b_one01_ic_q1_max
  print m_low_b_one01_ic_q1_min m_low_b_one01_ic_q2_max m_low_b_one01_ic_q2_min
  * run low_b_one02: one-tone, available power -52 dBm per tone
  alterparam fq1 = 17950000000.0
  alterparam fq2 = 17950000000.0
  alterparam va1 = 0.00158865646944856
  alterparam va2 = 0.0
  reset
  save all @q.xdut.xq1.qnpn13g2[ic] @q.xdut.xq2.qnpn13g2[ic]
  tran 1e-12 6e-08 0 1e-12
  linearize v(p2) v(xdut.c1) v(xdut.e1) v(xdut.oc) v(xdut.b1) v(xdut.b2) @q.xdut.xq1.qnpn13g2[ic] @q.xdut.xq2.qnpn13g2[ic]
  let tt = time[40000,59999]
  let xo = v(p2)[40000,59999]
  let m_low_b_one02_n = length(xo)
  let m_low_b_one02_t0 = tt[0]
  let m_low_b_one02_t1 = tt[19999]
  let m_low_b_one02_f0_c = 2*mean(xo*cos(2*pi*17950000000.0*tt))
  let m_low_b_one02_f0_s = 2*mean(xo*sin(2*pi*17950000000.0*tt))
  let m_low_b_one02_fl_lo_c = 2*mean(xo*cos(2*pi*17900000000.0*tt))
  let m_low_b_one02_fl_lo_s = 2*mean(xo*sin(2*pi*17900000000.0*tt))
  let m_low_b_one02_fl_hi_c = 2*mean(xo*cos(2*pi*18000000000.0*tt))
  let m_low_b_one02_fl_hi_s = 2*mean(xo*sin(2*pi*18000000000.0*tt))
  let m_low_b_one02_vce_q1_max = maximum(v(xdut.c1)[40000,59999] - v(xdut.e1)[40000,59999])
  let m_low_b_one02_vce_q1_min = minimum(v(xdut.c1)[40000,59999] - v(xdut.e1)[40000,59999])
  let m_low_b_one02_vce_q2_max = maximum(v(xdut.oc)[40000,59999] - v(xdut.c1)[40000,59999])
  let m_low_b_one02_vce_q2_min = minimum(v(xdut.oc)[40000,59999] - v(xdut.c1)[40000,59999])
  let m_low_b_one02_vbe_q1_max = maximum(v(xdut.b1)[40000,59999] - v(xdut.e1)[40000,59999])
  let m_low_b_one02_vbe_q1_min = minimum(v(xdut.b1)[40000,59999] - v(xdut.e1)[40000,59999])
  let m_low_b_one02_vbe_q2_max = maximum(v(xdut.b2)[40000,59999] - v(xdut.c1)[40000,59999])
  let m_low_b_one02_vbe_q2_min = minimum(v(xdut.b2)[40000,59999] - v(xdut.c1)[40000,59999])
  let w_low_b_one02_ic_q1 = @q.xdut.xq1.qnpn13g2[ic][40000,59999]
  let m_low_b_one02_ic_q1_max = maximum(w_low_b_one02_ic_q1)
  let m_low_b_one02_ic_q1_min = minimum(w_low_b_one02_ic_q1)
  let w_low_b_one02_ic_q2 = @q.xdut.xq2.qnpn13g2[ic][40000,59999]
  let m_low_b_one02_ic_q2_max = maximum(w_low_b_one02_ic_q2)
  let m_low_b_one02_ic_q2_min = minimum(w_low_b_one02_ic_q2)
  print m_low_b_one02_n m_low_b_one02_t0 m_low_b_one02_t1 m_low_b_one02_f0_c m_low_b_one02_f0_s m_low_b_one02_fl_lo_c
  print m_low_b_one02_fl_lo_s m_low_b_one02_fl_hi_c m_low_b_one02_fl_hi_s m_low_b_one02_vce_q1_max m_low_b_one02_vce_q1_min m_low_b_one02_vce_q2_max
  print m_low_b_one02_vce_q2_min m_low_b_one02_vbe_q1_max m_low_b_one02_vbe_q1_min m_low_b_one02_vbe_q2_max m_low_b_one02_vbe_q2_min m_low_b_one02_ic_q1_max
  print m_low_b_one02_ic_q1_min m_low_b_one02_ic_q2_max m_low_b_one02_ic_q2_min
  * run low_b_one03: one-tone, available power -50 dBm per tone
  alterparam fq1 = 17950000000.0
  alterparam fq2 = 17950000000.0
  alterparam va1 = 0.002
  alterparam va2 = 0.0
  reset
  save all @q.xdut.xq1.qnpn13g2[ic] @q.xdut.xq2.qnpn13g2[ic]
  tran 1e-12 6e-08 0 1e-12
  linearize v(p2) v(xdut.c1) v(xdut.e1) v(xdut.oc) v(xdut.b1) v(xdut.b2) @q.xdut.xq1.qnpn13g2[ic] @q.xdut.xq2.qnpn13g2[ic]
  let tt = time[40000,59999]
  let xo = v(p2)[40000,59999]
  let m_low_b_one03_n = length(xo)
  let m_low_b_one03_t0 = tt[0]
  let m_low_b_one03_t1 = tt[19999]
  let m_low_b_one03_f0_c = 2*mean(xo*cos(2*pi*17950000000.0*tt))
  let m_low_b_one03_f0_s = 2*mean(xo*sin(2*pi*17950000000.0*tt))
  let m_low_b_one03_fl_lo_c = 2*mean(xo*cos(2*pi*17900000000.0*tt))
  let m_low_b_one03_fl_lo_s = 2*mean(xo*sin(2*pi*17900000000.0*tt))
  let m_low_b_one03_fl_hi_c = 2*mean(xo*cos(2*pi*18000000000.0*tt))
  let m_low_b_one03_fl_hi_s = 2*mean(xo*sin(2*pi*18000000000.0*tt))
  let m_low_b_one03_vce_q1_max = maximum(v(xdut.c1)[40000,59999] - v(xdut.e1)[40000,59999])
  let m_low_b_one03_vce_q1_min = minimum(v(xdut.c1)[40000,59999] - v(xdut.e1)[40000,59999])
  let m_low_b_one03_vce_q2_max = maximum(v(xdut.oc)[40000,59999] - v(xdut.c1)[40000,59999])
  let m_low_b_one03_vce_q2_min = minimum(v(xdut.oc)[40000,59999] - v(xdut.c1)[40000,59999])
  let m_low_b_one03_vbe_q1_max = maximum(v(xdut.b1)[40000,59999] - v(xdut.e1)[40000,59999])
  let m_low_b_one03_vbe_q1_min = minimum(v(xdut.b1)[40000,59999] - v(xdut.e1)[40000,59999])
  let m_low_b_one03_vbe_q2_max = maximum(v(xdut.b2)[40000,59999] - v(xdut.c1)[40000,59999])
  let m_low_b_one03_vbe_q2_min = minimum(v(xdut.b2)[40000,59999] - v(xdut.c1)[40000,59999])
  let w_low_b_one03_ic_q1 = @q.xdut.xq1.qnpn13g2[ic][40000,59999]
  let m_low_b_one03_ic_q1_max = maximum(w_low_b_one03_ic_q1)
  let m_low_b_one03_ic_q1_min = minimum(w_low_b_one03_ic_q1)
  let w_low_b_one03_ic_q2 = @q.xdut.xq2.qnpn13g2[ic][40000,59999]
  let m_low_b_one03_ic_q2_max = maximum(w_low_b_one03_ic_q2)
  let m_low_b_one03_ic_q2_min = minimum(w_low_b_one03_ic_q2)
  print m_low_b_one03_n m_low_b_one03_t0 m_low_b_one03_t1 m_low_b_one03_f0_c m_low_b_one03_f0_s m_low_b_one03_fl_lo_c
  print m_low_b_one03_fl_lo_s m_low_b_one03_fl_hi_c m_low_b_one03_fl_hi_s m_low_b_one03_vce_q1_max m_low_b_one03_vce_q1_min m_low_b_one03_vce_q2_max
  print m_low_b_one03_vce_q2_min m_low_b_one03_vbe_q1_max m_low_b_one03_vbe_q1_min m_low_b_one03_vbe_q2_max m_low_b_one03_vbe_q2_min m_low_b_one03_ic_q1_max
  print m_low_b_one03_ic_q1_min m_low_b_one03_ic_q2_max m_low_b_one03_ic_q2_min
  * run low_b_one04: one-tone, available power -48 dBm per tone
  alterparam fq1 = 17950000000.0
  alterparam fq2 = 17950000000.0
  alterparam va1 = 0.00251785082358833
  alterparam va2 = 0.0
  reset
  save all @q.xdut.xq1.qnpn13g2[ic] @q.xdut.xq2.qnpn13g2[ic]
  tran 1e-12 6e-08 0 1e-12
  linearize v(p2) v(xdut.c1) v(xdut.e1) v(xdut.oc) v(xdut.b1) v(xdut.b2) @q.xdut.xq1.qnpn13g2[ic] @q.xdut.xq2.qnpn13g2[ic]
  let tt = time[40000,59999]
  let xo = v(p2)[40000,59999]
  let m_low_b_one04_n = length(xo)
  let m_low_b_one04_t0 = tt[0]
  let m_low_b_one04_t1 = tt[19999]
  let m_low_b_one04_f0_c = 2*mean(xo*cos(2*pi*17950000000.0*tt))
  let m_low_b_one04_f0_s = 2*mean(xo*sin(2*pi*17950000000.0*tt))
  let m_low_b_one04_fl_lo_c = 2*mean(xo*cos(2*pi*17900000000.0*tt))
  let m_low_b_one04_fl_lo_s = 2*mean(xo*sin(2*pi*17900000000.0*tt))
  let m_low_b_one04_fl_hi_c = 2*mean(xo*cos(2*pi*18000000000.0*tt))
  let m_low_b_one04_fl_hi_s = 2*mean(xo*sin(2*pi*18000000000.0*tt))
  let m_low_b_one04_vce_q1_max = maximum(v(xdut.c1)[40000,59999] - v(xdut.e1)[40000,59999])
  let m_low_b_one04_vce_q1_min = minimum(v(xdut.c1)[40000,59999] - v(xdut.e1)[40000,59999])
  let m_low_b_one04_vce_q2_max = maximum(v(xdut.oc)[40000,59999] - v(xdut.c1)[40000,59999])
  let m_low_b_one04_vce_q2_min = minimum(v(xdut.oc)[40000,59999] - v(xdut.c1)[40000,59999])
  let m_low_b_one04_vbe_q1_max = maximum(v(xdut.b1)[40000,59999] - v(xdut.e1)[40000,59999])
  let m_low_b_one04_vbe_q1_min = minimum(v(xdut.b1)[40000,59999] - v(xdut.e1)[40000,59999])
  let m_low_b_one04_vbe_q2_max = maximum(v(xdut.b2)[40000,59999] - v(xdut.c1)[40000,59999])
  let m_low_b_one04_vbe_q2_min = minimum(v(xdut.b2)[40000,59999] - v(xdut.c1)[40000,59999])
  let w_low_b_one04_ic_q1 = @q.xdut.xq1.qnpn13g2[ic][40000,59999]
  let m_low_b_one04_ic_q1_max = maximum(w_low_b_one04_ic_q1)
  let m_low_b_one04_ic_q1_min = minimum(w_low_b_one04_ic_q1)
  let w_low_b_one04_ic_q2 = @q.xdut.xq2.qnpn13g2[ic][40000,59999]
  let m_low_b_one04_ic_q2_max = maximum(w_low_b_one04_ic_q2)
  let m_low_b_one04_ic_q2_min = minimum(w_low_b_one04_ic_q2)
  print m_low_b_one04_n m_low_b_one04_t0 m_low_b_one04_t1 m_low_b_one04_f0_c m_low_b_one04_f0_s m_low_b_one04_fl_lo_c
  print m_low_b_one04_fl_lo_s m_low_b_one04_fl_hi_c m_low_b_one04_fl_hi_s m_low_b_one04_vce_q1_max m_low_b_one04_vce_q1_min m_low_b_one04_vce_q2_max
  print m_low_b_one04_vce_q2_min m_low_b_one04_vbe_q1_max m_low_b_one04_vbe_q1_min m_low_b_one04_vbe_q2_max m_low_b_one04_vbe_q2_min m_low_b_one04_ic_q1_max
  print m_low_b_one04_ic_q1_min m_low_b_one04_ic_q2_max m_low_b_one04_ic_q2_min
  * run low_b_one05: one-tone, available power -46 dBm per tone
  alterparam fq1 = 17950000000.0
  alterparam fq2 = 17950000000.0
  alterparam va1 = 0.00316978638492223
  alterparam va2 = 0.0
  reset
  save all @q.xdut.xq1.qnpn13g2[ic] @q.xdut.xq2.qnpn13g2[ic]
  tran 1e-12 6e-08 0 1e-12
  linearize v(p2) v(xdut.c1) v(xdut.e1) v(xdut.oc) v(xdut.b1) v(xdut.b2) @q.xdut.xq1.qnpn13g2[ic] @q.xdut.xq2.qnpn13g2[ic]
  let tt = time[40000,59999]
  let xo = v(p2)[40000,59999]
  let m_low_b_one05_n = length(xo)
  let m_low_b_one05_t0 = tt[0]
  let m_low_b_one05_t1 = tt[19999]
  let m_low_b_one05_f0_c = 2*mean(xo*cos(2*pi*17950000000.0*tt))
  let m_low_b_one05_f0_s = 2*mean(xo*sin(2*pi*17950000000.0*tt))
  let m_low_b_one05_fl_lo_c = 2*mean(xo*cos(2*pi*17900000000.0*tt))
  let m_low_b_one05_fl_lo_s = 2*mean(xo*sin(2*pi*17900000000.0*tt))
  let m_low_b_one05_fl_hi_c = 2*mean(xo*cos(2*pi*18000000000.0*tt))
  let m_low_b_one05_fl_hi_s = 2*mean(xo*sin(2*pi*18000000000.0*tt))
  let m_low_b_one05_vce_q1_max = maximum(v(xdut.c1)[40000,59999] - v(xdut.e1)[40000,59999])
  let m_low_b_one05_vce_q1_min = minimum(v(xdut.c1)[40000,59999] - v(xdut.e1)[40000,59999])
  let m_low_b_one05_vce_q2_max = maximum(v(xdut.oc)[40000,59999] - v(xdut.c1)[40000,59999])
  let m_low_b_one05_vce_q2_min = minimum(v(xdut.oc)[40000,59999] - v(xdut.c1)[40000,59999])
  let m_low_b_one05_vbe_q1_max = maximum(v(xdut.b1)[40000,59999] - v(xdut.e1)[40000,59999])
  let m_low_b_one05_vbe_q1_min = minimum(v(xdut.b1)[40000,59999] - v(xdut.e1)[40000,59999])
  let m_low_b_one05_vbe_q2_max = maximum(v(xdut.b2)[40000,59999] - v(xdut.c1)[40000,59999])
  let m_low_b_one05_vbe_q2_min = minimum(v(xdut.b2)[40000,59999] - v(xdut.c1)[40000,59999])
  let w_low_b_one05_ic_q1 = @q.xdut.xq1.qnpn13g2[ic][40000,59999]
  let m_low_b_one05_ic_q1_max = maximum(w_low_b_one05_ic_q1)
  let m_low_b_one05_ic_q1_min = minimum(w_low_b_one05_ic_q1)
  let w_low_b_one05_ic_q2 = @q.xdut.xq2.qnpn13g2[ic][40000,59999]
  let m_low_b_one05_ic_q2_max = maximum(w_low_b_one05_ic_q2)
  let m_low_b_one05_ic_q2_min = minimum(w_low_b_one05_ic_q2)
  print m_low_b_one05_n m_low_b_one05_t0 m_low_b_one05_t1 m_low_b_one05_f0_c m_low_b_one05_f0_s m_low_b_one05_fl_lo_c
  print m_low_b_one05_fl_lo_s m_low_b_one05_fl_hi_c m_low_b_one05_fl_hi_s m_low_b_one05_vce_q1_max m_low_b_one05_vce_q1_min m_low_b_one05_vce_q2_max
  print m_low_b_one05_vce_q2_min m_low_b_one05_vbe_q1_max m_low_b_one05_vbe_q1_min m_low_b_one05_vbe_q2_max m_low_b_one05_vbe_q2_min m_low_b_one05_ic_q1_max
  print m_low_b_one05_ic_q1_min m_low_b_one05_ic_q2_max m_low_b_one05_ic_q2_min
  * run low_b_one06: one-tone, available power -44 dBm per tone
  alterparam fq1 = 17950000000.0
  alterparam fq2 = 17950000000.0
  alterparam va1 = 0.00399052462993776
  alterparam va2 = 0.0
  reset
  save all @q.xdut.xq1.qnpn13g2[ic] @q.xdut.xq2.qnpn13g2[ic]
  tran 1e-12 6e-08 0 1e-12
  linearize v(p2) v(xdut.c1) v(xdut.e1) v(xdut.oc) v(xdut.b1) v(xdut.b2) @q.xdut.xq1.qnpn13g2[ic] @q.xdut.xq2.qnpn13g2[ic]
  let tt = time[40000,59999]
  let xo = v(p2)[40000,59999]
  let m_low_b_one06_n = length(xo)
  let m_low_b_one06_t0 = tt[0]
  let m_low_b_one06_t1 = tt[19999]
  let m_low_b_one06_f0_c = 2*mean(xo*cos(2*pi*17950000000.0*tt))
  let m_low_b_one06_f0_s = 2*mean(xo*sin(2*pi*17950000000.0*tt))
  let m_low_b_one06_fl_lo_c = 2*mean(xo*cos(2*pi*17900000000.0*tt))
  let m_low_b_one06_fl_lo_s = 2*mean(xo*sin(2*pi*17900000000.0*tt))
  let m_low_b_one06_fl_hi_c = 2*mean(xo*cos(2*pi*18000000000.0*tt))
  let m_low_b_one06_fl_hi_s = 2*mean(xo*sin(2*pi*18000000000.0*tt))
  let m_low_b_one06_vce_q1_max = maximum(v(xdut.c1)[40000,59999] - v(xdut.e1)[40000,59999])
  let m_low_b_one06_vce_q1_min = minimum(v(xdut.c1)[40000,59999] - v(xdut.e1)[40000,59999])
  let m_low_b_one06_vce_q2_max = maximum(v(xdut.oc)[40000,59999] - v(xdut.c1)[40000,59999])
  let m_low_b_one06_vce_q2_min = minimum(v(xdut.oc)[40000,59999] - v(xdut.c1)[40000,59999])
  let m_low_b_one06_vbe_q1_max = maximum(v(xdut.b1)[40000,59999] - v(xdut.e1)[40000,59999])
  let m_low_b_one06_vbe_q1_min = minimum(v(xdut.b1)[40000,59999] - v(xdut.e1)[40000,59999])
  let m_low_b_one06_vbe_q2_max = maximum(v(xdut.b2)[40000,59999] - v(xdut.c1)[40000,59999])
  let m_low_b_one06_vbe_q2_min = minimum(v(xdut.b2)[40000,59999] - v(xdut.c1)[40000,59999])
  let w_low_b_one06_ic_q1 = @q.xdut.xq1.qnpn13g2[ic][40000,59999]
  let m_low_b_one06_ic_q1_max = maximum(w_low_b_one06_ic_q1)
  let m_low_b_one06_ic_q1_min = minimum(w_low_b_one06_ic_q1)
  let w_low_b_one06_ic_q2 = @q.xdut.xq2.qnpn13g2[ic][40000,59999]
  let m_low_b_one06_ic_q2_max = maximum(w_low_b_one06_ic_q2)
  let m_low_b_one06_ic_q2_min = minimum(w_low_b_one06_ic_q2)
  print m_low_b_one06_n m_low_b_one06_t0 m_low_b_one06_t1 m_low_b_one06_f0_c m_low_b_one06_f0_s m_low_b_one06_fl_lo_c
  print m_low_b_one06_fl_lo_s m_low_b_one06_fl_hi_c m_low_b_one06_fl_hi_s m_low_b_one06_vce_q1_max m_low_b_one06_vce_q1_min m_low_b_one06_vce_q2_max
  print m_low_b_one06_vce_q2_min m_low_b_one06_vbe_q1_max m_low_b_one06_vbe_q1_min m_low_b_one06_vbe_q2_max m_low_b_one06_vbe_q2_min m_low_b_one06_ic_q1_max
  print m_low_b_one06_ic_q1_min m_low_b_one06_ic_q2_max m_low_b_one06_ic_q2_min
  * run low_b_one07: one-tone, available power -42 dBm per tone
  alterparam fq1 = 17950000000.0
  alterparam fq2 = 17950000000.0
  alterparam va1 = 0.00502377286301916
  alterparam va2 = 0.0
  reset
  save all @q.xdut.xq1.qnpn13g2[ic] @q.xdut.xq2.qnpn13g2[ic]
  tran 1e-12 6e-08 0 1e-12
  linearize v(p2) v(xdut.c1) v(xdut.e1) v(xdut.oc) v(xdut.b1) v(xdut.b2) @q.xdut.xq1.qnpn13g2[ic] @q.xdut.xq2.qnpn13g2[ic]
  let tt = time[40000,59999]
  let xo = v(p2)[40000,59999]
  let m_low_b_one07_n = length(xo)
  let m_low_b_one07_t0 = tt[0]
  let m_low_b_one07_t1 = tt[19999]
  let m_low_b_one07_f0_c = 2*mean(xo*cos(2*pi*17950000000.0*tt))
  let m_low_b_one07_f0_s = 2*mean(xo*sin(2*pi*17950000000.0*tt))
  let m_low_b_one07_fl_lo_c = 2*mean(xo*cos(2*pi*17900000000.0*tt))
  let m_low_b_one07_fl_lo_s = 2*mean(xo*sin(2*pi*17900000000.0*tt))
  let m_low_b_one07_fl_hi_c = 2*mean(xo*cos(2*pi*18000000000.0*tt))
  let m_low_b_one07_fl_hi_s = 2*mean(xo*sin(2*pi*18000000000.0*tt))
  let m_low_b_one07_vce_q1_max = maximum(v(xdut.c1)[40000,59999] - v(xdut.e1)[40000,59999])
  let m_low_b_one07_vce_q1_min = minimum(v(xdut.c1)[40000,59999] - v(xdut.e1)[40000,59999])
  let m_low_b_one07_vce_q2_max = maximum(v(xdut.oc)[40000,59999] - v(xdut.c1)[40000,59999])
  let m_low_b_one07_vce_q2_min = minimum(v(xdut.oc)[40000,59999] - v(xdut.c1)[40000,59999])
  let m_low_b_one07_vbe_q1_max = maximum(v(xdut.b1)[40000,59999] - v(xdut.e1)[40000,59999])
  let m_low_b_one07_vbe_q1_min = minimum(v(xdut.b1)[40000,59999] - v(xdut.e1)[40000,59999])
  let m_low_b_one07_vbe_q2_max = maximum(v(xdut.b2)[40000,59999] - v(xdut.c1)[40000,59999])
  let m_low_b_one07_vbe_q2_min = minimum(v(xdut.b2)[40000,59999] - v(xdut.c1)[40000,59999])
  let w_low_b_one07_ic_q1 = @q.xdut.xq1.qnpn13g2[ic][40000,59999]
  let m_low_b_one07_ic_q1_max = maximum(w_low_b_one07_ic_q1)
  let m_low_b_one07_ic_q1_min = minimum(w_low_b_one07_ic_q1)
  let w_low_b_one07_ic_q2 = @q.xdut.xq2.qnpn13g2[ic][40000,59999]
  let m_low_b_one07_ic_q2_max = maximum(w_low_b_one07_ic_q2)
  let m_low_b_one07_ic_q2_min = minimum(w_low_b_one07_ic_q2)
  print m_low_b_one07_n m_low_b_one07_t0 m_low_b_one07_t1 m_low_b_one07_f0_c m_low_b_one07_f0_s m_low_b_one07_fl_lo_c
  print m_low_b_one07_fl_lo_s m_low_b_one07_fl_hi_c m_low_b_one07_fl_hi_s m_low_b_one07_vce_q1_max m_low_b_one07_vce_q1_min m_low_b_one07_vce_q2_max
  print m_low_b_one07_vce_q2_min m_low_b_one07_vbe_q1_max m_low_b_one07_vbe_q1_min m_low_b_one07_vbe_q2_max m_low_b_one07_vbe_q2_min m_low_b_one07_ic_q1_max
  print m_low_b_one07_ic_q1_min m_low_b_one07_ic_q2_max m_low_b_one07_ic_q2_min
  * run low_b_one08: one-tone, available power -40 dBm per tone
  alterparam fq1 = 17950000000.0
  alterparam fq2 = 17950000000.0
  alterparam va1 = 0.00632455532033676
  alterparam va2 = 0.0
  reset
  save all @q.xdut.xq1.qnpn13g2[ic] @q.xdut.xq2.qnpn13g2[ic]
  tran 1e-12 6e-08 0 1e-12
  linearize v(p2) v(xdut.c1) v(xdut.e1) v(xdut.oc) v(xdut.b1) v(xdut.b2) @q.xdut.xq1.qnpn13g2[ic] @q.xdut.xq2.qnpn13g2[ic]
  let tt = time[40000,59999]
  let xo = v(p2)[40000,59999]
  let m_low_b_one08_n = length(xo)
  let m_low_b_one08_t0 = tt[0]
  let m_low_b_one08_t1 = tt[19999]
  let m_low_b_one08_f0_c = 2*mean(xo*cos(2*pi*17950000000.0*tt))
  let m_low_b_one08_f0_s = 2*mean(xo*sin(2*pi*17950000000.0*tt))
  let m_low_b_one08_fl_lo_c = 2*mean(xo*cos(2*pi*17900000000.0*tt))
  let m_low_b_one08_fl_lo_s = 2*mean(xo*sin(2*pi*17900000000.0*tt))
  let m_low_b_one08_fl_hi_c = 2*mean(xo*cos(2*pi*18000000000.0*tt))
  let m_low_b_one08_fl_hi_s = 2*mean(xo*sin(2*pi*18000000000.0*tt))
  let m_low_b_one08_vce_q1_max = maximum(v(xdut.c1)[40000,59999] - v(xdut.e1)[40000,59999])
  let m_low_b_one08_vce_q1_min = minimum(v(xdut.c1)[40000,59999] - v(xdut.e1)[40000,59999])
  let m_low_b_one08_vce_q2_max = maximum(v(xdut.oc)[40000,59999] - v(xdut.c1)[40000,59999])
  let m_low_b_one08_vce_q2_min = minimum(v(xdut.oc)[40000,59999] - v(xdut.c1)[40000,59999])
  let m_low_b_one08_vbe_q1_max = maximum(v(xdut.b1)[40000,59999] - v(xdut.e1)[40000,59999])
  let m_low_b_one08_vbe_q1_min = minimum(v(xdut.b1)[40000,59999] - v(xdut.e1)[40000,59999])
  let m_low_b_one08_vbe_q2_max = maximum(v(xdut.b2)[40000,59999] - v(xdut.c1)[40000,59999])
  let m_low_b_one08_vbe_q2_min = minimum(v(xdut.b2)[40000,59999] - v(xdut.c1)[40000,59999])
  let w_low_b_one08_ic_q1 = @q.xdut.xq1.qnpn13g2[ic][40000,59999]
  let m_low_b_one08_ic_q1_max = maximum(w_low_b_one08_ic_q1)
  let m_low_b_one08_ic_q1_min = minimum(w_low_b_one08_ic_q1)
  let w_low_b_one08_ic_q2 = @q.xdut.xq2.qnpn13g2[ic][40000,59999]
  let m_low_b_one08_ic_q2_max = maximum(w_low_b_one08_ic_q2)
  let m_low_b_one08_ic_q2_min = minimum(w_low_b_one08_ic_q2)
  print m_low_b_one08_n m_low_b_one08_t0 m_low_b_one08_t1 m_low_b_one08_f0_c m_low_b_one08_f0_s m_low_b_one08_fl_lo_c
  print m_low_b_one08_fl_lo_s m_low_b_one08_fl_hi_c m_low_b_one08_fl_hi_s m_low_b_one08_vce_q1_max m_low_b_one08_vce_q1_min m_low_b_one08_vce_q2_max
  print m_low_b_one08_vce_q2_min m_low_b_one08_vbe_q1_max m_low_b_one08_vbe_q1_min m_low_b_one08_vbe_q2_max m_low_b_one08_vbe_q2_min m_low_b_one08_ic_q1_max
  print m_low_b_one08_ic_q1_min m_low_b_one08_ic_q2_max m_low_b_one08_ic_q2_min
  * run low_b_one09: one-tone, available power -38 dBm per tone
  alterparam fq1 = 17950000000.0
  alterparam fq2 = 17950000000.0
  alterparam va1 = 0.00796214341106995
  alterparam va2 = 0.0
  reset
  save all @q.xdut.xq1.qnpn13g2[ic] @q.xdut.xq2.qnpn13g2[ic]
  tran 1e-12 6e-08 0 1e-12
  linearize v(p2) v(xdut.c1) v(xdut.e1) v(xdut.oc) v(xdut.b1) v(xdut.b2) @q.xdut.xq1.qnpn13g2[ic] @q.xdut.xq2.qnpn13g2[ic]
  let tt = time[40000,59999]
  let xo = v(p2)[40000,59999]
  let m_low_b_one09_n = length(xo)
  let m_low_b_one09_t0 = tt[0]
  let m_low_b_one09_t1 = tt[19999]
  let m_low_b_one09_f0_c = 2*mean(xo*cos(2*pi*17950000000.0*tt))
  let m_low_b_one09_f0_s = 2*mean(xo*sin(2*pi*17950000000.0*tt))
  let m_low_b_one09_fl_lo_c = 2*mean(xo*cos(2*pi*17900000000.0*tt))
  let m_low_b_one09_fl_lo_s = 2*mean(xo*sin(2*pi*17900000000.0*tt))
  let m_low_b_one09_fl_hi_c = 2*mean(xo*cos(2*pi*18000000000.0*tt))
  let m_low_b_one09_fl_hi_s = 2*mean(xo*sin(2*pi*18000000000.0*tt))
  let m_low_b_one09_vce_q1_max = maximum(v(xdut.c1)[40000,59999] - v(xdut.e1)[40000,59999])
  let m_low_b_one09_vce_q1_min = minimum(v(xdut.c1)[40000,59999] - v(xdut.e1)[40000,59999])
  let m_low_b_one09_vce_q2_max = maximum(v(xdut.oc)[40000,59999] - v(xdut.c1)[40000,59999])
  let m_low_b_one09_vce_q2_min = minimum(v(xdut.oc)[40000,59999] - v(xdut.c1)[40000,59999])
  let m_low_b_one09_vbe_q1_max = maximum(v(xdut.b1)[40000,59999] - v(xdut.e1)[40000,59999])
  let m_low_b_one09_vbe_q1_min = minimum(v(xdut.b1)[40000,59999] - v(xdut.e1)[40000,59999])
  let m_low_b_one09_vbe_q2_max = maximum(v(xdut.b2)[40000,59999] - v(xdut.c1)[40000,59999])
  let m_low_b_one09_vbe_q2_min = minimum(v(xdut.b2)[40000,59999] - v(xdut.c1)[40000,59999])
  let w_low_b_one09_ic_q1 = @q.xdut.xq1.qnpn13g2[ic][40000,59999]
  let m_low_b_one09_ic_q1_max = maximum(w_low_b_one09_ic_q1)
  let m_low_b_one09_ic_q1_min = minimum(w_low_b_one09_ic_q1)
  let w_low_b_one09_ic_q2 = @q.xdut.xq2.qnpn13g2[ic][40000,59999]
  let m_low_b_one09_ic_q2_max = maximum(w_low_b_one09_ic_q2)
  let m_low_b_one09_ic_q2_min = minimum(w_low_b_one09_ic_q2)
  print m_low_b_one09_n m_low_b_one09_t0 m_low_b_one09_t1 m_low_b_one09_f0_c m_low_b_one09_f0_s m_low_b_one09_fl_lo_c
  print m_low_b_one09_fl_lo_s m_low_b_one09_fl_hi_c m_low_b_one09_fl_hi_s m_low_b_one09_vce_q1_max m_low_b_one09_vce_q1_min m_low_b_one09_vce_q2_max
  print m_low_b_one09_vce_q2_min m_low_b_one09_vbe_q1_max m_low_b_one09_vbe_q1_min m_low_b_one09_vbe_q2_max m_low_b_one09_vbe_q2_min m_low_b_one09_ic_q1_max
  print m_low_b_one09_ic_q1_min m_low_b_one09_ic_q2_max m_low_b_one09_ic_q2_min
  * run low_b_one10: one-tone, available power -36 dBm per tone
  alterparam fq1 = 17950000000.0
  alterparam fq2 = 17950000000.0
  alterparam va1 = 0.0100237446725454
  alterparam va2 = 0.0
  reset
  save all @q.xdut.xq1.qnpn13g2[ic] @q.xdut.xq2.qnpn13g2[ic]
  tran 1e-12 6e-08 0 1e-12
  linearize v(p2) v(xdut.c1) v(xdut.e1) v(xdut.oc) v(xdut.b1) v(xdut.b2) @q.xdut.xq1.qnpn13g2[ic] @q.xdut.xq2.qnpn13g2[ic]
  let tt = time[40000,59999]
  let xo = v(p2)[40000,59999]
  let m_low_b_one10_n = length(xo)
  let m_low_b_one10_t0 = tt[0]
  let m_low_b_one10_t1 = tt[19999]
  let m_low_b_one10_f0_c = 2*mean(xo*cos(2*pi*17950000000.0*tt))
  let m_low_b_one10_f0_s = 2*mean(xo*sin(2*pi*17950000000.0*tt))
  let m_low_b_one10_fl_lo_c = 2*mean(xo*cos(2*pi*17900000000.0*tt))
  let m_low_b_one10_fl_lo_s = 2*mean(xo*sin(2*pi*17900000000.0*tt))
  let m_low_b_one10_fl_hi_c = 2*mean(xo*cos(2*pi*18000000000.0*tt))
  let m_low_b_one10_fl_hi_s = 2*mean(xo*sin(2*pi*18000000000.0*tt))
  let m_low_b_one10_vce_q1_max = maximum(v(xdut.c1)[40000,59999] - v(xdut.e1)[40000,59999])
  let m_low_b_one10_vce_q1_min = minimum(v(xdut.c1)[40000,59999] - v(xdut.e1)[40000,59999])
  let m_low_b_one10_vce_q2_max = maximum(v(xdut.oc)[40000,59999] - v(xdut.c1)[40000,59999])
  let m_low_b_one10_vce_q2_min = minimum(v(xdut.oc)[40000,59999] - v(xdut.c1)[40000,59999])
  let m_low_b_one10_vbe_q1_max = maximum(v(xdut.b1)[40000,59999] - v(xdut.e1)[40000,59999])
  let m_low_b_one10_vbe_q1_min = minimum(v(xdut.b1)[40000,59999] - v(xdut.e1)[40000,59999])
  let m_low_b_one10_vbe_q2_max = maximum(v(xdut.b2)[40000,59999] - v(xdut.c1)[40000,59999])
  let m_low_b_one10_vbe_q2_min = minimum(v(xdut.b2)[40000,59999] - v(xdut.c1)[40000,59999])
  let w_low_b_one10_ic_q1 = @q.xdut.xq1.qnpn13g2[ic][40000,59999]
  let m_low_b_one10_ic_q1_max = maximum(w_low_b_one10_ic_q1)
  let m_low_b_one10_ic_q1_min = minimum(w_low_b_one10_ic_q1)
  let w_low_b_one10_ic_q2 = @q.xdut.xq2.qnpn13g2[ic][40000,59999]
  let m_low_b_one10_ic_q2_max = maximum(w_low_b_one10_ic_q2)
  let m_low_b_one10_ic_q2_min = minimum(w_low_b_one10_ic_q2)
  print m_low_b_one10_n m_low_b_one10_t0 m_low_b_one10_t1 m_low_b_one10_f0_c m_low_b_one10_f0_s m_low_b_one10_fl_lo_c
  print m_low_b_one10_fl_lo_s m_low_b_one10_fl_hi_c m_low_b_one10_fl_hi_s m_low_b_one10_vce_q1_max m_low_b_one10_vce_q1_min m_low_b_one10_vce_q2_max
  print m_low_b_one10_vce_q2_min m_low_b_one10_vbe_q1_max m_low_b_one10_vbe_q1_min m_low_b_one10_vbe_q2_max m_low_b_one10_vbe_q2_min m_low_b_one10_ic_q1_max
  print m_low_b_one10_ic_q1_min m_low_b_one10_ic_q2_max m_low_b_one10_ic_q2_min
  * run low_b_one11: one-tone, available power -34 dBm per tone
  alterparam fq1 = 17950000000.0
  alterparam fq2 = 17950000000.0
  alterparam va1 = 0.0126191468896039
  alterparam va2 = 0.0
  reset
  save all @q.xdut.xq1.qnpn13g2[ic] @q.xdut.xq2.qnpn13g2[ic]
  tran 1e-12 6e-08 0 1e-12
  linearize v(p2) v(xdut.c1) v(xdut.e1) v(xdut.oc) v(xdut.b1) v(xdut.b2) @q.xdut.xq1.qnpn13g2[ic] @q.xdut.xq2.qnpn13g2[ic]
  let tt = time[40000,59999]
  let xo = v(p2)[40000,59999]
  let m_low_b_one11_n = length(xo)
  let m_low_b_one11_t0 = tt[0]
  let m_low_b_one11_t1 = tt[19999]
  let m_low_b_one11_f0_c = 2*mean(xo*cos(2*pi*17950000000.0*tt))
  let m_low_b_one11_f0_s = 2*mean(xo*sin(2*pi*17950000000.0*tt))
  let m_low_b_one11_fl_lo_c = 2*mean(xo*cos(2*pi*17900000000.0*tt))
  let m_low_b_one11_fl_lo_s = 2*mean(xo*sin(2*pi*17900000000.0*tt))
  let m_low_b_one11_fl_hi_c = 2*mean(xo*cos(2*pi*18000000000.0*tt))
  let m_low_b_one11_fl_hi_s = 2*mean(xo*sin(2*pi*18000000000.0*tt))
  let m_low_b_one11_vce_q1_max = maximum(v(xdut.c1)[40000,59999] - v(xdut.e1)[40000,59999])
  let m_low_b_one11_vce_q1_min = minimum(v(xdut.c1)[40000,59999] - v(xdut.e1)[40000,59999])
  let m_low_b_one11_vce_q2_max = maximum(v(xdut.oc)[40000,59999] - v(xdut.c1)[40000,59999])
  let m_low_b_one11_vce_q2_min = minimum(v(xdut.oc)[40000,59999] - v(xdut.c1)[40000,59999])
  let m_low_b_one11_vbe_q1_max = maximum(v(xdut.b1)[40000,59999] - v(xdut.e1)[40000,59999])
  let m_low_b_one11_vbe_q1_min = minimum(v(xdut.b1)[40000,59999] - v(xdut.e1)[40000,59999])
  let m_low_b_one11_vbe_q2_max = maximum(v(xdut.b2)[40000,59999] - v(xdut.c1)[40000,59999])
  let m_low_b_one11_vbe_q2_min = minimum(v(xdut.b2)[40000,59999] - v(xdut.c1)[40000,59999])
  let w_low_b_one11_ic_q1 = @q.xdut.xq1.qnpn13g2[ic][40000,59999]
  let m_low_b_one11_ic_q1_max = maximum(w_low_b_one11_ic_q1)
  let m_low_b_one11_ic_q1_min = minimum(w_low_b_one11_ic_q1)
  let w_low_b_one11_ic_q2 = @q.xdut.xq2.qnpn13g2[ic][40000,59999]
  let m_low_b_one11_ic_q2_max = maximum(w_low_b_one11_ic_q2)
  let m_low_b_one11_ic_q2_min = minimum(w_low_b_one11_ic_q2)
  print m_low_b_one11_n m_low_b_one11_t0 m_low_b_one11_t1 m_low_b_one11_f0_c m_low_b_one11_f0_s m_low_b_one11_fl_lo_c
  print m_low_b_one11_fl_lo_s m_low_b_one11_fl_hi_c m_low_b_one11_fl_hi_s m_low_b_one11_vce_q1_max m_low_b_one11_vce_q1_min m_low_b_one11_vce_q2_max
  print m_low_b_one11_vce_q2_min m_low_b_one11_vbe_q1_max m_low_b_one11_vbe_q1_min m_low_b_one11_vbe_q2_max m_low_b_one11_vbe_q2_min m_low_b_one11_ic_q1_max
  print m_low_b_one11_ic_q1_min m_low_b_one11_ic_q2_max m_low_b_one11_ic_q2_min
  * run low_b_one12: one-tone, available power -32 dBm per tone
  alterparam fq1 = 17950000000.0
  alterparam fq2 = 17950000000.0
  alterparam va1 = 0.0158865646944856
  alterparam va2 = 0.0
  reset
  save all @q.xdut.xq1.qnpn13g2[ic] @q.xdut.xq2.qnpn13g2[ic]
  tran 1e-12 6e-08 0 1e-12
  linearize v(p2) v(xdut.c1) v(xdut.e1) v(xdut.oc) v(xdut.b1) v(xdut.b2) @q.xdut.xq1.qnpn13g2[ic] @q.xdut.xq2.qnpn13g2[ic]
  let tt = time[40000,59999]
  let xo = v(p2)[40000,59999]
  let m_low_b_one12_n = length(xo)
  let m_low_b_one12_t0 = tt[0]
  let m_low_b_one12_t1 = tt[19999]
  let m_low_b_one12_f0_c = 2*mean(xo*cos(2*pi*17950000000.0*tt))
  let m_low_b_one12_f0_s = 2*mean(xo*sin(2*pi*17950000000.0*tt))
  let m_low_b_one12_fl_lo_c = 2*mean(xo*cos(2*pi*17900000000.0*tt))
  let m_low_b_one12_fl_lo_s = 2*mean(xo*sin(2*pi*17900000000.0*tt))
  let m_low_b_one12_fl_hi_c = 2*mean(xo*cos(2*pi*18000000000.0*tt))
  let m_low_b_one12_fl_hi_s = 2*mean(xo*sin(2*pi*18000000000.0*tt))
  let m_low_b_one12_vce_q1_max = maximum(v(xdut.c1)[40000,59999] - v(xdut.e1)[40000,59999])
  let m_low_b_one12_vce_q1_min = minimum(v(xdut.c1)[40000,59999] - v(xdut.e1)[40000,59999])
  let m_low_b_one12_vce_q2_max = maximum(v(xdut.oc)[40000,59999] - v(xdut.c1)[40000,59999])
  let m_low_b_one12_vce_q2_min = minimum(v(xdut.oc)[40000,59999] - v(xdut.c1)[40000,59999])
  let m_low_b_one12_vbe_q1_max = maximum(v(xdut.b1)[40000,59999] - v(xdut.e1)[40000,59999])
  let m_low_b_one12_vbe_q1_min = minimum(v(xdut.b1)[40000,59999] - v(xdut.e1)[40000,59999])
  let m_low_b_one12_vbe_q2_max = maximum(v(xdut.b2)[40000,59999] - v(xdut.c1)[40000,59999])
  let m_low_b_one12_vbe_q2_min = minimum(v(xdut.b2)[40000,59999] - v(xdut.c1)[40000,59999])
  let w_low_b_one12_ic_q1 = @q.xdut.xq1.qnpn13g2[ic][40000,59999]
  let m_low_b_one12_ic_q1_max = maximum(w_low_b_one12_ic_q1)
  let m_low_b_one12_ic_q1_min = minimum(w_low_b_one12_ic_q1)
  let w_low_b_one12_ic_q2 = @q.xdut.xq2.qnpn13g2[ic][40000,59999]
  let m_low_b_one12_ic_q2_max = maximum(w_low_b_one12_ic_q2)
  let m_low_b_one12_ic_q2_min = minimum(w_low_b_one12_ic_q2)
  print m_low_b_one12_n m_low_b_one12_t0 m_low_b_one12_t1 m_low_b_one12_f0_c m_low_b_one12_f0_s m_low_b_one12_fl_lo_c
  print m_low_b_one12_fl_lo_s m_low_b_one12_fl_hi_c m_low_b_one12_fl_hi_s m_low_b_one12_vce_q1_max m_low_b_one12_vce_q1_min m_low_b_one12_vce_q2_max
  print m_low_b_one12_vce_q2_min m_low_b_one12_vbe_q1_max m_low_b_one12_vbe_q1_min m_low_b_one12_vbe_q2_max m_low_b_one12_vbe_q2_min m_low_b_one12_ic_q1_max
  print m_low_b_one12_ic_q1_min m_low_b_one12_ic_q2_max m_low_b_one12_ic_q2_min
  * run low_b_one13: one-tone, available power -30 dBm per tone
  alterparam fq1 = 17950000000.0
  alterparam fq2 = 17950000000.0
  alterparam va1 = 0.02
  alterparam va2 = 0.0
  reset
  save all @q.xdut.xq1.qnpn13g2[ic] @q.xdut.xq2.qnpn13g2[ic]
  tran 1e-12 6e-08 0 1e-12
  linearize v(p2) v(xdut.c1) v(xdut.e1) v(xdut.oc) v(xdut.b1) v(xdut.b2) @q.xdut.xq1.qnpn13g2[ic] @q.xdut.xq2.qnpn13g2[ic]
  let tt = time[40000,59999]
  let xo = v(p2)[40000,59999]
  let m_low_b_one13_n = length(xo)
  let m_low_b_one13_t0 = tt[0]
  let m_low_b_one13_t1 = tt[19999]
  let m_low_b_one13_f0_c = 2*mean(xo*cos(2*pi*17950000000.0*tt))
  let m_low_b_one13_f0_s = 2*mean(xo*sin(2*pi*17950000000.0*tt))
  let m_low_b_one13_fl_lo_c = 2*mean(xo*cos(2*pi*17900000000.0*tt))
  let m_low_b_one13_fl_lo_s = 2*mean(xo*sin(2*pi*17900000000.0*tt))
  let m_low_b_one13_fl_hi_c = 2*mean(xo*cos(2*pi*18000000000.0*tt))
  let m_low_b_one13_fl_hi_s = 2*mean(xo*sin(2*pi*18000000000.0*tt))
  let m_low_b_one13_vce_q1_max = maximum(v(xdut.c1)[40000,59999] - v(xdut.e1)[40000,59999])
  let m_low_b_one13_vce_q1_min = minimum(v(xdut.c1)[40000,59999] - v(xdut.e1)[40000,59999])
  let m_low_b_one13_vce_q2_max = maximum(v(xdut.oc)[40000,59999] - v(xdut.c1)[40000,59999])
  let m_low_b_one13_vce_q2_min = minimum(v(xdut.oc)[40000,59999] - v(xdut.c1)[40000,59999])
  let m_low_b_one13_vbe_q1_max = maximum(v(xdut.b1)[40000,59999] - v(xdut.e1)[40000,59999])
  let m_low_b_one13_vbe_q1_min = minimum(v(xdut.b1)[40000,59999] - v(xdut.e1)[40000,59999])
  let m_low_b_one13_vbe_q2_max = maximum(v(xdut.b2)[40000,59999] - v(xdut.c1)[40000,59999])
  let m_low_b_one13_vbe_q2_min = minimum(v(xdut.b2)[40000,59999] - v(xdut.c1)[40000,59999])
  let w_low_b_one13_ic_q1 = @q.xdut.xq1.qnpn13g2[ic][40000,59999]
  let m_low_b_one13_ic_q1_max = maximum(w_low_b_one13_ic_q1)
  let m_low_b_one13_ic_q1_min = minimum(w_low_b_one13_ic_q1)
  let w_low_b_one13_ic_q2 = @q.xdut.xq2.qnpn13g2[ic][40000,59999]
  let m_low_b_one13_ic_q2_max = maximum(w_low_b_one13_ic_q2)
  let m_low_b_one13_ic_q2_min = minimum(w_low_b_one13_ic_q2)
  print m_low_b_one13_n m_low_b_one13_t0 m_low_b_one13_t1 m_low_b_one13_f0_c m_low_b_one13_f0_s m_low_b_one13_fl_lo_c
  print m_low_b_one13_fl_lo_s m_low_b_one13_fl_hi_c m_low_b_one13_fl_hi_s m_low_b_one13_vce_q1_max m_low_b_one13_vce_q1_min m_low_b_one13_vce_q2_max
  print m_low_b_one13_vce_q2_min m_low_b_one13_vbe_q1_max m_low_b_one13_vbe_q1_min m_low_b_one13_vbe_q2_max m_low_b_one13_vbe_q2_min m_low_b_one13_ic_q1_max
  print m_low_b_one13_ic_q1_min m_low_b_one13_ic_q2_max m_low_b_one13_ic_q2_min
  * run low_b_one14: one-tone, available power -28 dBm per tone
  alterparam fq1 = 17950000000.0
  alterparam fq2 = 17950000000.0
  alterparam va1 = 0.0251785082358833
  alterparam va2 = 0.0
  reset
  save all @q.xdut.xq1.qnpn13g2[ic] @q.xdut.xq2.qnpn13g2[ic]
  tran 1e-12 6e-08 0 1e-12
  linearize v(p2) v(xdut.c1) v(xdut.e1) v(xdut.oc) v(xdut.b1) v(xdut.b2) @q.xdut.xq1.qnpn13g2[ic] @q.xdut.xq2.qnpn13g2[ic]
  let tt = time[40000,59999]
  let xo = v(p2)[40000,59999]
  let m_low_b_one14_n = length(xo)
  let m_low_b_one14_t0 = tt[0]
  let m_low_b_one14_t1 = tt[19999]
  let m_low_b_one14_f0_c = 2*mean(xo*cos(2*pi*17950000000.0*tt))
  let m_low_b_one14_f0_s = 2*mean(xo*sin(2*pi*17950000000.0*tt))
  let m_low_b_one14_fl_lo_c = 2*mean(xo*cos(2*pi*17900000000.0*tt))
  let m_low_b_one14_fl_lo_s = 2*mean(xo*sin(2*pi*17900000000.0*tt))
  let m_low_b_one14_fl_hi_c = 2*mean(xo*cos(2*pi*18000000000.0*tt))
  let m_low_b_one14_fl_hi_s = 2*mean(xo*sin(2*pi*18000000000.0*tt))
  let m_low_b_one14_vce_q1_max = maximum(v(xdut.c1)[40000,59999] - v(xdut.e1)[40000,59999])
  let m_low_b_one14_vce_q1_min = minimum(v(xdut.c1)[40000,59999] - v(xdut.e1)[40000,59999])
  let m_low_b_one14_vce_q2_max = maximum(v(xdut.oc)[40000,59999] - v(xdut.c1)[40000,59999])
  let m_low_b_one14_vce_q2_min = minimum(v(xdut.oc)[40000,59999] - v(xdut.c1)[40000,59999])
  let m_low_b_one14_vbe_q1_max = maximum(v(xdut.b1)[40000,59999] - v(xdut.e1)[40000,59999])
  let m_low_b_one14_vbe_q1_min = minimum(v(xdut.b1)[40000,59999] - v(xdut.e1)[40000,59999])
  let m_low_b_one14_vbe_q2_max = maximum(v(xdut.b2)[40000,59999] - v(xdut.c1)[40000,59999])
  let m_low_b_one14_vbe_q2_min = minimum(v(xdut.b2)[40000,59999] - v(xdut.c1)[40000,59999])
  let w_low_b_one14_ic_q1 = @q.xdut.xq1.qnpn13g2[ic][40000,59999]
  let m_low_b_one14_ic_q1_max = maximum(w_low_b_one14_ic_q1)
  let m_low_b_one14_ic_q1_min = minimum(w_low_b_one14_ic_q1)
  let w_low_b_one14_ic_q2 = @q.xdut.xq2.qnpn13g2[ic][40000,59999]
  let m_low_b_one14_ic_q2_max = maximum(w_low_b_one14_ic_q2)
  let m_low_b_one14_ic_q2_min = minimum(w_low_b_one14_ic_q2)
  print m_low_b_one14_n m_low_b_one14_t0 m_low_b_one14_t1 m_low_b_one14_f0_c m_low_b_one14_f0_s m_low_b_one14_fl_lo_c
  print m_low_b_one14_fl_lo_s m_low_b_one14_fl_hi_c m_low_b_one14_fl_hi_s m_low_b_one14_vce_q1_max m_low_b_one14_vce_q1_min m_low_b_one14_vce_q2_max
  print m_low_b_one14_vce_q2_min m_low_b_one14_vbe_q1_max m_low_b_one14_vbe_q1_min m_low_b_one14_vbe_q2_max m_low_b_one14_vbe_q2_min m_low_b_one14_ic_q1_max
  print m_low_b_one14_ic_q1_min m_low_b_one14_ic_q2_max m_low_b_one14_ic_q2_min
  * run low_b_one15: one-tone, available power -26 dBm per tone
  alterparam fq1 = 17950000000.0
  alterparam fq2 = 17950000000.0
  alterparam va1 = 0.0316978638492223
  alterparam va2 = 0.0
  reset
  save all @q.xdut.xq1.qnpn13g2[ic] @q.xdut.xq2.qnpn13g2[ic]
  tran 1e-12 6e-08 0 1e-12
  linearize v(p2) v(xdut.c1) v(xdut.e1) v(xdut.oc) v(xdut.b1) v(xdut.b2) @q.xdut.xq1.qnpn13g2[ic] @q.xdut.xq2.qnpn13g2[ic]
  let tt = time[40000,59999]
  let xo = v(p2)[40000,59999]
  let m_low_b_one15_n = length(xo)
  let m_low_b_one15_t0 = tt[0]
  let m_low_b_one15_t1 = tt[19999]
  let m_low_b_one15_f0_c = 2*mean(xo*cos(2*pi*17950000000.0*tt))
  let m_low_b_one15_f0_s = 2*mean(xo*sin(2*pi*17950000000.0*tt))
  let m_low_b_one15_fl_lo_c = 2*mean(xo*cos(2*pi*17900000000.0*tt))
  let m_low_b_one15_fl_lo_s = 2*mean(xo*sin(2*pi*17900000000.0*tt))
  let m_low_b_one15_fl_hi_c = 2*mean(xo*cos(2*pi*18000000000.0*tt))
  let m_low_b_one15_fl_hi_s = 2*mean(xo*sin(2*pi*18000000000.0*tt))
  let m_low_b_one15_vce_q1_max = maximum(v(xdut.c1)[40000,59999] - v(xdut.e1)[40000,59999])
  let m_low_b_one15_vce_q1_min = minimum(v(xdut.c1)[40000,59999] - v(xdut.e1)[40000,59999])
  let m_low_b_one15_vce_q2_max = maximum(v(xdut.oc)[40000,59999] - v(xdut.c1)[40000,59999])
  let m_low_b_one15_vce_q2_min = minimum(v(xdut.oc)[40000,59999] - v(xdut.c1)[40000,59999])
  let m_low_b_one15_vbe_q1_max = maximum(v(xdut.b1)[40000,59999] - v(xdut.e1)[40000,59999])
  let m_low_b_one15_vbe_q1_min = minimum(v(xdut.b1)[40000,59999] - v(xdut.e1)[40000,59999])
  let m_low_b_one15_vbe_q2_max = maximum(v(xdut.b2)[40000,59999] - v(xdut.c1)[40000,59999])
  let m_low_b_one15_vbe_q2_min = minimum(v(xdut.b2)[40000,59999] - v(xdut.c1)[40000,59999])
  let w_low_b_one15_ic_q1 = @q.xdut.xq1.qnpn13g2[ic][40000,59999]
  let m_low_b_one15_ic_q1_max = maximum(w_low_b_one15_ic_q1)
  let m_low_b_one15_ic_q1_min = minimum(w_low_b_one15_ic_q1)
  let w_low_b_one15_ic_q2 = @q.xdut.xq2.qnpn13g2[ic][40000,59999]
  let m_low_b_one15_ic_q2_max = maximum(w_low_b_one15_ic_q2)
  let m_low_b_one15_ic_q2_min = minimum(w_low_b_one15_ic_q2)
  print m_low_b_one15_n m_low_b_one15_t0 m_low_b_one15_t1 m_low_b_one15_f0_c m_low_b_one15_f0_s m_low_b_one15_fl_lo_c
  print m_low_b_one15_fl_lo_s m_low_b_one15_fl_hi_c m_low_b_one15_fl_hi_s m_low_b_one15_vce_q1_max m_low_b_one15_vce_q1_min m_low_b_one15_vce_q2_max
  print m_low_b_one15_vce_q2_min m_low_b_one15_vbe_q1_max m_low_b_one15_vbe_q1_min m_low_b_one15_vbe_q2_max m_low_b_one15_vbe_q2_min m_low_b_one15_ic_q1_max
  print m_low_b_one15_ic_q1_min m_low_b_one15_ic_q2_max m_low_b_one15_ic_q2_min
  * run low_b_one16: one-tone, available power -24 dBm per tone
  alterparam fq1 = 17950000000.0
  alterparam fq2 = 17950000000.0
  alterparam va1 = 0.0399052462993776
  alterparam va2 = 0.0
  reset
  save all @q.xdut.xq1.qnpn13g2[ic] @q.xdut.xq2.qnpn13g2[ic]
  tran 1e-12 6e-08 0 1e-12
  linearize v(p2) v(xdut.c1) v(xdut.e1) v(xdut.oc) v(xdut.b1) v(xdut.b2) @q.xdut.xq1.qnpn13g2[ic] @q.xdut.xq2.qnpn13g2[ic]
  let tt = time[40000,59999]
  let xo = v(p2)[40000,59999]
  let m_low_b_one16_n = length(xo)
  let m_low_b_one16_t0 = tt[0]
  let m_low_b_one16_t1 = tt[19999]
  let m_low_b_one16_f0_c = 2*mean(xo*cos(2*pi*17950000000.0*tt))
  let m_low_b_one16_f0_s = 2*mean(xo*sin(2*pi*17950000000.0*tt))
  let m_low_b_one16_fl_lo_c = 2*mean(xo*cos(2*pi*17900000000.0*tt))
  let m_low_b_one16_fl_lo_s = 2*mean(xo*sin(2*pi*17900000000.0*tt))
  let m_low_b_one16_fl_hi_c = 2*mean(xo*cos(2*pi*18000000000.0*tt))
  let m_low_b_one16_fl_hi_s = 2*mean(xo*sin(2*pi*18000000000.0*tt))
  let m_low_b_one16_vce_q1_max = maximum(v(xdut.c1)[40000,59999] - v(xdut.e1)[40000,59999])
  let m_low_b_one16_vce_q1_min = minimum(v(xdut.c1)[40000,59999] - v(xdut.e1)[40000,59999])
  let m_low_b_one16_vce_q2_max = maximum(v(xdut.oc)[40000,59999] - v(xdut.c1)[40000,59999])
  let m_low_b_one16_vce_q2_min = minimum(v(xdut.oc)[40000,59999] - v(xdut.c1)[40000,59999])
  let m_low_b_one16_vbe_q1_max = maximum(v(xdut.b1)[40000,59999] - v(xdut.e1)[40000,59999])
  let m_low_b_one16_vbe_q1_min = minimum(v(xdut.b1)[40000,59999] - v(xdut.e1)[40000,59999])
  let m_low_b_one16_vbe_q2_max = maximum(v(xdut.b2)[40000,59999] - v(xdut.c1)[40000,59999])
  let m_low_b_one16_vbe_q2_min = minimum(v(xdut.b2)[40000,59999] - v(xdut.c1)[40000,59999])
  let w_low_b_one16_ic_q1 = @q.xdut.xq1.qnpn13g2[ic][40000,59999]
  let m_low_b_one16_ic_q1_max = maximum(w_low_b_one16_ic_q1)
  let m_low_b_one16_ic_q1_min = minimum(w_low_b_one16_ic_q1)
  let w_low_b_one16_ic_q2 = @q.xdut.xq2.qnpn13g2[ic][40000,59999]
  let m_low_b_one16_ic_q2_max = maximum(w_low_b_one16_ic_q2)
  let m_low_b_one16_ic_q2_min = minimum(w_low_b_one16_ic_q2)
  print m_low_b_one16_n m_low_b_one16_t0 m_low_b_one16_t1 m_low_b_one16_f0_c m_low_b_one16_f0_s m_low_b_one16_fl_lo_c
  print m_low_b_one16_fl_lo_s m_low_b_one16_fl_hi_c m_low_b_one16_fl_hi_s m_low_b_one16_vce_q1_max m_low_b_one16_vce_q1_min m_low_b_one16_vce_q2_max
  print m_low_b_one16_vce_q2_min m_low_b_one16_vbe_q1_max m_low_b_one16_vbe_q1_min m_low_b_one16_vbe_q2_max m_low_b_one16_vbe_q2_min m_low_b_one16_ic_q1_max
  print m_low_b_one16_ic_q1_min m_low_b_one16_ic_q2_max m_low_b_one16_ic_q2_min
  * run low_b_one17: one-tone, available power -22 dBm per tone
  alterparam fq1 = 17950000000.0
  alterparam fq2 = 17950000000.0
  alterparam va1 = 0.0502377286301916
  alterparam va2 = 0.0
  reset
  save all @q.xdut.xq1.qnpn13g2[ic] @q.xdut.xq2.qnpn13g2[ic]
  tran 1e-12 6e-08 0 1e-12
  linearize v(p2) v(xdut.c1) v(xdut.e1) v(xdut.oc) v(xdut.b1) v(xdut.b2) @q.xdut.xq1.qnpn13g2[ic] @q.xdut.xq2.qnpn13g2[ic]
  let tt = time[40000,59999]
  let xo = v(p2)[40000,59999]
  let m_low_b_one17_n = length(xo)
  let m_low_b_one17_t0 = tt[0]
  let m_low_b_one17_t1 = tt[19999]
  let m_low_b_one17_f0_c = 2*mean(xo*cos(2*pi*17950000000.0*tt))
  let m_low_b_one17_f0_s = 2*mean(xo*sin(2*pi*17950000000.0*tt))
  let m_low_b_one17_fl_lo_c = 2*mean(xo*cos(2*pi*17900000000.0*tt))
  let m_low_b_one17_fl_lo_s = 2*mean(xo*sin(2*pi*17900000000.0*tt))
  let m_low_b_one17_fl_hi_c = 2*mean(xo*cos(2*pi*18000000000.0*tt))
  let m_low_b_one17_fl_hi_s = 2*mean(xo*sin(2*pi*18000000000.0*tt))
  let m_low_b_one17_vce_q1_max = maximum(v(xdut.c1)[40000,59999] - v(xdut.e1)[40000,59999])
  let m_low_b_one17_vce_q1_min = minimum(v(xdut.c1)[40000,59999] - v(xdut.e1)[40000,59999])
  let m_low_b_one17_vce_q2_max = maximum(v(xdut.oc)[40000,59999] - v(xdut.c1)[40000,59999])
  let m_low_b_one17_vce_q2_min = minimum(v(xdut.oc)[40000,59999] - v(xdut.c1)[40000,59999])
  let m_low_b_one17_vbe_q1_max = maximum(v(xdut.b1)[40000,59999] - v(xdut.e1)[40000,59999])
  let m_low_b_one17_vbe_q1_min = minimum(v(xdut.b1)[40000,59999] - v(xdut.e1)[40000,59999])
  let m_low_b_one17_vbe_q2_max = maximum(v(xdut.b2)[40000,59999] - v(xdut.c1)[40000,59999])
  let m_low_b_one17_vbe_q2_min = minimum(v(xdut.b2)[40000,59999] - v(xdut.c1)[40000,59999])
  let w_low_b_one17_ic_q1 = @q.xdut.xq1.qnpn13g2[ic][40000,59999]
  let m_low_b_one17_ic_q1_max = maximum(w_low_b_one17_ic_q1)
  let m_low_b_one17_ic_q1_min = minimum(w_low_b_one17_ic_q1)
  let w_low_b_one17_ic_q2 = @q.xdut.xq2.qnpn13g2[ic][40000,59999]
  let m_low_b_one17_ic_q2_max = maximum(w_low_b_one17_ic_q2)
  let m_low_b_one17_ic_q2_min = minimum(w_low_b_one17_ic_q2)
  print m_low_b_one17_n m_low_b_one17_t0 m_low_b_one17_t1 m_low_b_one17_f0_c m_low_b_one17_f0_s m_low_b_one17_fl_lo_c
  print m_low_b_one17_fl_lo_s m_low_b_one17_fl_hi_c m_low_b_one17_fl_hi_s m_low_b_one17_vce_q1_max m_low_b_one17_vce_q1_min m_low_b_one17_vce_q2_max
  print m_low_b_one17_vce_q2_min m_low_b_one17_vbe_q1_max m_low_b_one17_vbe_q1_min m_low_b_one17_vbe_q2_max m_low_b_one17_vbe_q2_min m_low_b_one17_ic_q1_max
  print m_low_b_one17_ic_q1_min m_low_b_one17_ic_q2_max m_low_b_one17_ic_q2_min
  * run low_b_one18: one-tone, available power -20 dBm per tone
  alterparam fq1 = 17950000000.0
  alterparam fq2 = 17950000000.0
  alterparam va1 = 0.0632455532033676
  alterparam va2 = 0.0
  reset
  save all @q.xdut.xq1.qnpn13g2[ic] @q.xdut.xq2.qnpn13g2[ic]
  tran 1e-12 6e-08 0 1e-12
  linearize v(p2) v(xdut.c1) v(xdut.e1) v(xdut.oc) v(xdut.b1) v(xdut.b2) @q.xdut.xq1.qnpn13g2[ic] @q.xdut.xq2.qnpn13g2[ic]
  let tt = time[40000,59999]
  let xo = v(p2)[40000,59999]
  let m_low_b_one18_n = length(xo)
  let m_low_b_one18_t0 = tt[0]
  let m_low_b_one18_t1 = tt[19999]
  let m_low_b_one18_f0_c = 2*mean(xo*cos(2*pi*17950000000.0*tt))
  let m_low_b_one18_f0_s = 2*mean(xo*sin(2*pi*17950000000.0*tt))
  let m_low_b_one18_fl_lo_c = 2*mean(xo*cos(2*pi*17900000000.0*tt))
  let m_low_b_one18_fl_lo_s = 2*mean(xo*sin(2*pi*17900000000.0*tt))
  let m_low_b_one18_fl_hi_c = 2*mean(xo*cos(2*pi*18000000000.0*tt))
  let m_low_b_one18_fl_hi_s = 2*mean(xo*sin(2*pi*18000000000.0*tt))
  let m_low_b_one18_vce_q1_max = maximum(v(xdut.c1)[40000,59999] - v(xdut.e1)[40000,59999])
  let m_low_b_one18_vce_q1_min = minimum(v(xdut.c1)[40000,59999] - v(xdut.e1)[40000,59999])
  let m_low_b_one18_vce_q2_max = maximum(v(xdut.oc)[40000,59999] - v(xdut.c1)[40000,59999])
  let m_low_b_one18_vce_q2_min = minimum(v(xdut.oc)[40000,59999] - v(xdut.c1)[40000,59999])
  let m_low_b_one18_vbe_q1_max = maximum(v(xdut.b1)[40000,59999] - v(xdut.e1)[40000,59999])
  let m_low_b_one18_vbe_q1_min = minimum(v(xdut.b1)[40000,59999] - v(xdut.e1)[40000,59999])
  let m_low_b_one18_vbe_q2_max = maximum(v(xdut.b2)[40000,59999] - v(xdut.c1)[40000,59999])
  let m_low_b_one18_vbe_q2_min = minimum(v(xdut.b2)[40000,59999] - v(xdut.c1)[40000,59999])
  let w_low_b_one18_ic_q1 = @q.xdut.xq1.qnpn13g2[ic][40000,59999]
  let m_low_b_one18_ic_q1_max = maximum(w_low_b_one18_ic_q1)
  let m_low_b_one18_ic_q1_min = minimum(w_low_b_one18_ic_q1)
  let w_low_b_one18_ic_q2 = @q.xdut.xq2.qnpn13g2[ic][40000,59999]
  let m_low_b_one18_ic_q2_max = maximum(w_low_b_one18_ic_q2)
  let m_low_b_one18_ic_q2_min = minimum(w_low_b_one18_ic_q2)
  print m_low_b_one18_n m_low_b_one18_t0 m_low_b_one18_t1 m_low_b_one18_f0_c m_low_b_one18_f0_s m_low_b_one18_fl_lo_c
  print m_low_b_one18_fl_lo_s m_low_b_one18_fl_hi_c m_low_b_one18_fl_hi_s m_low_b_one18_vce_q1_max m_low_b_one18_vce_q1_min m_low_b_one18_vce_q2_max
  print m_low_b_one18_vce_q2_min m_low_b_one18_vbe_q1_max m_low_b_one18_vbe_q1_min m_low_b_one18_vbe_q2_max m_low_b_one18_vbe_q2_min m_low_b_one18_ic_q1_max
  print m_low_b_one18_ic_q1_min m_low_b_one18_ic_q2_max m_low_b_one18_ic_q2_min
  * run low_b_one19: one-tone, available power -18 dBm per tone
  alterparam fq1 = 17950000000.0
  alterparam fq2 = 17950000000.0
  alterparam va1 = 0.0796214341106995
  alterparam va2 = 0.0
  reset
  save all @q.xdut.xq1.qnpn13g2[ic] @q.xdut.xq2.qnpn13g2[ic]
  tran 1e-12 6e-08 0 1e-12
  linearize v(p2) v(xdut.c1) v(xdut.e1) v(xdut.oc) v(xdut.b1) v(xdut.b2) @q.xdut.xq1.qnpn13g2[ic] @q.xdut.xq2.qnpn13g2[ic]
  let tt = time[40000,59999]
  let xo = v(p2)[40000,59999]
  let m_low_b_one19_n = length(xo)
  let m_low_b_one19_t0 = tt[0]
  let m_low_b_one19_t1 = tt[19999]
  let m_low_b_one19_f0_c = 2*mean(xo*cos(2*pi*17950000000.0*tt))
  let m_low_b_one19_f0_s = 2*mean(xo*sin(2*pi*17950000000.0*tt))
  let m_low_b_one19_fl_lo_c = 2*mean(xo*cos(2*pi*17900000000.0*tt))
  let m_low_b_one19_fl_lo_s = 2*mean(xo*sin(2*pi*17900000000.0*tt))
  let m_low_b_one19_fl_hi_c = 2*mean(xo*cos(2*pi*18000000000.0*tt))
  let m_low_b_one19_fl_hi_s = 2*mean(xo*sin(2*pi*18000000000.0*tt))
  let m_low_b_one19_vce_q1_max = maximum(v(xdut.c1)[40000,59999] - v(xdut.e1)[40000,59999])
  let m_low_b_one19_vce_q1_min = minimum(v(xdut.c1)[40000,59999] - v(xdut.e1)[40000,59999])
  let m_low_b_one19_vce_q2_max = maximum(v(xdut.oc)[40000,59999] - v(xdut.c1)[40000,59999])
  let m_low_b_one19_vce_q2_min = minimum(v(xdut.oc)[40000,59999] - v(xdut.c1)[40000,59999])
  let m_low_b_one19_vbe_q1_max = maximum(v(xdut.b1)[40000,59999] - v(xdut.e1)[40000,59999])
  let m_low_b_one19_vbe_q1_min = minimum(v(xdut.b1)[40000,59999] - v(xdut.e1)[40000,59999])
  let m_low_b_one19_vbe_q2_max = maximum(v(xdut.b2)[40000,59999] - v(xdut.c1)[40000,59999])
  let m_low_b_one19_vbe_q2_min = minimum(v(xdut.b2)[40000,59999] - v(xdut.c1)[40000,59999])
  let w_low_b_one19_ic_q1 = @q.xdut.xq1.qnpn13g2[ic][40000,59999]
  let m_low_b_one19_ic_q1_max = maximum(w_low_b_one19_ic_q1)
  let m_low_b_one19_ic_q1_min = minimum(w_low_b_one19_ic_q1)
  let w_low_b_one19_ic_q2 = @q.xdut.xq2.qnpn13g2[ic][40000,59999]
  let m_low_b_one19_ic_q2_max = maximum(w_low_b_one19_ic_q2)
  let m_low_b_one19_ic_q2_min = minimum(w_low_b_one19_ic_q2)
  print m_low_b_one19_n m_low_b_one19_t0 m_low_b_one19_t1 m_low_b_one19_f0_c m_low_b_one19_f0_s m_low_b_one19_fl_lo_c
  print m_low_b_one19_fl_lo_s m_low_b_one19_fl_hi_c m_low_b_one19_fl_hi_s m_low_b_one19_vce_q1_max m_low_b_one19_vce_q1_min m_low_b_one19_vce_q2_max
  print m_low_b_one19_vce_q2_min m_low_b_one19_vbe_q1_max m_low_b_one19_vbe_q1_min m_low_b_one19_vbe_q2_max m_low_b_one19_vbe_q2_min m_low_b_one19_ic_q1_max
  print m_low_b_one19_ic_q1_min m_low_b_one19_ic_q2_max m_low_b_one19_ic_q2_min
  * run low_b_one20: one-tone, available power -16 dBm per tone
  alterparam fq1 = 17950000000.0
  alterparam fq2 = 17950000000.0
  alterparam va1 = 0.100237446725454
  alterparam va2 = 0.0
  reset
  save all @q.xdut.xq1.qnpn13g2[ic] @q.xdut.xq2.qnpn13g2[ic]
  tran 1e-12 6e-08 0 1e-12
  linearize v(p2) v(xdut.c1) v(xdut.e1) v(xdut.oc) v(xdut.b1) v(xdut.b2) @q.xdut.xq1.qnpn13g2[ic] @q.xdut.xq2.qnpn13g2[ic]
  let tt = time[40000,59999]
  let xo = v(p2)[40000,59999]
  let m_low_b_one20_n = length(xo)
  let m_low_b_one20_t0 = tt[0]
  let m_low_b_one20_t1 = tt[19999]
  let m_low_b_one20_f0_c = 2*mean(xo*cos(2*pi*17950000000.0*tt))
  let m_low_b_one20_f0_s = 2*mean(xo*sin(2*pi*17950000000.0*tt))
  let m_low_b_one20_fl_lo_c = 2*mean(xo*cos(2*pi*17900000000.0*tt))
  let m_low_b_one20_fl_lo_s = 2*mean(xo*sin(2*pi*17900000000.0*tt))
  let m_low_b_one20_fl_hi_c = 2*mean(xo*cos(2*pi*18000000000.0*tt))
  let m_low_b_one20_fl_hi_s = 2*mean(xo*sin(2*pi*18000000000.0*tt))
  let m_low_b_one20_vce_q1_max = maximum(v(xdut.c1)[40000,59999] - v(xdut.e1)[40000,59999])
  let m_low_b_one20_vce_q1_min = minimum(v(xdut.c1)[40000,59999] - v(xdut.e1)[40000,59999])
  let m_low_b_one20_vce_q2_max = maximum(v(xdut.oc)[40000,59999] - v(xdut.c1)[40000,59999])
  let m_low_b_one20_vce_q2_min = minimum(v(xdut.oc)[40000,59999] - v(xdut.c1)[40000,59999])
  let m_low_b_one20_vbe_q1_max = maximum(v(xdut.b1)[40000,59999] - v(xdut.e1)[40000,59999])
  let m_low_b_one20_vbe_q1_min = minimum(v(xdut.b1)[40000,59999] - v(xdut.e1)[40000,59999])
  let m_low_b_one20_vbe_q2_max = maximum(v(xdut.b2)[40000,59999] - v(xdut.c1)[40000,59999])
  let m_low_b_one20_vbe_q2_min = minimum(v(xdut.b2)[40000,59999] - v(xdut.c1)[40000,59999])
  let w_low_b_one20_ic_q1 = @q.xdut.xq1.qnpn13g2[ic][40000,59999]
  let m_low_b_one20_ic_q1_max = maximum(w_low_b_one20_ic_q1)
  let m_low_b_one20_ic_q1_min = minimum(w_low_b_one20_ic_q1)
  let w_low_b_one20_ic_q2 = @q.xdut.xq2.qnpn13g2[ic][40000,59999]
  let m_low_b_one20_ic_q2_max = maximum(w_low_b_one20_ic_q2)
  let m_low_b_one20_ic_q2_min = minimum(w_low_b_one20_ic_q2)
  print m_low_b_one20_n m_low_b_one20_t0 m_low_b_one20_t1 m_low_b_one20_f0_c m_low_b_one20_f0_s m_low_b_one20_fl_lo_c
  print m_low_b_one20_fl_lo_s m_low_b_one20_fl_hi_c m_low_b_one20_fl_hi_s m_low_b_one20_vce_q1_max m_low_b_one20_vce_q1_min m_low_b_one20_vce_q2_max
  print m_low_b_one20_vce_q2_min m_low_b_one20_vbe_q1_max m_low_b_one20_vbe_q1_min m_low_b_one20_vbe_q2_max m_low_b_one20_vbe_q2_min m_low_b_one20_ic_q1_max
  print m_low_b_one20_ic_q1_min m_low_b_one20_ic_q2_max m_low_b_one20_ic_q2_min
  * run mid_b_one00: one-tone, available power -56 dBm per tone
  alterparam fq1 = 19450000000.0
  alterparam fq2 = 19450000000.0
  alterparam va1 = 0.00100237446725455
  alterparam va2 = 0.0
  reset
  save all @q.xdut.xq1.qnpn13g2[ic] @q.xdut.xq2.qnpn13g2[ic]
  tran 1e-12 6e-08 0 1e-12
  linearize v(p2) v(xdut.c1) v(xdut.e1) v(xdut.oc) v(xdut.b1) v(xdut.b2) @q.xdut.xq1.qnpn13g2[ic] @q.xdut.xq2.qnpn13g2[ic]
  let tt = time[40000,59999]
  let xo = v(p2)[40000,59999]
  let m_mid_b_one00_n = length(xo)
  let m_mid_b_one00_t0 = tt[0]
  let m_mid_b_one00_t1 = tt[19999]
  let m_mid_b_one00_f0_c = 2*mean(xo*cos(2*pi*19450000000.0*tt))
  let m_mid_b_one00_f0_s = 2*mean(xo*sin(2*pi*19450000000.0*tt))
  let m_mid_b_one00_fl_lo_c = 2*mean(xo*cos(2*pi*19400000000.0*tt))
  let m_mid_b_one00_fl_lo_s = 2*mean(xo*sin(2*pi*19400000000.0*tt))
  let m_mid_b_one00_fl_hi_c = 2*mean(xo*cos(2*pi*19500000000.0*tt))
  let m_mid_b_one00_fl_hi_s = 2*mean(xo*sin(2*pi*19500000000.0*tt))
  let m_mid_b_one00_vce_q1_max = maximum(v(xdut.c1)[40000,59999] - v(xdut.e1)[40000,59999])
  let m_mid_b_one00_vce_q1_min = minimum(v(xdut.c1)[40000,59999] - v(xdut.e1)[40000,59999])
  let m_mid_b_one00_vce_q2_max = maximum(v(xdut.oc)[40000,59999] - v(xdut.c1)[40000,59999])
  let m_mid_b_one00_vce_q2_min = minimum(v(xdut.oc)[40000,59999] - v(xdut.c1)[40000,59999])
  let m_mid_b_one00_vbe_q1_max = maximum(v(xdut.b1)[40000,59999] - v(xdut.e1)[40000,59999])
  let m_mid_b_one00_vbe_q1_min = minimum(v(xdut.b1)[40000,59999] - v(xdut.e1)[40000,59999])
  let m_mid_b_one00_vbe_q2_max = maximum(v(xdut.b2)[40000,59999] - v(xdut.c1)[40000,59999])
  let m_mid_b_one00_vbe_q2_min = minimum(v(xdut.b2)[40000,59999] - v(xdut.c1)[40000,59999])
  let w_mid_b_one00_ic_q1 = @q.xdut.xq1.qnpn13g2[ic][40000,59999]
  let m_mid_b_one00_ic_q1_max = maximum(w_mid_b_one00_ic_q1)
  let m_mid_b_one00_ic_q1_min = minimum(w_mid_b_one00_ic_q1)
  let w_mid_b_one00_ic_q2 = @q.xdut.xq2.qnpn13g2[ic][40000,59999]
  let m_mid_b_one00_ic_q2_max = maximum(w_mid_b_one00_ic_q2)
  let m_mid_b_one00_ic_q2_min = minimum(w_mid_b_one00_ic_q2)
  print m_mid_b_one00_n m_mid_b_one00_t0 m_mid_b_one00_t1 m_mid_b_one00_f0_c m_mid_b_one00_f0_s m_mid_b_one00_fl_lo_c
  print m_mid_b_one00_fl_lo_s m_mid_b_one00_fl_hi_c m_mid_b_one00_fl_hi_s m_mid_b_one00_vce_q1_max m_mid_b_one00_vce_q1_min m_mid_b_one00_vce_q2_max
  print m_mid_b_one00_vce_q2_min m_mid_b_one00_vbe_q1_max m_mid_b_one00_vbe_q1_min m_mid_b_one00_vbe_q2_max m_mid_b_one00_vbe_q2_min m_mid_b_one00_ic_q1_max
  print m_mid_b_one00_ic_q1_min m_mid_b_one00_ic_q2_max m_mid_b_one00_ic_q2_min
  * run mid_b_one01: one-tone, available power -54 dBm per tone
  alterparam fq1 = 19450000000.0
  alterparam fq2 = 19450000000.0
  alterparam va1 = 0.00126191468896039
  alterparam va2 = 0.0
  reset
  save all @q.xdut.xq1.qnpn13g2[ic] @q.xdut.xq2.qnpn13g2[ic]
  tran 1e-12 6e-08 0 1e-12
  linearize v(p2) v(xdut.c1) v(xdut.e1) v(xdut.oc) v(xdut.b1) v(xdut.b2) @q.xdut.xq1.qnpn13g2[ic] @q.xdut.xq2.qnpn13g2[ic]
  let tt = time[40000,59999]
  let xo = v(p2)[40000,59999]
  let m_mid_b_one01_n = length(xo)
  let m_mid_b_one01_t0 = tt[0]
  let m_mid_b_one01_t1 = tt[19999]
  let m_mid_b_one01_f0_c = 2*mean(xo*cos(2*pi*19450000000.0*tt))
  let m_mid_b_one01_f0_s = 2*mean(xo*sin(2*pi*19450000000.0*tt))
  let m_mid_b_one01_fl_lo_c = 2*mean(xo*cos(2*pi*19400000000.0*tt))
  let m_mid_b_one01_fl_lo_s = 2*mean(xo*sin(2*pi*19400000000.0*tt))
  let m_mid_b_one01_fl_hi_c = 2*mean(xo*cos(2*pi*19500000000.0*tt))
  let m_mid_b_one01_fl_hi_s = 2*mean(xo*sin(2*pi*19500000000.0*tt))
  let m_mid_b_one01_vce_q1_max = maximum(v(xdut.c1)[40000,59999] - v(xdut.e1)[40000,59999])
  let m_mid_b_one01_vce_q1_min = minimum(v(xdut.c1)[40000,59999] - v(xdut.e1)[40000,59999])
  let m_mid_b_one01_vce_q2_max = maximum(v(xdut.oc)[40000,59999] - v(xdut.c1)[40000,59999])
  let m_mid_b_one01_vce_q2_min = minimum(v(xdut.oc)[40000,59999] - v(xdut.c1)[40000,59999])
  let m_mid_b_one01_vbe_q1_max = maximum(v(xdut.b1)[40000,59999] - v(xdut.e1)[40000,59999])
  let m_mid_b_one01_vbe_q1_min = minimum(v(xdut.b1)[40000,59999] - v(xdut.e1)[40000,59999])
  let m_mid_b_one01_vbe_q2_max = maximum(v(xdut.b2)[40000,59999] - v(xdut.c1)[40000,59999])
  let m_mid_b_one01_vbe_q2_min = minimum(v(xdut.b2)[40000,59999] - v(xdut.c1)[40000,59999])
  let w_mid_b_one01_ic_q1 = @q.xdut.xq1.qnpn13g2[ic][40000,59999]
  let m_mid_b_one01_ic_q1_max = maximum(w_mid_b_one01_ic_q1)
  let m_mid_b_one01_ic_q1_min = minimum(w_mid_b_one01_ic_q1)
  let w_mid_b_one01_ic_q2 = @q.xdut.xq2.qnpn13g2[ic][40000,59999]
  let m_mid_b_one01_ic_q2_max = maximum(w_mid_b_one01_ic_q2)
  let m_mid_b_one01_ic_q2_min = minimum(w_mid_b_one01_ic_q2)
  print m_mid_b_one01_n m_mid_b_one01_t0 m_mid_b_one01_t1 m_mid_b_one01_f0_c m_mid_b_one01_f0_s m_mid_b_one01_fl_lo_c
  print m_mid_b_one01_fl_lo_s m_mid_b_one01_fl_hi_c m_mid_b_one01_fl_hi_s m_mid_b_one01_vce_q1_max m_mid_b_one01_vce_q1_min m_mid_b_one01_vce_q2_max
  print m_mid_b_one01_vce_q2_min m_mid_b_one01_vbe_q1_max m_mid_b_one01_vbe_q1_min m_mid_b_one01_vbe_q2_max m_mid_b_one01_vbe_q2_min m_mid_b_one01_ic_q1_max
  print m_mid_b_one01_ic_q1_min m_mid_b_one01_ic_q2_max m_mid_b_one01_ic_q2_min
  * run mid_b_one02: one-tone, available power -52 dBm per tone
  alterparam fq1 = 19450000000.0
  alterparam fq2 = 19450000000.0
  alterparam va1 = 0.00158865646944856
  alterparam va2 = 0.0
  reset
  save all @q.xdut.xq1.qnpn13g2[ic] @q.xdut.xq2.qnpn13g2[ic]
  tran 1e-12 6e-08 0 1e-12
  linearize v(p2) v(xdut.c1) v(xdut.e1) v(xdut.oc) v(xdut.b1) v(xdut.b2) @q.xdut.xq1.qnpn13g2[ic] @q.xdut.xq2.qnpn13g2[ic]
  let tt = time[40000,59999]
  let xo = v(p2)[40000,59999]
  let m_mid_b_one02_n = length(xo)
  let m_mid_b_one02_t0 = tt[0]
  let m_mid_b_one02_t1 = tt[19999]
  let m_mid_b_one02_f0_c = 2*mean(xo*cos(2*pi*19450000000.0*tt))
  let m_mid_b_one02_f0_s = 2*mean(xo*sin(2*pi*19450000000.0*tt))
  let m_mid_b_one02_fl_lo_c = 2*mean(xo*cos(2*pi*19400000000.0*tt))
  let m_mid_b_one02_fl_lo_s = 2*mean(xo*sin(2*pi*19400000000.0*tt))
  let m_mid_b_one02_fl_hi_c = 2*mean(xo*cos(2*pi*19500000000.0*tt))
  let m_mid_b_one02_fl_hi_s = 2*mean(xo*sin(2*pi*19500000000.0*tt))
  let m_mid_b_one02_vce_q1_max = maximum(v(xdut.c1)[40000,59999] - v(xdut.e1)[40000,59999])
  let m_mid_b_one02_vce_q1_min = minimum(v(xdut.c1)[40000,59999] - v(xdut.e1)[40000,59999])
  let m_mid_b_one02_vce_q2_max = maximum(v(xdut.oc)[40000,59999] - v(xdut.c1)[40000,59999])
  let m_mid_b_one02_vce_q2_min = minimum(v(xdut.oc)[40000,59999] - v(xdut.c1)[40000,59999])
  let m_mid_b_one02_vbe_q1_max = maximum(v(xdut.b1)[40000,59999] - v(xdut.e1)[40000,59999])
  let m_mid_b_one02_vbe_q1_min = minimum(v(xdut.b1)[40000,59999] - v(xdut.e1)[40000,59999])
  let m_mid_b_one02_vbe_q2_max = maximum(v(xdut.b2)[40000,59999] - v(xdut.c1)[40000,59999])
  let m_mid_b_one02_vbe_q2_min = minimum(v(xdut.b2)[40000,59999] - v(xdut.c1)[40000,59999])
  let w_mid_b_one02_ic_q1 = @q.xdut.xq1.qnpn13g2[ic][40000,59999]
  let m_mid_b_one02_ic_q1_max = maximum(w_mid_b_one02_ic_q1)
  let m_mid_b_one02_ic_q1_min = minimum(w_mid_b_one02_ic_q1)
  let w_mid_b_one02_ic_q2 = @q.xdut.xq2.qnpn13g2[ic][40000,59999]
  let m_mid_b_one02_ic_q2_max = maximum(w_mid_b_one02_ic_q2)
  let m_mid_b_one02_ic_q2_min = minimum(w_mid_b_one02_ic_q2)
  print m_mid_b_one02_n m_mid_b_one02_t0 m_mid_b_one02_t1 m_mid_b_one02_f0_c m_mid_b_one02_f0_s m_mid_b_one02_fl_lo_c
  print m_mid_b_one02_fl_lo_s m_mid_b_one02_fl_hi_c m_mid_b_one02_fl_hi_s m_mid_b_one02_vce_q1_max m_mid_b_one02_vce_q1_min m_mid_b_one02_vce_q2_max
  print m_mid_b_one02_vce_q2_min m_mid_b_one02_vbe_q1_max m_mid_b_one02_vbe_q1_min m_mid_b_one02_vbe_q2_max m_mid_b_one02_vbe_q2_min m_mid_b_one02_ic_q1_max
  print m_mid_b_one02_ic_q1_min m_mid_b_one02_ic_q2_max m_mid_b_one02_ic_q2_min
  * run mid_b_one03: one-tone, available power -50 dBm per tone
  alterparam fq1 = 19450000000.0
  alterparam fq2 = 19450000000.0
  alterparam va1 = 0.002
  alterparam va2 = 0.0
  reset
  save all @q.xdut.xq1.qnpn13g2[ic] @q.xdut.xq2.qnpn13g2[ic]
  tran 1e-12 6e-08 0 1e-12
  linearize v(p2) v(xdut.c1) v(xdut.e1) v(xdut.oc) v(xdut.b1) v(xdut.b2) @q.xdut.xq1.qnpn13g2[ic] @q.xdut.xq2.qnpn13g2[ic]
  let tt = time[40000,59999]
  let xo = v(p2)[40000,59999]
  let m_mid_b_one03_n = length(xo)
  let m_mid_b_one03_t0 = tt[0]
  let m_mid_b_one03_t1 = tt[19999]
  let m_mid_b_one03_f0_c = 2*mean(xo*cos(2*pi*19450000000.0*tt))
  let m_mid_b_one03_f0_s = 2*mean(xo*sin(2*pi*19450000000.0*tt))
  let m_mid_b_one03_fl_lo_c = 2*mean(xo*cos(2*pi*19400000000.0*tt))
  let m_mid_b_one03_fl_lo_s = 2*mean(xo*sin(2*pi*19400000000.0*tt))
  let m_mid_b_one03_fl_hi_c = 2*mean(xo*cos(2*pi*19500000000.0*tt))
  let m_mid_b_one03_fl_hi_s = 2*mean(xo*sin(2*pi*19500000000.0*tt))
  let m_mid_b_one03_vce_q1_max = maximum(v(xdut.c1)[40000,59999] - v(xdut.e1)[40000,59999])
  let m_mid_b_one03_vce_q1_min = minimum(v(xdut.c1)[40000,59999] - v(xdut.e1)[40000,59999])
  let m_mid_b_one03_vce_q2_max = maximum(v(xdut.oc)[40000,59999] - v(xdut.c1)[40000,59999])
  let m_mid_b_one03_vce_q2_min = minimum(v(xdut.oc)[40000,59999] - v(xdut.c1)[40000,59999])
  let m_mid_b_one03_vbe_q1_max = maximum(v(xdut.b1)[40000,59999] - v(xdut.e1)[40000,59999])
  let m_mid_b_one03_vbe_q1_min = minimum(v(xdut.b1)[40000,59999] - v(xdut.e1)[40000,59999])
  let m_mid_b_one03_vbe_q2_max = maximum(v(xdut.b2)[40000,59999] - v(xdut.c1)[40000,59999])
  let m_mid_b_one03_vbe_q2_min = minimum(v(xdut.b2)[40000,59999] - v(xdut.c1)[40000,59999])
  let w_mid_b_one03_ic_q1 = @q.xdut.xq1.qnpn13g2[ic][40000,59999]
  let m_mid_b_one03_ic_q1_max = maximum(w_mid_b_one03_ic_q1)
  let m_mid_b_one03_ic_q1_min = minimum(w_mid_b_one03_ic_q1)
  let w_mid_b_one03_ic_q2 = @q.xdut.xq2.qnpn13g2[ic][40000,59999]
  let m_mid_b_one03_ic_q2_max = maximum(w_mid_b_one03_ic_q2)
  let m_mid_b_one03_ic_q2_min = minimum(w_mid_b_one03_ic_q2)
  print m_mid_b_one03_n m_mid_b_one03_t0 m_mid_b_one03_t1 m_mid_b_one03_f0_c m_mid_b_one03_f0_s m_mid_b_one03_fl_lo_c
  print m_mid_b_one03_fl_lo_s m_mid_b_one03_fl_hi_c m_mid_b_one03_fl_hi_s m_mid_b_one03_vce_q1_max m_mid_b_one03_vce_q1_min m_mid_b_one03_vce_q2_max
  print m_mid_b_one03_vce_q2_min m_mid_b_one03_vbe_q1_max m_mid_b_one03_vbe_q1_min m_mid_b_one03_vbe_q2_max m_mid_b_one03_vbe_q2_min m_mid_b_one03_ic_q1_max
  print m_mid_b_one03_ic_q1_min m_mid_b_one03_ic_q2_max m_mid_b_one03_ic_q2_min
  * run mid_b_one04: one-tone, available power -48 dBm per tone
  alterparam fq1 = 19450000000.0
  alterparam fq2 = 19450000000.0
  alterparam va1 = 0.00251785082358833
  alterparam va2 = 0.0
  reset
  save all @q.xdut.xq1.qnpn13g2[ic] @q.xdut.xq2.qnpn13g2[ic]
  tran 1e-12 6e-08 0 1e-12
  linearize v(p2) v(xdut.c1) v(xdut.e1) v(xdut.oc) v(xdut.b1) v(xdut.b2) @q.xdut.xq1.qnpn13g2[ic] @q.xdut.xq2.qnpn13g2[ic]
  let tt = time[40000,59999]
  let xo = v(p2)[40000,59999]
  let m_mid_b_one04_n = length(xo)
  let m_mid_b_one04_t0 = tt[0]
  let m_mid_b_one04_t1 = tt[19999]
  let m_mid_b_one04_f0_c = 2*mean(xo*cos(2*pi*19450000000.0*tt))
  let m_mid_b_one04_f0_s = 2*mean(xo*sin(2*pi*19450000000.0*tt))
  let m_mid_b_one04_fl_lo_c = 2*mean(xo*cos(2*pi*19400000000.0*tt))
  let m_mid_b_one04_fl_lo_s = 2*mean(xo*sin(2*pi*19400000000.0*tt))
  let m_mid_b_one04_fl_hi_c = 2*mean(xo*cos(2*pi*19500000000.0*tt))
  let m_mid_b_one04_fl_hi_s = 2*mean(xo*sin(2*pi*19500000000.0*tt))
  let m_mid_b_one04_vce_q1_max = maximum(v(xdut.c1)[40000,59999] - v(xdut.e1)[40000,59999])
  let m_mid_b_one04_vce_q1_min = minimum(v(xdut.c1)[40000,59999] - v(xdut.e1)[40000,59999])
  let m_mid_b_one04_vce_q2_max = maximum(v(xdut.oc)[40000,59999] - v(xdut.c1)[40000,59999])
  let m_mid_b_one04_vce_q2_min = minimum(v(xdut.oc)[40000,59999] - v(xdut.c1)[40000,59999])
  let m_mid_b_one04_vbe_q1_max = maximum(v(xdut.b1)[40000,59999] - v(xdut.e1)[40000,59999])
  let m_mid_b_one04_vbe_q1_min = minimum(v(xdut.b1)[40000,59999] - v(xdut.e1)[40000,59999])
  let m_mid_b_one04_vbe_q2_max = maximum(v(xdut.b2)[40000,59999] - v(xdut.c1)[40000,59999])
  let m_mid_b_one04_vbe_q2_min = minimum(v(xdut.b2)[40000,59999] - v(xdut.c1)[40000,59999])
  let w_mid_b_one04_ic_q1 = @q.xdut.xq1.qnpn13g2[ic][40000,59999]
  let m_mid_b_one04_ic_q1_max = maximum(w_mid_b_one04_ic_q1)
  let m_mid_b_one04_ic_q1_min = minimum(w_mid_b_one04_ic_q1)
  let w_mid_b_one04_ic_q2 = @q.xdut.xq2.qnpn13g2[ic][40000,59999]
  let m_mid_b_one04_ic_q2_max = maximum(w_mid_b_one04_ic_q2)
  let m_mid_b_one04_ic_q2_min = minimum(w_mid_b_one04_ic_q2)
  print m_mid_b_one04_n m_mid_b_one04_t0 m_mid_b_one04_t1 m_mid_b_one04_f0_c m_mid_b_one04_f0_s m_mid_b_one04_fl_lo_c
  print m_mid_b_one04_fl_lo_s m_mid_b_one04_fl_hi_c m_mid_b_one04_fl_hi_s m_mid_b_one04_vce_q1_max m_mid_b_one04_vce_q1_min m_mid_b_one04_vce_q2_max
  print m_mid_b_one04_vce_q2_min m_mid_b_one04_vbe_q1_max m_mid_b_one04_vbe_q1_min m_mid_b_one04_vbe_q2_max m_mid_b_one04_vbe_q2_min m_mid_b_one04_ic_q1_max
  print m_mid_b_one04_ic_q1_min m_mid_b_one04_ic_q2_max m_mid_b_one04_ic_q2_min
  * run mid_b_one05: one-tone, available power -46 dBm per tone
  alterparam fq1 = 19450000000.0
  alterparam fq2 = 19450000000.0
  alterparam va1 = 0.00316978638492223
  alterparam va2 = 0.0
  reset
  save all @q.xdut.xq1.qnpn13g2[ic] @q.xdut.xq2.qnpn13g2[ic]
  tran 1e-12 6e-08 0 1e-12
  linearize v(p2) v(xdut.c1) v(xdut.e1) v(xdut.oc) v(xdut.b1) v(xdut.b2) @q.xdut.xq1.qnpn13g2[ic] @q.xdut.xq2.qnpn13g2[ic]
  let tt = time[40000,59999]
  let xo = v(p2)[40000,59999]
  let m_mid_b_one05_n = length(xo)
  let m_mid_b_one05_t0 = tt[0]
  let m_mid_b_one05_t1 = tt[19999]
  let m_mid_b_one05_f0_c = 2*mean(xo*cos(2*pi*19450000000.0*tt))
  let m_mid_b_one05_f0_s = 2*mean(xo*sin(2*pi*19450000000.0*tt))
  let m_mid_b_one05_fl_lo_c = 2*mean(xo*cos(2*pi*19400000000.0*tt))
  let m_mid_b_one05_fl_lo_s = 2*mean(xo*sin(2*pi*19400000000.0*tt))
  let m_mid_b_one05_fl_hi_c = 2*mean(xo*cos(2*pi*19500000000.0*tt))
  let m_mid_b_one05_fl_hi_s = 2*mean(xo*sin(2*pi*19500000000.0*tt))
  let m_mid_b_one05_vce_q1_max = maximum(v(xdut.c1)[40000,59999] - v(xdut.e1)[40000,59999])
  let m_mid_b_one05_vce_q1_min = minimum(v(xdut.c1)[40000,59999] - v(xdut.e1)[40000,59999])
  let m_mid_b_one05_vce_q2_max = maximum(v(xdut.oc)[40000,59999] - v(xdut.c1)[40000,59999])
  let m_mid_b_one05_vce_q2_min = minimum(v(xdut.oc)[40000,59999] - v(xdut.c1)[40000,59999])
  let m_mid_b_one05_vbe_q1_max = maximum(v(xdut.b1)[40000,59999] - v(xdut.e1)[40000,59999])
  let m_mid_b_one05_vbe_q1_min = minimum(v(xdut.b1)[40000,59999] - v(xdut.e1)[40000,59999])
  let m_mid_b_one05_vbe_q2_max = maximum(v(xdut.b2)[40000,59999] - v(xdut.c1)[40000,59999])
  let m_mid_b_one05_vbe_q2_min = minimum(v(xdut.b2)[40000,59999] - v(xdut.c1)[40000,59999])
  let w_mid_b_one05_ic_q1 = @q.xdut.xq1.qnpn13g2[ic][40000,59999]
  let m_mid_b_one05_ic_q1_max = maximum(w_mid_b_one05_ic_q1)
  let m_mid_b_one05_ic_q1_min = minimum(w_mid_b_one05_ic_q1)
  let w_mid_b_one05_ic_q2 = @q.xdut.xq2.qnpn13g2[ic][40000,59999]
  let m_mid_b_one05_ic_q2_max = maximum(w_mid_b_one05_ic_q2)
  let m_mid_b_one05_ic_q2_min = minimum(w_mid_b_one05_ic_q2)
  print m_mid_b_one05_n m_mid_b_one05_t0 m_mid_b_one05_t1 m_mid_b_one05_f0_c m_mid_b_one05_f0_s m_mid_b_one05_fl_lo_c
  print m_mid_b_one05_fl_lo_s m_mid_b_one05_fl_hi_c m_mid_b_one05_fl_hi_s m_mid_b_one05_vce_q1_max m_mid_b_one05_vce_q1_min m_mid_b_one05_vce_q2_max
  print m_mid_b_one05_vce_q2_min m_mid_b_one05_vbe_q1_max m_mid_b_one05_vbe_q1_min m_mid_b_one05_vbe_q2_max m_mid_b_one05_vbe_q2_min m_mid_b_one05_ic_q1_max
  print m_mid_b_one05_ic_q1_min m_mid_b_one05_ic_q2_max m_mid_b_one05_ic_q2_min
  * run mid_b_one06: one-tone, available power -44 dBm per tone
  alterparam fq1 = 19450000000.0
  alterparam fq2 = 19450000000.0
  alterparam va1 = 0.00399052462993776
  alterparam va2 = 0.0
  reset
  save all @q.xdut.xq1.qnpn13g2[ic] @q.xdut.xq2.qnpn13g2[ic]
  tran 1e-12 6e-08 0 1e-12
  linearize v(p2) v(xdut.c1) v(xdut.e1) v(xdut.oc) v(xdut.b1) v(xdut.b2) @q.xdut.xq1.qnpn13g2[ic] @q.xdut.xq2.qnpn13g2[ic]
  let tt = time[40000,59999]
  let xo = v(p2)[40000,59999]
  let m_mid_b_one06_n = length(xo)
  let m_mid_b_one06_t0 = tt[0]
  let m_mid_b_one06_t1 = tt[19999]
  let m_mid_b_one06_f0_c = 2*mean(xo*cos(2*pi*19450000000.0*tt))
  let m_mid_b_one06_f0_s = 2*mean(xo*sin(2*pi*19450000000.0*tt))
  let m_mid_b_one06_fl_lo_c = 2*mean(xo*cos(2*pi*19400000000.0*tt))
  let m_mid_b_one06_fl_lo_s = 2*mean(xo*sin(2*pi*19400000000.0*tt))
  let m_mid_b_one06_fl_hi_c = 2*mean(xo*cos(2*pi*19500000000.0*tt))
  let m_mid_b_one06_fl_hi_s = 2*mean(xo*sin(2*pi*19500000000.0*tt))
  let m_mid_b_one06_vce_q1_max = maximum(v(xdut.c1)[40000,59999] - v(xdut.e1)[40000,59999])
  let m_mid_b_one06_vce_q1_min = minimum(v(xdut.c1)[40000,59999] - v(xdut.e1)[40000,59999])
  let m_mid_b_one06_vce_q2_max = maximum(v(xdut.oc)[40000,59999] - v(xdut.c1)[40000,59999])
  let m_mid_b_one06_vce_q2_min = minimum(v(xdut.oc)[40000,59999] - v(xdut.c1)[40000,59999])
  let m_mid_b_one06_vbe_q1_max = maximum(v(xdut.b1)[40000,59999] - v(xdut.e1)[40000,59999])
  let m_mid_b_one06_vbe_q1_min = minimum(v(xdut.b1)[40000,59999] - v(xdut.e1)[40000,59999])
  let m_mid_b_one06_vbe_q2_max = maximum(v(xdut.b2)[40000,59999] - v(xdut.c1)[40000,59999])
  let m_mid_b_one06_vbe_q2_min = minimum(v(xdut.b2)[40000,59999] - v(xdut.c1)[40000,59999])
  let w_mid_b_one06_ic_q1 = @q.xdut.xq1.qnpn13g2[ic][40000,59999]
  let m_mid_b_one06_ic_q1_max = maximum(w_mid_b_one06_ic_q1)
  let m_mid_b_one06_ic_q1_min = minimum(w_mid_b_one06_ic_q1)
  let w_mid_b_one06_ic_q2 = @q.xdut.xq2.qnpn13g2[ic][40000,59999]
  let m_mid_b_one06_ic_q2_max = maximum(w_mid_b_one06_ic_q2)
  let m_mid_b_one06_ic_q2_min = minimum(w_mid_b_one06_ic_q2)
  print m_mid_b_one06_n m_mid_b_one06_t0 m_mid_b_one06_t1 m_mid_b_one06_f0_c m_mid_b_one06_f0_s m_mid_b_one06_fl_lo_c
  print m_mid_b_one06_fl_lo_s m_mid_b_one06_fl_hi_c m_mid_b_one06_fl_hi_s m_mid_b_one06_vce_q1_max m_mid_b_one06_vce_q1_min m_mid_b_one06_vce_q2_max
  print m_mid_b_one06_vce_q2_min m_mid_b_one06_vbe_q1_max m_mid_b_one06_vbe_q1_min m_mid_b_one06_vbe_q2_max m_mid_b_one06_vbe_q2_min m_mid_b_one06_ic_q1_max
  print m_mid_b_one06_ic_q1_min m_mid_b_one06_ic_q2_max m_mid_b_one06_ic_q2_min
  * run mid_b_one07: one-tone, available power -42 dBm per tone
  alterparam fq1 = 19450000000.0
  alterparam fq2 = 19450000000.0
  alterparam va1 = 0.00502377286301916
  alterparam va2 = 0.0
  reset
  save all @q.xdut.xq1.qnpn13g2[ic] @q.xdut.xq2.qnpn13g2[ic]
  tran 1e-12 6e-08 0 1e-12
  linearize v(p2) v(xdut.c1) v(xdut.e1) v(xdut.oc) v(xdut.b1) v(xdut.b2) @q.xdut.xq1.qnpn13g2[ic] @q.xdut.xq2.qnpn13g2[ic]
  let tt = time[40000,59999]
  let xo = v(p2)[40000,59999]
  let m_mid_b_one07_n = length(xo)
  let m_mid_b_one07_t0 = tt[0]
  let m_mid_b_one07_t1 = tt[19999]
  let m_mid_b_one07_f0_c = 2*mean(xo*cos(2*pi*19450000000.0*tt))
  let m_mid_b_one07_f0_s = 2*mean(xo*sin(2*pi*19450000000.0*tt))
  let m_mid_b_one07_fl_lo_c = 2*mean(xo*cos(2*pi*19400000000.0*tt))
  let m_mid_b_one07_fl_lo_s = 2*mean(xo*sin(2*pi*19400000000.0*tt))
  let m_mid_b_one07_fl_hi_c = 2*mean(xo*cos(2*pi*19500000000.0*tt))
  let m_mid_b_one07_fl_hi_s = 2*mean(xo*sin(2*pi*19500000000.0*tt))
  let m_mid_b_one07_vce_q1_max = maximum(v(xdut.c1)[40000,59999] - v(xdut.e1)[40000,59999])
  let m_mid_b_one07_vce_q1_min = minimum(v(xdut.c1)[40000,59999] - v(xdut.e1)[40000,59999])
  let m_mid_b_one07_vce_q2_max = maximum(v(xdut.oc)[40000,59999] - v(xdut.c1)[40000,59999])
  let m_mid_b_one07_vce_q2_min = minimum(v(xdut.oc)[40000,59999] - v(xdut.c1)[40000,59999])
  let m_mid_b_one07_vbe_q1_max = maximum(v(xdut.b1)[40000,59999] - v(xdut.e1)[40000,59999])
  let m_mid_b_one07_vbe_q1_min = minimum(v(xdut.b1)[40000,59999] - v(xdut.e1)[40000,59999])
  let m_mid_b_one07_vbe_q2_max = maximum(v(xdut.b2)[40000,59999] - v(xdut.c1)[40000,59999])
  let m_mid_b_one07_vbe_q2_min = minimum(v(xdut.b2)[40000,59999] - v(xdut.c1)[40000,59999])
  let w_mid_b_one07_ic_q1 = @q.xdut.xq1.qnpn13g2[ic][40000,59999]
  let m_mid_b_one07_ic_q1_max = maximum(w_mid_b_one07_ic_q1)
  let m_mid_b_one07_ic_q1_min = minimum(w_mid_b_one07_ic_q1)
  let w_mid_b_one07_ic_q2 = @q.xdut.xq2.qnpn13g2[ic][40000,59999]
  let m_mid_b_one07_ic_q2_max = maximum(w_mid_b_one07_ic_q2)
  let m_mid_b_one07_ic_q2_min = minimum(w_mid_b_one07_ic_q2)
  print m_mid_b_one07_n m_mid_b_one07_t0 m_mid_b_one07_t1 m_mid_b_one07_f0_c m_mid_b_one07_f0_s m_mid_b_one07_fl_lo_c
  print m_mid_b_one07_fl_lo_s m_mid_b_one07_fl_hi_c m_mid_b_one07_fl_hi_s m_mid_b_one07_vce_q1_max m_mid_b_one07_vce_q1_min m_mid_b_one07_vce_q2_max
  print m_mid_b_one07_vce_q2_min m_mid_b_one07_vbe_q1_max m_mid_b_one07_vbe_q1_min m_mid_b_one07_vbe_q2_max m_mid_b_one07_vbe_q2_min m_mid_b_one07_ic_q1_max
  print m_mid_b_one07_ic_q1_min m_mid_b_one07_ic_q2_max m_mid_b_one07_ic_q2_min
  * run mid_b_one08: one-tone, available power -40 dBm per tone
  alterparam fq1 = 19450000000.0
  alterparam fq2 = 19450000000.0
  alterparam va1 = 0.00632455532033676
  alterparam va2 = 0.0
  reset
  save all @q.xdut.xq1.qnpn13g2[ic] @q.xdut.xq2.qnpn13g2[ic]
  tran 1e-12 6e-08 0 1e-12
  linearize v(p2) v(xdut.c1) v(xdut.e1) v(xdut.oc) v(xdut.b1) v(xdut.b2) @q.xdut.xq1.qnpn13g2[ic] @q.xdut.xq2.qnpn13g2[ic]
  let tt = time[40000,59999]
  let xo = v(p2)[40000,59999]
  let m_mid_b_one08_n = length(xo)
  let m_mid_b_one08_t0 = tt[0]
  let m_mid_b_one08_t1 = tt[19999]
  let m_mid_b_one08_f0_c = 2*mean(xo*cos(2*pi*19450000000.0*tt))
  let m_mid_b_one08_f0_s = 2*mean(xo*sin(2*pi*19450000000.0*tt))
  let m_mid_b_one08_fl_lo_c = 2*mean(xo*cos(2*pi*19400000000.0*tt))
  let m_mid_b_one08_fl_lo_s = 2*mean(xo*sin(2*pi*19400000000.0*tt))
  let m_mid_b_one08_fl_hi_c = 2*mean(xo*cos(2*pi*19500000000.0*tt))
  let m_mid_b_one08_fl_hi_s = 2*mean(xo*sin(2*pi*19500000000.0*tt))
  let m_mid_b_one08_vce_q1_max = maximum(v(xdut.c1)[40000,59999] - v(xdut.e1)[40000,59999])
  let m_mid_b_one08_vce_q1_min = minimum(v(xdut.c1)[40000,59999] - v(xdut.e1)[40000,59999])
  let m_mid_b_one08_vce_q2_max = maximum(v(xdut.oc)[40000,59999] - v(xdut.c1)[40000,59999])
  let m_mid_b_one08_vce_q2_min = minimum(v(xdut.oc)[40000,59999] - v(xdut.c1)[40000,59999])
  let m_mid_b_one08_vbe_q1_max = maximum(v(xdut.b1)[40000,59999] - v(xdut.e1)[40000,59999])
  let m_mid_b_one08_vbe_q1_min = minimum(v(xdut.b1)[40000,59999] - v(xdut.e1)[40000,59999])
  let m_mid_b_one08_vbe_q2_max = maximum(v(xdut.b2)[40000,59999] - v(xdut.c1)[40000,59999])
  let m_mid_b_one08_vbe_q2_min = minimum(v(xdut.b2)[40000,59999] - v(xdut.c1)[40000,59999])
  let w_mid_b_one08_ic_q1 = @q.xdut.xq1.qnpn13g2[ic][40000,59999]
  let m_mid_b_one08_ic_q1_max = maximum(w_mid_b_one08_ic_q1)
  let m_mid_b_one08_ic_q1_min = minimum(w_mid_b_one08_ic_q1)
  let w_mid_b_one08_ic_q2 = @q.xdut.xq2.qnpn13g2[ic][40000,59999]
  let m_mid_b_one08_ic_q2_max = maximum(w_mid_b_one08_ic_q2)
  let m_mid_b_one08_ic_q2_min = minimum(w_mid_b_one08_ic_q2)
  print m_mid_b_one08_n m_mid_b_one08_t0 m_mid_b_one08_t1 m_mid_b_one08_f0_c m_mid_b_one08_f0_s m_mid_b_one08_fl_lo_c
  print m_mid_b_one08_fl_lo_s m_mid_b_one08_fl_hi_c m_mid_b_one08_fl_hi_s m_mid_b_one08_vce_q1_max m_mid_b_one08_vce_q1_min m_mid_b_one08_vce_q2_max
  print m_mid_b_one08_vce_q2_min m_mid_b_one08_vbe_q1_max m_mid_b_one08_vbe_q1_min m_mid_b_one08_vbe_q2_max m_mid_b_one08_vbe_q2_min m_mid_b_one08_ic_q1_max
  print m_mid_b_one08_ic_q1_min m_mid_b_one08_ic_q2_max m_mid_b_one08_ic_q2_min
  * run mid_b_one09: one-tone, available power -38 dBm per tone
  alterparam fq1 = 19450000000.0
  alterparam fq2 = 19450000000.0
  alterparam va1 = 0.00796214341106995
  alterparam va2 = 0.0
  reset
  save all @q.xdut.xq1.qnpn13g2[ic] @q.xdut.xq2.qnpn13g2[ic]
  tran 1e-12 6e-08 0 1e-12
  linearize v(p2) v(xdut.c1) v(xdut.e1) v(xdut.oc) v(xdut.b1) v(xdut.b2) @q.xdut.xq1.qnpn13g2[ic] @q.xdut.xq2.qnpn13g2[ic]
  let tt = time[40000,59999]
  let xo = v(p2)[40000,59999]
  let m_mid_b_one09_n = length(xo)
  let m_mid_b_one09_t0 = tt[0]
  let m_mid_b_one09_t1 = tt[19999]
  let m_mid_b_one09_f0_c = 2*mean(xo*cos(2*pi*19450000000.0*tt))
  let m_mid_b_one09_f0_s = 2*mean(xo*sin(2*pi*19450000000.0*tt))
  let m_mid_b_one09_fl_lo_c = 2*mean(xo*cos(2*pi*19400000000.0*tt))
  let m_mid_b_one09_fl_lo_s = 2*mean(xo*sin(2*pi*19400000000.0*tt))
  let m_mid_b_one09_fl_hi_c = 2*mean(xo*cos(2*pi*19500000000.0*tt))
  let m_mid_b_one09_fl_hi_s = 2*mean(xo*sin(2*pi*19500000000.0*tt))
  let m_mid_b_one09_vce_q1_max = maximum(v(xdut.c1)[40000,59999] - v(xdut.e1)[40000,59999])
  let m_mid_b_one09_vce_q1_min = minimum(v(xdut.c1)[40000,59999] - v(xdut.e1)[40000,59999])
  let m_mid_b_one09_vce_q2_max = maximum(v(xdut.oc)[40000,59999] - v(xdut.c1)[40000,59999])
  let m_mid_b_one09_vce_q2_min = minimum(v(xdut.oc)[40000,59999] - v(xdut.c1)[40000,59999])
  let m_mid_b_one09_vbe_q1_max = maximum(v(xdut.b1)[40000,59999] - v(xdut.e1)[40000,59999])
  let m_mid_b_one09_vbe_q1_min = minimum(v(xdut.b1)[40000,59999] - v(xdut.e1)[40000,59999])
  let m_mid_b_one09_vbe_q2_max = maximum(v(xdut.b2)[40000,59999] - v(xdut.c1)[40000,59999])
  let m_mid_b_one09_vbe_q2_min = minimum(v(xdut.b2)[40000,59999] - v(xdut.c1)[40000,59999])
  let w_mid_b_one09_ic_q1 = @q.xdut.xq1.qnpn13g2[ic][40000,59999]
  let m_mid_b_one09_ic_q1_max = maximum(w_mid_b_one09_ic_q1)
  let m_mid_b_one09_ic_q1_min = minimum(w_mid_b_one09_ic_q1)
  let w_mid_b_one09_ic_q2 = @q.xdut.xq2.qnpn13g2[ic][40000,59999]
  let m_mid_b_one09_ic_q2_max = maximum(w_mid_b_one09_ic_q2)
  let m_mid_b_one09_ic_q2_min = minimum(w_mid_b_one09_ic_q2)
  print m_mid_b_one09_n m_mid_b_one09_t0 m_mid_b_one09_t1 m_mid_b_one09_f0_c m_mid_b_one09_f0_s m_mid_b_one09_fl_lo_c
  print m_mid_b_one09_fl_lo_s m_mid_b_one09_fl_hi_c m_mid_b_one09_fl_hi_s m_mid_b_one09_vce_q1_max m_mid_b_one09_vce_q1_min m_mid_b_one09_vce_q2_max
  print m_mid_b_one09_vce_q2_min m_mid_b_one09_vbe_q1_max m_mid_b_one09_vbe_q1_min m_mid_b_one09_vbe_q2_max m_mid_b_one09_vbe_q2_min m_mid_b_one09_ic_q1_max
  print m_mid_b_one09_ic_q1_min m_mid_b_one09_ic_q2_max m_mid_b_one09_ic_q2_min
  * run mid_b_one10: one-tone, available power -36 dBm per tone
  alterparam fq1 = 19450000000.0
  alterparam fq2 = 19450000000.0
  alterparam va1 = 0.0100237446725454
  alterparam va2 = 0.0
  reset
  save all @q.xdut.xq1.qnpn13g2[ic] @q.xdut.xq2.qnpn13g2[ic]
  tran 1e-12 6e-08 0 1e-12
  linearize v(p2) v(xdut.c1) v(xdut.e1) v(xdut.oc) v(xdut.b1) v(xdut.b2) @q.xdut.xq1.qnpn13g2[ic] @q.xdut.xq2.qnpn13g2[ic]
  let tt = time[40000,59999]
  let xo = v(p2)[40000,59999]
  let m_mid_b_one10_n = length(xo)
  let m_mid_b_one10_t0 = tt[0]
  let m_mid_b_one10_t1 = tt[19999]
  let m_mid_b_one10_f0_c = 2*mean(xo*cos(2*pi*19450000000.0*tt))
  let m_mid_b_one10_f0_s = 2*mean(xo*sin(2*pi*19450000000.0*tt))
  let m_mid_b_one10_fl_lo_c = 2*mean(xo*cos(2*pi*19400000000.0*tt))
  let m_mid_b_one10_fl_lo_s = 2*mean(xo*sin(2*pi*19400000000.0*tt))
  let m_mid_b_one10_fl_hi_c = 2*mean(xo*cos(2*pi*19500000000.0*tt))
  let m_mid_b_one10_fl_hi_s = 2*mean(xo*sin(2*pi*19500000000.0*tt))
  let m_mid_b_one10_vce_q1_max = maximum(v(xdut.c1)[40000,59999] - v(xdut.e1)[40000,59999])
  let m_mid_b_one10_vce_q1_min = minimum(v(xdut.c1)[40000,59999] - v(xdut.e1)[40000,59999])
  let m_mid_b_one10_vce_q2_max = maximum(v(xdut.oc)[40000,59999] - v(xdut.c1)[40000,59999])
  let m_mid_b_one10_vce_q2_min = minimum(v(xdut.oc)[40000,59999] - v(xdut.c1)[40000,59999])
  let m_mid_b_one10_vbe_q1_max = maximum(v(xdut.b1)[40000,59999] - v(xdut.e1)[40000,59999])
  let m_mid_b_one10_vbe_q1_min = minimum(v(xdut.b1)[40000,59999] - v(xdut.e1)[40000,59999])
  let m_mid_b_one10_vbe_q2_max = maximum(v(xdut.b2)[40000,59999] - v(xdut.c1)[40000,59999])
  let m_mid_b_one10_vbe_q2_min = minimum(v(xdut.b2)[40000,59999] - v(xdut.c1)[40000,59999])
  let w_mid_b_one10_ic_q1 = @q.xdut.xq1.qnpn13g2[ic][40000,59999]
  let m_mid_b_one10_ic_q1_max = maximum(w_mid_b_one10_ic_q1)
  let m_mid_b_one10_ic_q1_min = minimum(w_mid_b_one10_ic_q1)
  let w_mid_b_one10_ic_q2 = @q.xdut.xq2.qnpn13g2[ic][40000,59999]
  let m_mid_b_one10_ic_q2_max = maximum(w_mid_b_one10_ic_q2)
  let m_mid_b_one10_ic_q2_min = minimum(w_mid_b_one10_ic_q2)
  print m_mid_b_one10_n m_mid_b_one10_t0 m_mid_b_one10_t1 m_mid_b_one10_f0_c m_mid_b_one10_f0_s m_mid_b_one10_fl_lo_c
  print m_mid_b_one10_fl_lo_s m_mid_b_one10_fl_hi_c m_mid_b_one10_fl_hi_s m_mid_b_one10_vce_q1_max m_mid_b_one10_vce_q1_min m_mid_b_one10_vce_q2_max
  print m_mid_b_one10_vce_q2_min m_mid_b_one10_vbe_q1_max m_mid_b_one10_vbe_q1_min m_mid_b_one10_vbe_q2_max m_mid_b_one10_vbe_q2_min m_mid_b_one10_ic_q1_max
  print m_mid_b_one10_ic_q1_min m_mid_b_one10_ic_q2_max m_mid_b_one10_ic_q2_min
  * run mid_b_one11: one-tone, available power -34 dBm per tone
  alterparam fq1 = 19450000000.0
  alterparam fq2 = 19450000000.0
  alterparam va1 = 0.0126191468896039
  alterparam va2 = 0.0
  reset
  save all @q.xdut.xq1.qnpn13g2[ic] @q.xdut.xq2.qnpn13g2[ic]
  tran 1e-12 6e-08 0 1e-12
  linearize v(p2) v(xdut.c1) v(xdut.e1) v(xdut.oc) v(xdut.b1) v(xdut.b2) @q.xdut.xq1.qnpn13g2[ic] @q.xdut.xq2.qnpn13g2[ic]
  let tt = time[40000,59999]
  let xo = v(p2)[40000,59999]
  let m_mid_b_one11_n = length(xo)
  let m_mid_b_one11_t0 = tt[0]
  let m_mid_b_one11_t1 = tt[19999]
  let m_mid_b_one11_f0_c = 2*mean(xo*cos(2*pi*19450000000.0*tt))
  let m_mid_b_one11_f0_s = 2*mean(xo*sin(2*pi*19450000000.0*tt))
  let m_mid_b_one11_fl_lo_c = 2*mean(xo*cos(2*pi*19400000000.0*tt))
  let m_mid_b_one11_fl_lo_s = 2*mean(xo*sin(2*pi*19400000000.0*tt))
  let m_mid_b_one11_fl_hi_c = 2*mean(xo*cos(2*pi*19500000000.0*tt))
  let m_mid_b_one11_fl_hi_s = 2*mean(xo*sin(2*pi*19500000000.0*tt))
  let m_mid_b_one11_vce_q1_max = maximum(v(xdut.c1)[40000,59999] - v(xdut.e1)[40000,59999])
  let m_mid_b_one11_vce_q1_min = minimum(v(xdut.c1)[40000,59999] - v(xdut.e1)[40000,59999])
  let m_mid_b_one11_vce_q2_max = maximum(v(xdut.oc)[40000,59999] - v(xdut.c1)[40000,59999])
  let m_mid_b_one11_vce_q2_min = minimum(v(xdut.oc)[40000,59999] - v(xdut.c1)[40000,59999])
  let m_mid_b_one11_vbe_q1_max = maximum(v(xdut.b1)[40000,59999] - v(xdut.e1)[40000,59999])
  let m_mid_b_one11_vbe_q1_min = minimum(v(xdut.b1)[40000,59999] - v(xdut.e1)[40000,59999])
  let m_mid_b_one11_vbe_q2_max = maximum(v(xdut.b2)[40000,59999] - v(xdut.c1)[40000,59999])
  let m_mid_b_one11_vbe_q2_min = minimum(v(xdut.b2)[40000,59999] - v(xdut.c1)[40000,59999])
  let w_mid_b_one11_ic_q1 = @q.xdut.xq1.qnpn13g2[ic][40000,59999]
  let m_mid_b_one11_ic_q1_max = maximum(w_mid_b_one11_ic_q1)
  let m_mid_b_one11_ic_q1_min = minimum(w_mid_b_one11_ic_q1)
  let w_mid_b_one11_ic_q2 = @q.xdut.xq2.qnpn13g2[ic][40000,59999]
  let m_mid_b_one11_ic_q2_max = maximum(w_mid_b_one11_ic_q2)
  let m_mid_b_one11_ic_q2_min = minimum(w_mid_b_one11_ic_q2)
  print m_mid_b_one11_n m_mid_b_one11_t0 m_mid_b_one11_t1 m_mid_b_one11_f0_c m_mid_b_one11_f0_s m_mid_b_one11_fl_lo_c
  print m_mid_b_one11_fl_lo_s m_mid_b_one11_fl_hi_c m_mid_b_one11_fl_hi_s m_mid_b_one11_vce_q1_max m_mid_b_one11_vce_q1_min m_mid_b_one11_vce_q2_max
  print m_mid_b_one11_vce_q2_min m_mid_b_one11_vbe_q1_max m_mid_b_one11_vbe_q1_min m_mid_b_one11_vbe_q2_max m_mid_b_one11_vbe_q2_min m_mid_b_one11_ic_q1_max
  print m_mid_b_one11_ic_q1_min m_mid_b_one11_ic_q2_max m_mid_b_one11_ic_q2_min
  * run mid_b_one12: one-tone, available power -32 dBm per tone
  alterparam fq1 = 19450000000.0
  alterparam fq2 = 19450000000.0
  alterparam va1 = 0.0158865646944856
  alterparam va2 = 0.0
  reset
  save all @q.xdut.xq1.qnpn13g2[ic] @q.xdut.xq2.qnpn13g2[ic]
  tran 1e-12 6e-08 0 1e-12
  linearize v(p2) v(xdut.c1) v(xdut.e1) v(xdut.oc) v(xdut.b1) v(xdut.b2) @q.xdut.xq1.qnpn13g2[ic] @q.xdut.xq2.qnpn13g2[ic]
  let tt = time[40000,59999]
  let xo = v(p2)[40000,59999]
  let m_mid_b_one12_n = length(xo)
  let m_mid_b_one12_t0 = tt[0]
  let m_mid_b_one12_t1 = tt[19999]
  let m_mid_b_one12_f0_c = 2*mean(xo*cos(2*pi*19450000000.0*tt))
  let m_mid_b_one12_f0_s = 2*mean(xo*sin(2*pi*19450000000.0*tt))
  let m_mid_b_one12_fl_lo_c = 2*mean(xo*cos(2*pi*19400000000.0*tt))
  let m_mid_b_one12_fl_lo_s = 2*mean(xo*sin(2*pi*19400000000.0*tt))
  let m_mid_b_one12_fl_hi_c = 2*mean(xo*cos(2*pi*19500000000.0*tt))
  let m_mid_b_one12_fl_hi_s = 2*mean(xo*sin(2*pi*19500000000.0*tt))
  let m_mid_b_one12_vce_q1_max = maximum(v(xdut.c1)[40000,59999] - v(xdut.e1)[40000,59999])
  let m_mid_b_one12_vce_q1_min = minimum(v(xdut.c1)[40000,59999] - v(xdut.e1)[40000,59999])
  let m_mid_b_one12_vce_q2_max = maximum(v(xdut.oc)[40000,59999] - v(xdut.c1)[40000,59999])
  let m_mid_b_one12_vce_q2_min = minimum(v(xdut.oc)[40000,59999] - v(xdut.c1)[40000,59999])
  let m_mid_b_one12_vbe_q1_max = maximum(v(xdut.b1)[40000,59999] - v(xdut.e1)[40000,59999])
  let m_mid_b_one12_vbe_q1_min = minimum(v(xdut.b1)[40000,59999] - v(xdut.e1)[40000,59999])
  let m_mid_b_one12_vbe_q2_max = maximum(v(xdut.b2)[40000,59999] - v(xdut.c1)[40000,59999])
  let m_mid_b_one12_vbe_q2_min = minimum(v(xdut.b2)[40000,59999] - v(xdut.c1)[40000,59999])
  let w_mid_b_one12_ic_q1 = @q.xdut.xq1.qnpn13g2[ic][40000,59999]
  let m_mid_b_one12_ic_q1_max = maximum(w_mid_b_one12_ic_q1)
  let m_mid_b_one12_ic_q1_min = minimum(w_mid_b_one12_ic_q1)
  let w_mid_b_one12_ic_q2 = @q.xdut.xq2.qnpn13g2[ic][40000,59999]
  let m_mid_b_one12_ic_q2_max = maximum(w_mid_b_one12_ic_q2)
  let m_mid_b_one12_ic_q2_min = minimum(w_mid_b_one12_ic_q2)
  print m_mid_b_one12_n m_mid_b_one12_t0 m_mid_b_one12_t1 m_mid_b_one12_f0_c m_mid_b_one12_f0_s m_mid_b_one12_fl_lo_c
  print m_mid_b_one12_fl_lo_s m_mid_b_one12_fl_hi_c m_mid_b_one12_fl_hi_s m_mid_b_one12_vce_q1_max m_mid_b_one12_vce_q1_min m_mid_b_one12_vce_q2_max
  print m_mid_b_one12_vce_q2_min m_mid_b_one12_vbe_q1_max m_mid_b_one12_vbe_q1_min m_mid_b_one12_vbe_q2_max m_mid_b_one12_vbe_q2_min m_mid_b_one12_ic_q1_max
  print m_mid_b_one12_ic_q1_min m_mid_b_one12_ic_q2_max m_mid_b_one12_ic_q2_min
  * run mid_b_one13: one-tone, available power -30 dBm per tone
  alterparam fq1 = 19450000000.0
  alterparam fq2 = 19450000000.0
  alterparam va1 = 0.02
  alterparam va2 = 0.0
  reset
  save all @q.xdut.xq1.qnpn13g2[ic] @q.xdut.xq2.qnpn13g2[ic]
  tran 1e-12 6e-08 0 1e-12
  linearize v(p2) v(xdut.c1) v(xdut.e1) v(xdut.oc) v(xdut.b1) v(xdut.b2) @q.xdut.xq1.qnpn13g2[ic] @q.xdut.xq2.qnpn13g2[ic]
  let tt = time[40000,59999]
  let xo = v(p2)[40000,59999]
  let m_mid_b_one13_n = length(xo)
  let m_mid_b_one13_t0 = tt[0]
  let m_mid_b_one13_t1 = tt[19999]
  let m_mid_b_one13_f0_c = 2*mean(xo*cos(2*pi*19450000000.0*tt))
  let m_mid_b_one13_f0_s = 2*mean(xo*sin(2*pi*19450000000.0*tt))
  let m_mid_b_one13_fl_lo_c = 2*mean(xo*cos(2*pi*19400000000.0*tt))
  let m_mid_b_one13_fl_lo_s = 2*mean(xo*sin(2*pi*19400000000.0*tt))
  let m_mid_b_one13_fl_hi_c = 2*mean(xo*cos(2*pi*19500000000.0*tt))
  let m_mid_b_one13_fl_hi_s = 2*mean(xo*sin(2*pi*19500000000.0*tt))
  let m_mid_b_one13_vce_q1_max = maximum(v(xdut.c1)[40000,59999] - v(xdut.e1)[40000,59999])
  let m_mid_b_one13_vce_q1_min = minimum(v(xdut.c1)[40000,59999] - v(xdut.e1)[40000,59999])
  let m_mid_b_one13_vce_q2_max = maximum(v(xdut.oc)[40000,59999] - v(xdut.c1)[40000,59999])
  let m_mid_b_one13_vce_q2_min = minimum(v(xdut.oc)[40000,59999] - v(xdut.c1)[40000,59999])
  let m_mid_b_one13_vbe_q1_max = maximum(v(xdut.b1)[40000,59999] - v(xdut.e1)[40000,59999])
  let m_mid_b_one13_vbe_q1_min = minimum(v(xdut.b1)[40000,59999] - v(xdut.e1)[40000,59999])
  let m_mid_b_one13_vbe_q2_max = maximum(v(xdut.b2)[40000,59999] - v(xdut.c1)[40000,59999])
  let m_mid_b_one13_vbe_q2_min = minimum(v(xdut.b2)[40000,59999] - v(xdut.c1)[40000,59999])
  let w_mid_b_one13_ic_q1 = @q.xdut.xq1.qnpn13g2[ic][40000,59999]
  let m_mid_b_one13_ic_q1_max = maximum(w_mid_b_one13_ic_q1)
  let m_mid_b_one13_ic_q1_min = minimum(w_mid_b_one13_ic_q1)
  let w_mid_b_one13_ic_q2 = @q.xdut.xq2.qnpn13g2[ic][40000,59999]
  let m_mid_b_one13_ic_q2_max = maximum(w_mid_b_one13_ic_q2)
  let m_mid_b_one13_ic_q2_min = minimum(w_mid_b_one13_ic_q2)
  print m_mid_b_one13_n m_mid_b_one13_t0 m_mid_b_one13_t1 m_mid_b_one13_f0_c m_mid_b_one13_f0_s m_mid_b_one13_fl_lo_c
  print m_mid_b_one13_fl_lo_s m_mid_b_one13_fl_hi_c m_mid_b_one13_fl_hi_s m_mid_b_one13_vce_q1_max m_mid_b_one13_vce_q1_min m_mid_b_one13_vce_q2_max
  print m_mid_b_one13_vce_q2_min m_mid_b_one13_vbe_q1_max m_mid_b_one13_vbe_q1_min m_mid_b_one13_vbe_q2_max m_mid_b_one13_vbe_q2_min m_mid_b_one13_ic_q1_max
  print m_mid_b_one13_ic_q1_min m_mid_b_one13_ic_q2_max m_mid_b_one13_ic_q2_min
  * run mid_b_one14: one-tone, available power -28 dBm per tone
  alterparam fq1 = 19450000000.0
  alterparam fq2 = 19450000000.0
  alterparam va1 = 0.0251785082358833
  alterparam va2 = 0.0
  reset
  save all @q.xdut.xq1.qnpn13g2[ic] @q.xdut.xq2.qnpn13g2[ic]
  tran 1e-12 6e-08 0 1e-12
  linearize v(p2) v(xdut.c1) v(xdut.e1) v(xdut.oc) v(xdut.b1) v(xdut.b2) @q.xdut.xq1.qnpn13g2[ic] @q.xdut.xq2.qnpn13g2[ic]
  let tt = time[40000,59999]
  let xo = v(p2)[40000,59999]
  let m_mid_b_one14_n = length(xo)
  let m_mid_b_one14_t0 = tt[0]
  let m_mid_b_one14_t1 = tt[19999]
  let m_mid_b_one14_f0_c = 2*mean(xo*cos(2*pi*19450000000.0*tt))
  let m_mid_b_one14_f0_s = 2*mean(xo*sin(2*pi*19450000000.0*tt))
  let m_mid_b_one14_fl_lo_c = 2*mean(xo*cos(2*pi*19400000000.0*tt))
  let m_mid_b_one14_fl_lo_s = 2*mean(xo*sin(2*pi*19400000000.0*tt))
  let m_mid_b_one14_fl_hi_c = 2*mean(xo*cos(2*pi*19500000000.0*tt))
  let m_mid_b_one14_fl_hi_s = 2*mean(xo*sin(2*pi*19500000000.0*tt))
  let m_mid_b_one14_vce_q1_max = maximum(v(xdut.c1)[40000,59999] - v(xdut.e1)[40000,59999])
  let m_mid_b_one14_vce_q1_min = minimum(v(xdut.c1)[40000,59999] - v(xdut.e1)[40000,59999])
  let m_mid_b_one14_vce_q2_max = maximum(v(xdut.oc)[40000,59999] - v(xdut.c1)[40000,59999])
  let m_mid_b_one14_vce_q2_min = minimum(v(xdut.oc)[40000,59999] - v(xdut.c1)[40000,59999])
  let m_mid_b_one14_vbe_q1_max = maximum(v(xdut.b1)[40000,59999] - v(xdut.e1)[40000,59999])
  let m_mid_b_one14_vbe_q1_min = minimum(v(xdut.b1)[40000,59999] - v(xdut.e1)[40000,59999])
  let m_mid_b_one14_vbe_q2_max = maximum(v(xdut.b2)[40000,59999] - v(xdut.c1)[40000,59999])
  let m_mid_b_one14_vbe_q2_min = minimum(v(xdut.b2)[40000,59999] - v(xdut.c1)[40000,59999])
  let w_mid_b_one14_ic_q1 = @q.xdut.xq1.qnpn13g2[ic][40000,59999]
  let m_mid_b_one14_ic_q1_max = maximum(w_mid_b_one14_ic_q1)
  let m_mid_b_one14_ic_q1_min = minimum(w_mid_b_one14_ic_q1)
  let w_mid_b_one14_ic_q2 = @q.xdut.xq2.qnpn13g2[ic][40000,59999]
  let m_mid_b_one14_ic_q2_max = maximum(w_mid_b_one14_ic_q2)
  let m_mid_b_one14_ic_q2_min = minimum(w_mid_b_one14_ic_q2)
  print m_mid_b_one14_n m_mid_b_one14_t0 m_mid_b_one14_t1 m_mid_b_one14_f0_c m_mid_b_one14_f0_s m_mid_b_one14_fl_lo_c
  print m_mid_b_one14_fl_lo_s m_mid_b_one14_fl_hi_c m_mid_b_one14_fl_hi_s m_mid_b_one14_vce_q1_max m_mid_b_one14_vce_q1_min m_mid_b_one14_vce_q2_max
  print m_mid_b_one14_vce_q2_min m_mid_b_one14_vbe_q1_max m_mid_b_one14_vbe_q1_min m_mid_b_one14_vbe_q2_max m_mid_b_one14_vbe_q2_min m_mid_b_one14_ic_q1_max
  print m_mid_b_one14_ic_q1_min m_mid_b_one14_ic_q2_max m_mid_b_one14_ic_q2_min
  * run mid_b_one15: one-tone, available power -26 dBm per tone
  alterparam fq1 = 19450000000.0
  alterparam fq2 = 19450000000.0
  alterparam va1 = 0.0316978638492223
  alterparam va2 = 0.0
  reset
  save all @q.xdut.xq1.qnpn13g2[ic] @q.xdut.xq2.qnpn13g2[ic]
  tran 1e-12 6e-08 0 1e-12
  linearize v(p2) v(xdut.c1) v(xdut.e1) v(xdut.oc) v(xdut.b1) v(xdut.b2) @q.xdut.xq1.qnpn13g2[ic] @q.xdut.xq2.qnpn13g2[ic]
  let tt = time[40000,59999]
  let xo = v(p2)[40000,59999]
  let m_mid_b_one15_n = length(xo)
  let m_mid_b_one15_t0 = tt[0]
  let m_mid_b_one15_t1 = tt[19999]
  let m_mid_b_one15_f0_c = 2*mean(xo*cos(2*pi*19450000000.0*tt))
  let m_mid_b_one15_f0_s = 2*mean(xo*sin(2*pi*19450000000.0*tt))
  let m_mid_b_one15_fl_lo_c = 2*mean(xo*cos(2*pi*19400000000.0*tt))
  let m_mid_b_one15_fl_lo_s = 2*mean(xo*sin(2*pi*19400000000.0*tt))
  let m_mid_b_one15_fl_hi_c = 2*mean(xo*cos(2*pi*19500000000.0*tt))
  let m_mid_b_one15_fl_hi_s = 2*mean(xo*sin(2*pi*19500000000.0*tt))
  let m_mid_b_one15_vce_q1_max = maximum(v(xdut.c1)[40000,59999] - v(xdut.e1)[40000,59999])
  let m_mid_b_one15_vce_q1_min = minimum(v(xdut.c1)[40000,59999] - v(xdut.e1)[40000,59999])
  let m_mid_b_one15_vce_q2_max = maximum(v(xdut.oc)[40000,59999] - v(xdut.c1)[40000,59999])
  let m_mid_b_one15_vce_q2_min = minimum(v(xdut.oc)[40000,59999] - v(xdut.c1)[40000,59999])
  let m_mid_b_one15_vbe_q1_max = maximum(v(xdut.b1)[40000,59999] - v(xdut.e1)[40000,59999])
  let m_mid_b_one15_vbe_q1_min = minimum(v(xdut.b1)[40000,59999] - v(xdut.e1)[40000,59999])
  let m_mid_b_one15_vbe_q2_max = maximum(v(xdut.b2)[40000,59999] - v(xdut.c1)[40000,59999])
  let m_mid_b_one15_vbe_q2_min = minimum(v(xdut.b2)[40000,59999] - v(xdut.c1)[40000,59999])
  let w_mid_b_one15_ic_q1 = @q.xdut.xq1.qnpn13g2[ic][40000,59999]
  let m_mid_b_one15_ic_q1_max = maximum(w_mid_b_one15_ic_q1)
  let m_mid_b_one15_ic_q1_min = minimum(w_mid_b_one15_ic_q1)
  let w_mid_b_one15_ic_q2 = @q.xdut.xq2.qnpn13g2[ic][40000,59999]
  let m_mid_b_one15_ic_q2_max = maximum(w_mid_b_one15_ic_q2)
  let m_mid_b_one15_ic_q2_min = minimum(w_mid_b_one15_ic_q2)
  print m_mid_b_one15_n m_mid_b_one15_t0 m_mid_b_one15_t1 m_mid_b_one15_f0_c m_mid_b_one15_f0_s m_mid_b_one15_fl_lo_c
  print m_mid_b_one15_fl_lo_s m_mid_b_one15_fl_hi_c m_mid_b_one15_fl_hi_s m_mid_b_one15_vce_q1_max m_mid_b_one15_vce_q1_min m_mid_b_one15_vce_q2_max
  print m_mid_b_one15_vce_q2_min m_mid_b_one15_vbe_q1_max m_mid_b_one15_vbe_q1_min m_mid_b_one15_vbe_q2_max m_mid_b_one15_vbe_q2_min m_mid_b_one15_ic_q1_max
  print m_mid_b_one15_ic_q1_min m_mid_b_one15_ic_q2_max m_mid_b_one15_ic_q2_min
  * run mid_b_one16: one-tone, available power -24 dBm per tone
  alterparam fq1 = 19450000000.0
  alterparam fq2 = 19450000000.0
  alterparam va1 = 0.0399052462993776
  alterparam va2 = 0.0
  reset
  save all @q.xdut.xq1.qnpn13g2[ic] @q.xdut.xq2.qnpn13g2[ic]
  tran 1e-12 6e-08 0 1e-12
  linearize v(p2) v(xdut.c1) v(xdut.e1) v(xdut.oc) v(xdut.b1) v(xdut.b2) @q.xdut.xq1.qnpn13g2[ic] @q.xdut.xq2.qnpn13g2[ic]
  let tt = time[40000,59999]
  let xo = v(p2)[40000,59999]
  let m_mid_b_one16_n = length(xo)
  let m_mid_b_one16_t0 = tt[0]
  let m_mid_b_one16_t1 = tt[19999]
  let m_mid_b_one16_f0_c = 2*mean(xo*cos(2*pi*19450000000.0*tt))
  let m_mid_b_one16_f0_s = 2*mean(xo*sin(2*pi*19450000000.0*tt))
  let m_mid_b_one16_fl_lo_c = 2*mean(xo*cos(2*pi*19400000000.0*tt))
  let m_mid_b_one16_fl_lo_s = 2*mean(xo*sin(2*pi*19400000000.0*tt))
  let m_mid_b_one16_fl_hi_c = 2*mean(xo*cos(2*pi*19500000000.0*tt))
  let m_mid_b_one16_fl_hi_s = 2*mean(xo*sin(2*pi*19500000000.0*tt))
  let m_mid_b_one16_vce_q1_max = maximum(v(xdut.c1)[40000,59999] - v(xdut.e1)[40000,59999])
  let m_mid_b_one16_vce_q1_min = minimum(v(xdut.c1)[40000,59999] - v(xdut.e1)[40000,59999])
  let m_mid_b_one16_vce_q2_max = maximum(v(xdut.oc)[40000,59999] - v(xdut.c1)[40000,59999])
  let m_mid_b_one16_vce_q2_min = minimum(v(xdut.oc)[40000,59999] - v(xdut.c1)[40000,59999])
  let m_mid_b_one16_vbe_q1_max = maximum(v(xdut.b1)[40000,59999] - v(xdut.e1)[40000,59999])
  let m_mid_b_one16_vbe_q1_min = minimum(v(xdut.b1)[40000,59999] - v(xdut.e1)[40000,59999])
  let m_mid_b_one16_vbe_q2_max = maximum(v(xdut.b2)[40000,59999] - v(xdut.c1)[40000,59999])
  let m_mid_b_one16_vbe_q2_min = minimum(v(xdut.b2)[40000,59999] - v(xdut.c1)[40000,59999])
  let w_mid_b_one16_ic_q1 = @q.xdut.xq1.qnpn13g2[ic][40000,59999]
  let m_mid_b_one16_ic_q1_max = maximum(w_mid_b_one16_ic_q1)
  let m_mid_b_one16_ic_q1_min = minimum(w_mid_b_one16_ic_q1)
  let w_mid_b_one16_ic_q2 = @q.xdut.xq2.qnpn13g2[ic][40000,59999]
  let m_mid_b_one16_ic_q2_max = maximum(w_mid_b_one16_ic_q2)
  let m_mid_b_one16_ic_q2_min = minimum(w_mid_b_one16_ic_q2)
  print m_mid_b_one16_n m_mid_b_one16_t0 m_mid_b_one16_t1 m_mid_b_one16_f0_c m_mid_b_one16_f0_s m_mid_b_one16_fl_lo_c
  print m_mid_b_one16_fl_lo_s m_mid_b_one16_fl_hi_c m_mid_b_one16_fl_hi_s m_mid_b_one16_vce_q1_max m_mid_b_one16_vce_q1_min m_mid_b_one16_vce_q2_max
  print m_mid_b_one16_vce_q2_min m_mid_b_one16_vbe_q1_max m_mid_b_one16_vbe_q1_min m_mid_b_one16_vbe_q2_max m_mid_b_one16_vbe_q2_min m_mid_b_one16_ic_q1_max
  print m_mid_b_one16_ic_q1_min m_mid_b_one16_ic_q2_max m_mid_b_one16_ic_q2_min
  * run mid_b_one17: one-tone, available power -22 dBm per tone
  alterparam fq1 = 19450000000.0
  alterparam fq2 = 19450000000.0
  alterparam va1 = 0.0502377286301916
  alterparam va2 = 0.0
  reset
  save all @q.xdut.xq1.qnpn13g2[ic] @q.xdut.xq2.qnpn13g2[ic]
  tran 1e-12 6e-08 0 1e-12
  linearize v(p2) v(xdut.c1) v(xdut.e1) v(xdut.oc) v(xdut.b1) v(xdut.b2) @q.xdut.xq1.qnpn13g2[ic] @q.xdut.xq2.qnpn13g2[ic]
  let tt = time[40000,59999]
  let xo = v(p2)[40000,59999]
  let m_mid_b_one17_n = length(xo)
  let m_mid_b_one17_t0 = tt[0]
  let m_mid_b_one17_t1 = tt[19999]
  let m_mid_b_one17_f0_c = 2*mean(xo*cos(2*pi*19450000000.0*tt))
  let m_mid_b_one17_f0_s = 2*mean(xo*sin(2*pi*19450000000.0*tt))
  let m_mid_b_one17_fl_lo_c = 2*mean(xo*cos(2*pi*19400000000.0*tt))
  let m_mid_b_one17_fl_lo_s = 2*mean(xo*sin(2*pi*19400000000.0*tt))
  let m_mid_b_one17_fl_hi_c = 2*mean(xo*cos(2*pi*19500000000.0*tt))
  let m_mid_b_one17_fl_hi_s = 2*mean(xo*sin(2*pi*19500000000.0*tt))
  let m_mid_b_one17_vce_q1_max = maximum(v(xdut.c1)[40000,59999] - v(xdut.e1)[40000,59999])
  let m_mid_b_one17_vce_q1_min = minimum(v(xdut.c1)[40000,59999] - v(xdut.e1)[40000,59999])
  let m_mid_b_one17_vce_q2_max = maximum(v(xdut.oc)[40000,59999] - v(xdut.c1)[40000,59999])
  let m_mid_b_one17_vce_q2_min = minimum(v(xdut.oc)[40000,59999] - v(xdut.c1)[40000,59999])
  let m_mid_b_one17_vbe_q1_max = maximum(v(xdut.b1)[40000,59999] - v(xdut.e1)[40000,59999])
  let m_mid_b_one17_vbe_q1_min = minimum(v(xdut.b1)[40000,59999] - v(xdut.e1)[40000,59999])
  let m_mid_b_one17_vbe_q2_max = maximum(v(xdut.b2)[40000,59999] - v(xdut.c1)[40000,59999])
  let m_mid_b_one17_vbe_q2_min = minimum(v(xdut.b2)[40000,59999] - v(xdut.c1)[40000,59999])
  let w_mid_b_one17_ic_q1 = @q.xdut.xq1.qnpn13g2[ic][40000,59999]
  let m_mid_b_one17_ic_q1_max = maximum(w_mid_b_one17_ic_q1)
  let m_mid_b_one17_ic_q1_min = minimum(w_mid_b_one17_ic_q1)
  let w_mid_b_one17_ic_q2 = @q.xdut.xq2.qnpn13g2[ic][40000,59999]
  let m_mid_b_one17_ic_q2_max = maximum(w_mid_b_one17_ic_q2)
  let m_mid_b_one17_ic_q2_min = minimum(w_mid_b_one17_ic_q2)
  print m_mid_b_one17_n m_mid_b_one17_t0 m_mid_b_one17_t1 m_mid_b_one17_f0_c m_mid_b_one17_f0_s m_mid_b_one17_fl_lo_c
  print m_mid_b_one17_fl_lo_s m_mid_b_one17_fl_hi_c m_mid_b_one17_fl_hi_s m_mid_b_one17_vce_q1_max m_mid_b_one17_vce_q1_min m_mid_b_one17_vce_q2_max
  print m_mid_b_one17_vce_q2_min m_mid_b_one17_vbe_q1_max m_mid_b_one17_vbe_q1_min m_mid_b_one17_vbe_q2_max m_mid_b_one17_vbe_q2_min m_mid_b_one17_ic_q1_max
  print m_mid_b_one17_ic_q1_min m_mid_b_one17_ic_q2_max m_mid_b_one17_ic_q2_min
  * run mid_b_one18: one-tone, available power -20 dBm per tone
  alterparam fq1 = 19450000000.0
  alterparam fq2 = 19450000000.0
  alterparam va1 = 0.0632455532033676
  alterparam va2 = 0.0
  reset
  save all @q.xdut.xq1.qnpn13g2[ic] @q.xdut.xq2.qnpn13g2[ic]
  tran 1e-12 6e-08 0 1e-12
  linearize v(p2) v(xdut.c1) v(xdut.e1) v(xdut.oc) v(xdut.b1) v(xdut.b2) @q.xdut.xq1.qnpn13g2[ic] @q.xdut.xq2.qnpn13g2[ic]
  let tt = time[40000,59999]
  let xo = v(p2)[40000,59999]
  let m_mid_b_one18_n = length(xo)
  let m_mid_b_one18_t0 = tt[0]
  let m_mid_b_one18_t1 = tt[19999]
  let m_mid_b_one18_f0_c = 2*mean(xo*cos(2*pi*19450000000.0*tt))
  let m_mid_b_one18_f0_s = 2*mean(xo*sin(2*pi*19450000000.0*tt))
  let m_mid_b_one18_fl_lo_c = 2*mean(xo*cos(2*pi*19400000000.0*tt))
  let m_mid_b_one18_fl_lo_s = 2*mean(xo*sin(2*pi*19400000000.0*tt))
  let m_mid_b_one18_fl_hi_c = 2*mean(xo*cos(2*pi*19500000000.0*tt))
  let m_mid_b_one18_fl_hi_s = 2*mean(xo*sin(2*pi*19500000000.0*tt))
  let m_mid_b_one18_vce_q1_max = maximum(v(xdut.c1)[40000,59999] - v(xdut.e1)[40000,59999])
  let m_mid_b_one18_vce_q1_min = minimum(v(xdut.c1)[40000,59999] - v(xdut.e1)[40000,59999])
  let m_mid_b_one18_vce_q2_max = maximum(v(xdut.oc)[40000,59999] - v(xdut.c1)[40000,59999])
  let m_mid_b_one18_vce_q2_min = minimum(v(xdut.oc)[40000,59999] - v(xdut.c1)[40000,59999])
  let m_mid_b_one18_vbe_q1_max = maximum(v(xdut.b1)[40000,59999] - v(xdut.e1)[40000,59999])
  let m_mid_b_one18_vbe_q1_min = minimum(v(xdut.b1)[40000,59999] - v(xdut.e1)[40000,59999])
  let m_mid_b_one18_vbe_q2_max = maximum(v(xdut.b2)[40000,59999] - v(xdut.c1)[40000,59999])
  let m_mid_b_one18_vbe_q2_min = minimum(v(xdut.b2)[40000,59999] - v(xdut.c1)[40000,59999])
  let w_mid_b_one18_ic_q1 = @q.xdut.xq1.qnpn13g2[ic][40000,59999]
  let m_mid_b_one18_ic_q1_max = maximum(w_mid_b_one18_ic_q1)
  let m_mid_b_one18_ic_q1_min = minimum(w_mid_b_one18_ic_q1)
  let w_mid_b_one18_ic_q2 = @q.xdut.xq2.qnpn13g2[ic][40000,59999]
  let m_mid_b_one18_ic_q2_max = maximum(w_mid_b_one18_ic_q2)
  let m_mid_b_one18_ic_q2_min = minimum(w_mid_b_one18_ic_q2)
  print m_mid_b_one18_n m_mid_b_one18_t0 m_mid_b_one18_t1 m_mid_b_one18_f0_c m_mid_b_one18_f0_s m_mid_b_one18_fl_lo_c
  print m_mid_b_one18_fl_lo_s m_mid_b_one18_fl_hi_c m_mid_b_one18_fl_hi_s m_mid_b_one18_vce_q1_max m_mid_b_one18_vce_q1_min m_mid_b_one18_vce_q2_max
  print m_mid_b_one18_vce_q2_min m_mid_b_one18_vbe_q1_max m_mid_b_one18_vbe_q1_min m_mid_b_one18_vbe_q2_max m_mid_b_one18_vbe_q2_min m_mid_b_one18_ic_q1_max
  print m_mid_b_one18_ic_q1_min m_mid_b_one18_ic_q2_max m_mid_b_one18_ic_q2_min
  * run mid_b_one19: one-tone, available power -18 dBm per tone
  alterparam fq1 = 19450000000.0
  alterparam fq2 = 19450000000.0
  alterparam va1 = 0.0796214341106995
  alterparam va2 = 0.0
  reset
  save all @q.xdut.xq1.qnpn13g2[ic] @q.xdut.xq2.qnpn13g2[ic]
  tran 1e-12 6e-08 0 1e-12
  linearize v(p2) v(xdut.c1) v(xdut.e1) v(xdut.oc) v(xdut.b1) v(xdut.b2) @q.xdut.xq1.qnpn13g2[ic] @q.xdut.xq2.qnpn13g2[ic]
  let tt = time[40000,59999]
  let xo = v(p2)[40000,59999]
  let m_mid_b_one19_n = length(xo)
  let m_mid_b_one19_t0 = tt[0]
  let m_mid_b_one19_t1 = tt[19999]
  let m_mid_b_one19_f0_c = 2*mean(xo*cos(2*pi*19450000000.0*tt))
  let m_mid_b_one19_f0_s = 2*mean(xo*sin(2*pi*19450000000.0*tt))
  let m_mid_b_one19_fl_lo_c = 2*mean(xo*cos(2*pi*19400000000.0*tt))
  let m_mid_b_one19_fl_lo_s = 2*mean(xo*sin(2*pi*19400000000.0*tt))
  let m_mid_b_one19_fl_hi_c = 2*mean(xo*cos(2*pi*19500000000.0*tt))
  let m_mid_b_one19_fl_hi_s = 2*mean(xo*sin(2*pi*19500000000.0*tt))
  let m_mid_b_one19_vce_q1_max = maximum(v(xdut.c1)[40000,59999] - v(xdut.e1)[40000,59999])
  let m_mid_b_one19_vce_q1_min = minimum(v(xdut.c1)[40000,59999] - v(xdut.e1)[40000,59999])
  let m_mid_b_one19_vce_q2_max = maximum(v(xdut.oc)[40000,59999] - v(xdut.c1)[40000,59999])
  let m_mid_b_one19_vce_q2_min = minimum(v(xdut.oc)[40000,59999] - v(xdut.c1)[40000,59999])
  let m_mid_b_one19_vbe_q1_max = maximum(v(xdut.b1)[40000,59999] - v(xdut.e1)[40000,59999])
  let m_mid_b_one19_vbe_q1_min = minimum(v(xdut.b1)[40000,59999] - v(xdut.e1)[40000,59999])
  let m_mid_b_one19_vbe_q2_max = maximum(v(xdut.b2)[40000,59999] - v(xdut.c1)[40000,59999])
  let m_mid_b_one19_vbe_q2_min = minimum(v(xdut.b2)[40000,59999] - v(xdut.c1)[40000,59999])
  let w_mid_b_one19_ic_q1 = @q.xdut.xq1.qnpn13g2[ic][40000,59999]
  let m_mid_b_one19_ic_q1_max = maximum(w_mid_b_one19_ic_q1)
  let m_mid_b_one19_ic_q1_min = minimum(w_mid_b_one19_ic_q1)
  let w_mid_b_one19_ic_q2 = @q.xdut.xq2.qnpn13g2[ic][40000,59999]
  let m_mid_b_one19_ic_q2_max = maximum(w_mid_b_one19_ic_q2)
  let m_mid_b_one19_ic_q2_min = minimum(w_mid_b_one19_ic_q2)
  print m_mid_b_one19_n m_mid_b_one19_t0 m_mid_b_one19_t1 m_mid_b_one19_f0_c m_mid_b_one19_f0_s m_mid_b_one19_fl_lo_c
  print m_mid_b_one19_fl_lo_s m_mid_b_one19_fl_hi_c m_mid_b_one19_fl_hi_s m_mid_b_one19_vce_q1_max m_mid_b_one19_vce_q1_min m_mid_b_one19_vce_q2_max
  print m_mid_b_one19_vce_q2_min m_mid_b_one19_vbe_q1_max m_mid_b_one19_vbe_q1_min m_mid_b_one19_vbe_q2_max m_mid_b_one19_vbe_q2_min m_mid_b_one19_ic_q1_max
  print m_mid_b_one19_ic_q1_min m_mid_b_one19_ic_q2_max m_mid_b_one19_ic_q2_min
  * run mid_b_one20: one-tone, available power -16 dBm per tone
  alterparam fq1 = 19450000000.0
  alterparam fq2 = 19450000000.0
  alterparam va1 = 0.100237446725454
  alterparam va2 = 0.0
  reset
  save all @q.xdut.xq1.qnpn13g2[ic] @q.xdut.xq2.qnpn13g2[ic]
  tran 1e-12 6e-08 0 1e-12
  linearize v(p2) v(xdut.c1) v(xdut.e1) v(xdut.oc) v(xdut.b1) v(xdut.b2) @q.xdut.xq1.qnpn13g2[ic] @q.xdut.xq2.qnpn13g2[ic]
  let tt = time[40000,59999]
  let xo = v(p2)[40000,59999]
  let m_mid_b_one20_n = length(xo)
  let m_mid_b_one20_t0 = tt[0]
  let m_mid_b_one20_t1 = tt[19999]
  let m_mid_b_one20_f0_c = 2*mean(xo*cos(2*pi*19450000000.0*tt))
  let m_mid_b_one20_f0_s = 2*mean(xo*sin(2*pi*19450000000.0*tt))
  let m_mid_b_one20_fl_lo_c = 2*mean(xo*cos(2*pi*19400000000.0*tt))
  let m_mid_b_one20_fl_lo_s = 2*mean(xo*sin(2*pi*19400000000.0*tt))
  let m_mid_b_one20_fl_hi_c = 2*mean(xo*cos(2*pi*19500000000.0*tt))
  let m_mid_b_one20_fl_hi_s = 2*mean(xo*sin(2*pi*19500000000.0*tt))
  let m_mid_b_one20_vce_q1_max = maximum(v(xdut.c1)[40000,59999] - v(xdut.e1)[40000,59999])
  let m_mid_b_one20_vce_q1_min = minimum(v(xdut.c1)[40000,59999] - v(xdut.e1)[40000,59999])
  let m_mid_b_one20_vce_q2_max = maximum(v(xdut.oc)[40000,59999] - v(xdut.c1)[40000,59999])
  let m_mid_b_one20_vce_q2_min = minimum(v(xdut.oc)[40000,59999] - v(xdut.c1)[40000,59999])
  let m_mid_b_one20_vbe_q1_max = maximum(v(xdut.b1)[40000,59999] - v(xdut.e1)[40000,59999])
  let m_mid_b_one20_vbe_q1_min = minimum(v(xdut.b1)[40000,59999] - v(xdut.e1)[40000,59999])
  let m_mid_b_one20_vbe_q2_max = maximum(v(xdut.b2)[40000,59999] - v(xdut.c1)[40000,59999])
  let m_mid_b_one20_vbe_q2_min = minimum(v(xdut.b2)[40000,59999] - v(xdut.c1)[40000,59999])
  let w_mid_b_one20_ic_q1 = @q.xdut.xq1.qnpn13g2[ic][40000,59999]
  let m_mid_b_one20_ic_q1_max = maximum(w_mid_b_one20_ic_q1)
  let m_mid_b_one20_ic_q1_min = minimum(w_mid_b_one20_ic_q1)
  let w_mid_b_one20_ic_q2 = @q.xdut.xq2.qnpn13g2[ic][40000,59999]
  let m_mid_b_one20_ic_q2_max = maximum(w_mid_b_one20_ic_q2)
  let m_mid_b_one20_ic_q2_min = minimum(w_mid_b_one20_ic_q2)
  print m_mid_b_one20_n m_mid_b_one20_t0 m_mid_b_one20_t1 m_mid_b_one20_f0_c m_mid_b_one20_f0_s m_mid_b_one20_fl_lo_c
  print m_mid_b_one20_fl_lo_s m_mid_b_one20_fl_hi_c m_mid_b_one20_fl_hi_s m_mid_b_one20_vce_q1_max m_mid_b_one20_vce_q1_min m_mid_b_one20_vce_q2_max
  print m_mid_b_one20_vce_q2_min m_mid_b_one20_vbe_q1_max m_mid_b_one20_vbe_q1_min m_mid_b_one20_vbe_q2_max m_mid_b_one20_vbe_q2_min m_mid_b_one20_ic_q1_max
  print m_mid_b_one20_ic_q1_min m_mid_b_one20_ic_q2_max m_mid_b_one20_ic_q2_min
  * run high_b_one00: one-tone, available power -56 dBm per tone
  alterparam fq1 = 20950000000.0
  alterparam fq2 = 20950000000.0
  alterparam va1 = 0.00100237446725455
  alterparam va2 = 0.0
  reset
  save all @q.xdut.xq1.qnpn13g2[ic] @q.xdut.xq2.qnpn13g2[ic]
  tran 1e-12 6e-08 0 1e-12
  linearize v(p2) v(xdut.c1) v(xdut.e1) v(xdut.oc) v(xdut.b1) v(xdut.b2) @q.xdut.xq1.qnpn13g2[ic] @q.xdut.xq2.qnpn13g2[ic]
  let tt = time[40000,59999]
  let xo = v(p2)[40000,59999]
  let m_high_b_one00_n = length(xo)
  let m_high_b_one00_t0 = tt[0]
  let m_high_b_one00_t1 = tt[19999]
  let m_high_b_one00_f0_c = 2*mean(xo*cos(2*pi*20950000000.0*tt))
  let m_high_b_one00_f0_s = 2*mean(xo*sin(2*pi*20950000000.0*tt))
  let m_high_b_one00_fl_lo_c = 2*mean(xo*cos(2*pi*20900000000.0*tt))
  let m_high_b_one00_fl_lo_s = 2*mean(xo*sin(2*pi*20900000000.0*tt))
  let m_high_b_one00_fl_hi_c = 2*mean(xo*cos(2*pi*21000000000.0*tt))
  let m_high_b_one00_fl_hi_s = 2*mean(xo*sin(2*pi*21000000000.0*tt))
  let m_high_b_one00_vce_q1_max = maximum(v(xdut.c1)[40000,59999] - v(xdut.e1)[40000,59999])
  let m_high_b_one00_vce_q1_min = minimum(v(xdut.c1)[40000,59999] - v(xdut.e1)[40000,59999])
  let m_high_b_one00_vce_q2_max = maximum(v(xdut.oc)[40000,59999] - v(xdut.c1)[40000,59999])
  let m_high_b_one00_vce_q2_min = minimum(v(xdut.oc)[40000,59999] - v(xdut.c1)[40000,59999])
  let m_high_b_one00_vbe_q1_max = maximum(v(xdut.b1)[40000,59999] - v(xdut.e1)[40000,59999])
  let m_high_b_one00_vbe_q1_min = minimum(v(xdut.b1)[40000,59999] - v(xdut.e1)[40000,59999])
  let m_high_b_one00_vbe_q2_max = maximum(v(xdut.b2)[40000,59999] - v(xdut.c1)[40000,59999])
  let m_high_b_one00_vbe_q2_min = minimum(v(xdut.b2)[40000,59999] - v(xdut.c1)[40000,59999])
  let w_high_b_one00_ic_q1 = @q.xdut.xq1.qnpn13g2[ic][40000,59999]
  let m_high_b_one00_ic_q1_max = maximum(w_high_b_one00_ic_q1)
  let m_high_b_one00_ic_q1_min = minimum(w_high_b_one00_ic_q1)
  let w_high_b_one00_ic_q2 = @q.xdut.xq2.qnpn13g2[ic][40000,59999]
  let m_high_b_one00_ic_q2_max = maximum(w_high_b_one00_ic_q2)
  let m_high_b_one00_ic_q2_min = minimum(w_high_b_one00_ic_q2)
  print m_high_b_one00_n m_high_b_one00_t0 m_high_b_one00_t1 m_high_b_one00_f0_c m_high_b_one00_f0_s m_high_b_one00_fl_lo_c
  print m_high_b_one00_fl_lo_s m_high_b_one00_fl_hi_c m_high_b_one00_fl_hi_s m_high_b_one00_vce_q1_max m_high_b_one00_vce_q1_min m_high_b_one00_vce_q2_max
  print m_high_b_one00_vce_q2_min m_high_b_one00_vbe_q1_max m_high_b_one00_vbe_q1_min m_high_b_one00_vbe_q2_max m_high_b_one00_vbe_q2_min m_high_b_one00_ic_q1_max
  print m_high_b_one00_ic_q1_min m_high_b_one00_ic_q2_max m_high_b_one00_ic_q2_min
  * run high_b_one01: one-tone, available power -54 dBm per tone
  alterparam fq1 = 20950000000.0
  alterparam fq2 = 20950000000.0
  alterparam va1 = 0.00126191468896039
  alterparam va2 = 0.0
  reset
  save all @q.xdut.xq1.qnpn13g2[ic] @q.xdut.xq2.qnpn13g2[ic]
  tran 1e-12 6e-08 0 1e-12
  linearize v(p2) v(xdut.c1) v(xdut.e1) v(xdut.oc) v(xdut.b1) v(xdut.b2) @q.xdut.xq1.qnpn13g2[ic] @q.xdut.xq2.qnpn13g2[ic]
  let tt = time[40000,59999]
  let xo = v(p2)[40000,59999]
  let m_high_b_one01_n = length(xo)
  let m_high_b_one01_t0 = tt[0]
  let m_high_b_one01_t1 = tt[19999]
  let m_high_b_one01_f0_c = 2*mean(xo*cos(2*pi*20950000000.0*tt))
  let m_high_b_one01_f0_s = 2*mean(xo*sin(2*pi*20950000000.0*tt))
  let m_high_b_one01_fl_lo_c = 2*mean(xo*cos(2*pi*20900000000.0*tt))
  let m_high_b_one01_fl_lo_s = 2*mean(xo*sin(2*pi*20900000000.0*tt))
  let m_high_b_one01_fl_hi_c = 2*mean(xo*cos(2*pi*21000000000.0*tt))
  let m_high_b_one01_fl_hi_s = 2*mean(xo*sin(2*pi*21000000000.0*tt))
  let m_high_b_one01_vce_q1_max = maximum(v(xdut.c1)[40000,59999] - v(xdut.e1)[40000,59999])
  let m_high_b_one01_vce_q1_min = minimum(v(xdut.c1)[40000,59999] - v(xdut.e1)[40000,59999])
  let m_high_b_one01_vce_q2_max = maximum(v(xdut.oc)[40000,59999] - v(xdut.c1)[40000,59999])
  let m_high_b_one01_vce_q2_min = minimum(v(xdut.oc)[40000,59999] - v(xdut.c1)[40000,59999])
  let m_high_b_one01_vbe_q1_max = maximum(v(xdut.b1)[40000,59999] - v(xdut.e1)[40000,59999])
  let m_high_b_one01_vbe_q1_min = minimum(v(xdut.b1)[40000,59999] - v(xdut.e1)[40000,59999])
  let m_high_b_one01_vbe_q2_max = maximum(v(xdut.b2)[40000,59999] - v(xdut.c1)[40000,59999])
  let m_high_b_one01_vbe_q2_min = minimum(v(xdut.b2)[40000,59999] - v(xdut.c1)[40000,59999])
  let w_high_b_one01_ic_q1 = @q.xdut.xq1.qnpn13g2[ic][40000,59999]
  let m_high_b_one01_ic_q1_max = maximum(w_high_b_one01_ic_q1)
  let m_high_b_one01_ic_q1_min = minimum(w_high_b_one01_ic_q1)
  let w_high_b_one01_ic_q2 = @q.xdut.xq2.qnpn13g2[ic][40000,59999]
  let m_high_b_one01_ic_q2_max = maximum(w_high_b_one01_ic_q2)
  let m_high_b_one01_ic_q2_min = minimum(w_high_b_one01_ic_q2)
  print m_high_b_one01_n m_high_b_one01_t0 m_high_b_one01_t1 m_high_b_one01_f0_c m_high_b_one01_f0_s m_high_b_one01_fl_lo_c
  print m_high_b_one01_fl_lo_s m_high_b_one01_fl_hi_c m_high_b_one01_fl_hi_s m_high_b_one01_vce_q1_max m_high_b_one01_vce_q1_min m_high_b_one01_vce_q2_max
  print m_high_b_one01_vce_q2_min m_high_b_one01_vbe_q1_max m_high_b_one01_vbe_q1_min m_high_b_one01_vbe_q2_max m_high_b_one01_vbe_q2_min m_high_b_one01_ic_q1_max
  print m_high_b_one01_ic_q1_min m_high_b_one01_ic_q2_max m_high_b_one01_ic_q2_min
  * run high_b_one02: one-tone, available power -52 dBm per tone
  alterparam fq1 = 20950000000.0
  alterparam fq2 = 20950000000.0
  alterparam va1 = 0.00158865646944856
  alterparam va2 = 0.0
  reset
  save all @q.xdut.xq1.qnpn13g2[ic] @q.xdut.xq2.qnpn13g2[ic]
  tran 1e-12 6e-08 0 1e-12
  linearize v(p2) v(xdut.c1) v(xdut.e1) v(xdut.oc) v(xdut.b1) v(xdut.b2) @q.xdut.xq1.qnpn13g2[ic] @q.xdut.xq2.qnpn13g2[ic]
  let tt = time[40000,59999]
  let xo = v(p2)[40000,59999]
  let m_high_b_one02_n = length(xo)
  let m_high_b_one02_t0 = tt[0]
  let m_high_b_one02_t1 = tt[19999]
  let m_high_b_one02_f0_c = 2*mean(xo*cos(2*pi*20950000000.0*tt))
  let m_high_b_one02_f0_s = 2*mean(xo*sin(2*pi*20950000000.0*tt))
  let m_high_b_one02_fl_lo_c = 2*mean(xo*cos(2*pi*20900000000.0*tt))
  let m_high_b_one02_fl_lo_s = 2*mean(xo*sin(2*pi*20900000000.0*tt))
  let m_high_b_one02_fl_hi_c = 2*mean(xo*cos(2*pi*21000000000.0*tt))
  let m_high_b_one02_fl_hi_s = 2*mean(xo*sin(2*pi*21000000000.0*tt))
  let m_high_b_one02_vce_q1_max = maximum(v(xdut.c1)[40000,59999] - v(xdut.e1)[40000,59999])
  let m_high_b_one02_vce_q1_min = minimum(v(xdut.c1)[40000,59999] - v(xdut.e1)[40000,59999])
  let m_high_b_one02_vce_q2_max = maximum(v(xdut.oc)[40000,59999] - v(xdut.c1)[40000,59999])
  let m_high_b_one02_vce_q2_min = minimum(v(xdut.oc)[40000,59999] - v(xdut.c1)[40000,59999])
  let m_high_b_one02_vbe_q1_max = maximum(v(xdut.b1)[40000,59999] - v(xdut.e1)[40000,59999])
  let m_high_b_one02_vbe_q1_min = minimum(v(xdut.b1)[40000,59999] - v(xdut.e1)[40000,59999])
  let m_high_b_one02_vbe_q2_max = maximum(v(xdut.b2)[40000,59999] - v(xdut.c1)[40000,59999])
  let m_high_b_one02_vbe_q2_min = minimum(v(xdut.b2)[40000,59999] - v(xdut.c1)[40000,59999])
  let w_high_b_one02_ic_q1 = @q.xdut.xq1.qnpn13g2[ic][40000,59999]
  let m_high_b_one02_ic_q1_max = maximum(w_high_b_one02_ic_q1)
  let m_high_b_one02_ic_q1_min = minimum(w_high_b_one02_ic_q1)
  let w_high_b_one02_ic_q2 = @q.xdut.xq2.qnpn13g2[ic][40000,59999]
  let m_high_b_one02_ic_q2_max = maximum(w_high_b_one02_ic_q2)
  let m_high_b_one02_ic_q2_min = minimum(w_high_b_one02_ic_q2)
  print m_high_b_one02_n m_high_b_one02_t0 m_high_b_one02_t1 m_high_b_one02_f0_c m_high_b_one02_f0_s m_high_b_one02_fl_lo_c
  print m_high_b_one02_fl_lo_s m_high_b_one02_fl_hi_c m_high_b_one02_fl_hi_s m_high_b_one02_vce_q1_max m_high_b_one02_vce_q1_min m_high_b_one02_vce_q2_max
  print m_high_b_one02_vce_q2_min m_high_b_one02_vbe_q1_max m_high_b_one02_vbe_q1_min m_high_b_one02_vbe_q2_max m_high_b_one02_vbe_q2_min m_high_b_one02_ic_q1_max
  print m_high_b_one02_ic_q1_min m_high_b_one02_ic_q2_max m_high_b_one02_ic_q2_min
  * run high_b_one03: one-tone, available power -50 dBm per tone
  alterparam fq1 = 20950000000.0
  alterparam fq2 = 20950000000.0
  alterparam va1 = 0.002
  alterparam va2 = 0.0
  reset
  save all @q.xdut.xq1.qnpn13g2[ic] @q.xdut.xq2.qnpn13g2[ic]
  tran 1e-12 6e-08 0 1e-12
  linearize v(p2) v(xdut.c1) v(xdut.e1) v(xdut.oc) v(xdut.b1) v(xdut.b2) @q.xdut.xq1.qnpn13g2[ic] @q.xdut.xq2.qnpn13g2[ic]
  let tt = time[40000,59999]
  let xo = v(p2)[40000,59999]
  let m_high_b_one03_n = length(xo)
  let m_high_b_one03_t0 = tt[0]
  let m_high_b_one03_t1 = tt[19999]
  let m_high_b_one03_f0_c = 2*mean(xo*cos(2*pi*20950000000.0*tt))
  let m_high_b_one03_f0_s = 2*mean(xo*sin(2*pi*20950000000.0*tt))
  let m_high_b_one03_fl_lo_c = 2*mean(xo*cos(2*pi*20900000000.0*tt))
  let m_high_b_one03_fl_lo_s = 2*mean(xo*sin(2*pi*20900000000.0*tt))
  let m_high_b_one03_fl_hi_c = 2*mean(xo*cos(2*pi*21000000000.0*tt))
  let m_high_b_one03_fl_hi_s = 2*mean(xo*sin(2*pi*21000000000.0*tt))
  let m_high_b_one03_vce_q1_max = maximum(v(xdut.c1)[40000,59999] - v(xdut.e1)[40000,59999])
  let m_high_b_one03_vce_q1_min = minimum(v(xdut.c1)[40000,59999] - v(xdut.e1)[40000,59999])
  let m_high_b_one03_vce_q2_max = maximum(v(xdut.oc)[40000,59999] - v(xdut.c1)[40000,59999])
  let m_high_b_one03_vce_q2_min = minimum(v(xdut.oc)[40000,59999] - v(xdut.c1)[40000,59999])
  let m_high_b_one03_vbe_q1_max = maximum(v(xdut.b1)[40000,59999] - v(xdut.e1)[40000,59999])
  let m_high_b_one03_vbe_q1_min = minimum(v(xdut.b1)[40000,59999] - v(xdut.e1)[40000,59999])
  let m_high_b_one03_vbe_q2_max = maximum(v(xdut.b2)[40000,59999] - v(xdut.c1)[40000,59999])
  let m_high_b_one03_vbe_q2_min = minimum(v(xdut.b2)[40000,59999] - v(xdut.c1)[40000,59999])
  let w_high_b_one03_ic_q1 = @q.xdut.xq1.qnpn13g2[ic][40000,59999]
  let m_high_b_one03_ic_q1_max = maximum(w_high_b_one03_ic_q1)
  let m_high_b_one03_ic_q1_min = minimum(w_high_b_one03_ic_q1)
  let w_high_b_one03_ic_q2 = @q.xdut.xq2.qnpn13g2[ic][40000,59999]
  let m_high_b_one03_ic_q2_max = maximum(w_high_b_one03_ic_q2)
  let m_high_b_one03_ic_q2_min = minimum(w_high_b_one03_ic_q2)
  print m_high_b_one03_n m_high_b_one03_t0 m_high_b_one03_t1 m_high_b_one03_f0_c m_high_b_one03_f0_s m_high_b_one03_fl_lo_c
  print m_high_b_one03_fl_lo_s m_high_b_one03_fl_hi_c m_high_b_one03_fl_hi_s m_high_b_one03_vce_q1_max m_high_b_one03_vce_q1_min m_high_b_one03_vce_q2_max
  print m_high_b_one03_vce_q2_min m_high_b_one03_vbe_q1_max m_high_b_one03_vbe_q1_min m_high_b_one03_vbe_q2_max m_high_b_one03_vbe_q2_min m_high_b_one03_ic_q1_max
  print m_high_b_one03_ic_q1_min m_high_b_one03_ic_q2_max m_high_b_one03_ic_q2_min
  * run high_b_one04: one-tone, available power -48 dBm per tone
  alterparam fq1 = 20950000000.0
  alterparam fq2 = 20950000000.0
  alterparam va1 = 0.00251785082358833
  alterparam va2 = 0.0
  reset
  save all @q.xdut.xq1.qnpn13g2[ic] @q.xdut.xq2.qnpn13g2[ic]
  tran 1e-12 6e-08 0 1e-12
  linearize v(p2) v(xdut.c1) v(xdut.e1) v(xdut.oc) v(xdut.b1) v(xdut.b2) @q.xdut.xq1.qnpn13g2[ic] @q.xdut.xq2.qnpn13g2[ic]
  let tt = time[40000,59999]
  let xo = v(p2)[40000,59999]
  let m_high_b_one04_n = length(xo)
  let m_high_b_one04_t0 = tt[0]
  let m_high_b_one04_t1 = tt[19999]
  let m_high_b_one04_f0_c = 2*mean(xo*cos(2*pi*20950000000.0*tt))
  let m_high_b_one04_f0_s = 2*mean(xo*sin(2*pi*20950000000.0*tt))
  let m_high_b_one04_fl_lo_c = 2*mean(xo*cos(2*pi*20900000000.0*tt))
  let m_high_b_one04_fl_lo_s = 2*mean(xo*sin(2*pi*20900000000.0*tt))
  let m_high_b_one04_fl_hi_c = 2*mean(xo*cos(2*pi*21000000000.0*tt))
  let m_high_b_one04_fl_hi_s = 2*mean(xo*sin(2*pi*21000000000.0*tt))
  let m_high_b_one04_vce_q1_max = maximum(v(xdut.c1)[40000,59999] - v(xdut.e1)[40000,59999])
  let m_high_b_one04_vce_q1_min = minimum(v(xdut.c1)[40000,59999] - v(xdut.e1)[40000,59999])
  let m_high_b_one04_vce_q2_max = maximum(v(xdut.oc)[40000,59999] - v(xdut.c1)[40000,59999])
  let m_high_b_one04_vce_q2_min = minimum(v(xdut.oc)[40000,59999] - v(xdut.c1)[40000,59999])
  let m_high_b_one04_vbe_q1_max = maximum(v(xdut.b1)[40000,59999] - v(xdut.e1)[40000,59999])
  let m_high_b_one04_vbe_q1_min = minimum(v(xdut.b1)[40000,59999] - v(xdut.e1)[40000,59999])
  let m_high_b_one04_vbe_q2_max = maximum(v(xdut.b2)[40000,59999] - v(xdut.c1)[40000,59999])
  let m_high_b_one04_vbe_q2_min = minimum(v(xdut.b2)[40000,59999] - v(xdut.c1)[40000,59999])
  let w_high_b_one04_ic_q1 = @q.xdut.xq1.qnpn13g2[ic][40000,59999]
  let m_high_b_one04_ic_q1_max = maximum(w_high_b_one04_ic_q1)
  let m_high_b_one04_ic_q1_min = minimum(w_high_b_one04_ic_q1)
  let w_high_b_one04_ic_q2 = @q.xdut.xq2.qnpn13g2[ic][40000,59999]
  let m_high_b_one04_ic_q2_max = maximum(w_high_b_one04_ic_q2)
  let m_high_b_one04_ic_q2_min = minimum(w_high_b_one04_ic_q2)
  print m_high_b_one04_n m_high_b_one04_t0 m_high_b_one04_t1 m_high_b_one04_f0_c m_high_b_one04_f0_s m_high_b_one04_fl_lo_c
  print m_high_b_one04_fl_lo_s m_high_b_one04_fl_hi_c m_high_b_one04_fl_hi_s m_high_b_one04_vce_q1_max m_high_b_one04_vce_q1_min m_high_b_one04_vce_q2_max
  print m_high_b_one04_vce_q2_min m_high_b_one04_vbe_q1_max m_high_b_one04_vbe_q1_min m_high_b_one04_vbe_q2_max m_high_b_one04_vbe_q2_min m_high_b_one04_ic_q1_max
  print m_high_b_one04_ic_q1_min m_high_b_one04_ic_q2_max m_high_b_one04_ic_q2_min
  * run high_b_one05: one-tone, available power -46 dBm per tone
  alterparam fq1 = 20950000000.0
  alterparam fq2 = 20950000000.0
  alterparam va1 = 0.00316978638492223
  alterparam va2 = 0.0
  reset
  save all @q.xdut.xq1.qnpn13g2[ic] @q.xdut.xq2.qnpn13g2[ic]
  tran 1e-12 6e-08 0 1e-12
  linearize v(p2) v(xdut.c1) v(xdut.e1) v(xdut.oc) v(xdut.b1) v(xdut.b2) @q.xdut.xq1.qnpn13g2[ic] @q.xdut.xq2.qnpn13g2[ic]
  let tt = time[40000,59999]
  let xo = v(p2)[40000,59999]
  let m_high_b_one05_n = length(xo)
  let m_high_b_one05_t0 = tt[0]
  let m_high_b_one05_t1 = tt[19999]
  let m_high_b_one05_f0_c = 2*mean(xo*cos(2*pi*20950000000.0*tt))
  let m_high_b_one05_f0_s = 2*mean(xo*sin(2*pi*20950000000.0*tt))
  let m_high_b_one05_fl_lo_c = 2*mean(xo*cos(2*pi*20900000000.0*tt))
  let m_high_b_one05_fl_lo_s = 2*mean(xo*sin(2*pi*20900000000.0*tt))
  let m_high_b_one05_fl_hi_c = 2*mean(xo*cos(2*pi*21000000000.0*tt))
  let m_high_b_one05_fl_hi_s = 2*mean(xo*sin(2*pi*21000000000.0*tt))
  let m_high_b_one05_vce_q1_max = maximum(v(xdut.c1)[40000,59999] - v(xdut.e1)[40000,59999])
  let m_high_b_one05_vce_q1_min = minimum(v(xdut.c1)[40000,59999] - v(xdut.e1)[40000,59999])
  let m_high_b_one05_vce_q2_max = maximum(v(xdut.oc)[40000,59999] - v(xdut.c1)[40000,59999])
  let m_high_b_one05_vce_q2_min = minimum(v(xdut.oc)[40000,59999] - v(xdut.c1)[40000,59999])
  let m_high_b_one05_vbe_q1_max = maximum(v(xdut.b1)[40000,59999] - v(xdut.e1)[40000,59999])
  let m_high_b_one05_vbe_q1_min = minimum(v(xdut.b1)[40000,59999] - v(xdut.e1)[40000,59999])
  let m_high_b_one05_vbe_q2_max = maximum(v(xdut.b2)[40000,59999] - v(xdut.c1)[40000,59999])
  let m_high_b_one05_vbe_q2_min = minimum(v(xdut.b2)[40000,59999] - v(xdut.c1)[40000,59999])
  let w_high_b_one05_ic_q1 = @q.xdut.xq1.qnpn13g2[ic][40000,59999]
  let m_high_b_one05_ic_q1_max = maximum(w_high_b_one05_ic_q1)
  let m_high_b_one05_ic_q1_min = minimum(w_high_b_one05_ic_q1)
  let w_high_b_one05_ic_q2 = @q.xdut.xq2.qnpn13g2[ic][40000,59999]
  let m_high_b_one05_ic_q2_max = maximum(w_high_b_one05_ic_q2)
  let m_high_b_one05_ic_q2_min = minimum(w_high_b_one05_ic_q2)
  print m_high_b_one05_n m_high_b_one05_t0 m_high_b_one05_t1 m_high_b_one05_f0_c m_high_b_one05_f0_s m_high_b_one05_fl_lo_c
  print m_high_b_one05_fl_lo_s m_high_b_one05_fl_hi_c m_high_b_one05_fl_hi_s m_high_b_one05_vce_q1_max m_high_b_one05_vce_q1_min m_high_b_one05_vce_q2_max
  print m_high_b_one05_vce_q2_min m_high_b_one05_vbe_q1_max m_high_b_one05_vbe_q1_min m_high_b_one05_vbe_q2_max m_high_b_one05_vbe_q2_min m_high_b_one05_ic_q1_max
  print m_high_b_one05_ic_q1_min m_high_b_one05_ic_q2_max m_high_b_one05_ic_q2_min
  * run high_b_one06: one-tone, available power -44 dBm per tone
  alterparam fq1 = 20950000000.0
  alterparam fq2 = 20950000000.0
  alterparam va1 = 0.00399052462993776
  alterparam va2 = 0.0
  reset
  save all @q.xdut.xq1.qnpn13g2[ic] @q.xdut.xq2.qnpn13g2[ic]
  tran 1e-12 6e-08 0 1e-12
  linearize v(p2) v(xdut.c1) v(xdut.e1) v(xdut.oc) v(xdut.b1) v(xdut.b2) @q.xdut.xq1.qnpn13g2[ic] @q.xdut.xq2.qnpn13g2[ic]
  let tt = time[40000,59999]
  let xo = v(p2)[40000,59999]
  let m_high_b_one06_n = length(xo)
  let m_high_b_one06_t0 = tt[0]
  let m_high_b_one06_t1 = tt[19999]
  let m_high_b_one06_f0_c = 2*mean(xo*cos(2*pi*20950000000.0*tt))
  let m_high_b_one06_f0_s = 2*mean(xo*sin(2*pi*20950000000.0*tt))
  let m_high_b_one06_fl_lo_c = 2*mean(xo*cos(2*pi*20900000000.0*tt))
  let m_high_b_one06_fl_lo_s = 2*mean(xo*sin(2*pi*20900000000.0*tt))
  let m_high_b_one06_fl_hi_c = 2*mean(xo*cos(2*pi*21000000000.0*tt))
  let m_high_b_one06_fl_hi_s = 2*mean(xo*sin(2*pi*21000000000.0*tt))
  let m_high_b_one06_vce_q1_max = maximum(v(xdut.c1)[40000,59999] - v(xdut.e1)[40000,59999])
  let m_high_b_one06_vce_q1_min = minimum(v(xdut.c1)[40000,59999] - v(xdut.e1)[40000,59999])
  let m_high_b_one06_vce_q2_max = maximum(v(xdut.oc)[40000,59999] - v(xdut.c1)[40000,59999])
  let m_high_b_one06_vce_q2_min = minimum(v(xdut.oc)[40000,59999] - v(xdut.c1)[40000,59999])
  let m_high_b_one06_vbe_q1_max = maximum(v(xdut.b1)[40000,59999] - v(xdut.e1)[40000,59999])
  let m_high_b_one06_vbe_q1_min = minimum(v(xdut.b1)[40000,59999] - v(xdut.e1)[40000,59999])
  let m_high_b_one06_vbe_q2_max = maximum(v(xdut.b2)[40000,59999] - v(xdut.c1)[40000,59999])
  let m_high_b_one06_vbe_q2_min = minimum(v(xdut.b2)[40000,59999] - v(xdut.c1)[40000,59999])
  let w_high_b_one06_ic_q1 = @q.xdut.xq1.qnpn13g2[ic][40000,59999]
  let m_high_b_one06_ic_q1_max = maximum(w_high_b_one06_ic_q1)
  let m_high_b_one06_ic_q1_min = minimum(w_high_b_one06_ic_q1)
  let w_high_b_one06_ic_q2 = @q.xdut.xq2.qnpn13g2[ic][40000,59999]
  let m_high_b_one06_ic_q2_max = maximum(w_high_b_one06_ic_q2)
  let m_high_b_one06_ic_q2_min = minimum(w_high_b_one06_ic_q2)
  print m_high_b_one06_n m_high_b_one06_t0 m_high_b_one06_t1 m_high_b_one06_f0_c m_high_b_one06_f0_s m_high_b_one06_fl_lo_c
  print m_high_b_one06_fl_lo_s m_high_b_one06_fl_hi_c m_high_b_one06_fl_hi_s m_high_b_one06_vce_q1_max m_high_b_one06_vce_q1_min m_high_b_one06_vce_q2_max
  print m_high_b_one06_vce_q2_min m_high_b_one06_vbe_q1_max m_high_b_one06_vbe_q1_min m_high_b_one06_vbe_q2_max m_high_b_one06_vbe_q2_min m_high_b_one06_ic_q1_max
  print m_high_b_one06_ic_q1_min m_high_b_one06_ic_q2_max m_high_b_one06_ic_q2_min
  * run high_b_one07: one-tone, available power -42 dBm per tone
  alterparam fq1 = 20950000000.0
  alterparam fq2 = 20950000000.0
  alterparam va1 = 0.00502377286301916
  alterparam va2 = 0.0
  reset
  save all @q.xdut.xq1.qnpn13g2[ic] @q.xdut.xq2.qnpn13g2[ic]
  tran 1e-12 6e-08 0 1e-12
  linearize v(p2) v(xdut.c1) v(xdut.e1) v(xdut.oc) v(xdut.b1) v(xdut.b2) @q.xdut.xq1.qnpn13g2[ic] @q.xdut.xq2.qnpn13g2[ic]
  let tt = time[40000,59999]
  let xo = v(p2)[40000,59999]
  let m_high_b_one07_n = length(xo)
  let m_high_b_one07_t0 = tt[0]
  let m_high_b_one07_t1 = tt[19999]
  let m_high_b_one07_f0_c = 2*mean(xo*cos(2*pi*20950000000.0*tt))
  let m_high_b_one07_f0_s = 2*mean(xo*sin(2*pi*20950000000.0*tt))
  let m_high_b_one07_fl_lo_c = 2*mean(xo*cos(2*pi*20900000000.0*tt))
  let m_high_b_one07_fl_lo_s = 2*mean(xo*sin(2*pi*20900000000.0*tt))
  let m_high_b_one07_fl_hi_c = 2*mean(xo*cos(2*pi*21000000000.0*tt))
  let m_high_b_one07_fl_hi_s = 2*mean(xo*sin(2*pi*21000000000.0*tt))
  let m_high_b_one07_vce_q1_max = maximum(v(xdut.c1)[40000,59999] - v(xdut.e1)[40000,59999])
  let m_high_b_one07_vce_q1_min = minimum(v(xdut.c1)[40000,59999] - v(xdut.e1)[40000,59999])
  let m_high_b_one07_vce_q2_max = maximum(v(xdut.oc)[40000,59999] - v(xdut.c1)[40000,59999])
  let m_high_b_one07_vce_q2_min = minimum(v(xdut.oc)[40000,59999] - v(xdut.c1)[40000,59999])
  let m_high_b_one07_vbe_q1_max = maximum(v(xdut.b1)[40000,59999] - v(xdut.e1)[40000,59999])
  let m_high_b_one07_vbe_q1_min = minimum(v(xdut.b1)[40000,59999] - v(xdut.e1)[40000,59999])
  let m_high_b_one07_vbe_q2_max = maximum(v(xdut.b2)[40000,59999] - v(xdut.c1)[40000,59999])
  let m_high_b_one07_vbe_q2_min = minimum(v(xdut.b2)[40000,59999] - v(xdut.c1)[40000,59999])
  let w_high_b_one07_ic_q1 = @q.xdut.xq1.qnpn13g2[ic][40000,59999]
  let m_high_b_one07_ic_q1_max = maximum(w_high_b_one07_ic_q1)
  let m_high_b_one07_ic_q1_min = minimum(w_high_b_one07_ic_q1)
  let w_high_b_one07_ic_q2 = @q.xdut.xq2.qnpn13g2[ic][40000,59999]
  let m_high_b_one07_ic_q2_max = maximum(w_high_b_one07_ic_q2)
  let m_high_b_one07_ic_q2_min = minimum(w_high_b_one07_ic_q2)
  print m_high_b_one07_n m_high_b_one07_t0 m_high_b_one07_t1 m_high_b_one07_f0_c m_high_b_one07_f0_s m_high_b_one07_fl_lo_c
  print m_high_b_one07_fl_lo_s m_high_b_one07_fl_hi_c m_high_b_one07_fl_hi_s m_high_b_one07_vce_q1_max m_high_b_one07_vce_q1_min m_high_b_one07_vce_q2_max
  print m_high_b_one07_vce_q2_min m_high_b_one07_vbe_q1_max m_high_b_one07_vbe_q1_min m_high_b_one07_vbe_q2_max m_high_b_one07_vbe_q2_min m_high_b_one07_ic_q1_max
  print m_high_b_one07_ic_q1_min m_high_b_one07_ic_q2_max m_high_b_one07_ic_q2_min
  * run high_b_one08: one-tone, available power -40 dBm per tone
  alterparam fq1 = 20950000000.0
  alterparam fq2 = 20950000000.0
  alterparam va1 = 0.00632455532033676
  alterparam va2 = 0.0
  reset
  save all @q.xdut.xq1.qnpn13g2[ic] @q.xdut.xq2.qnpn13g2[ic]
  tran 1e-12 6e-08 0 1e-12
  linearize v(p2) v(xdut.c1) v(xdut.e1) v(xdut.oc) v(xdut.b1) v(xdut.b2) @q.xdut.xq1.qnpn13g2[ic] @q.xdut.xq2.qnpn13g2[ic]
  let tt = time[40000,59999]
  let xo = v(p2)[40000,59999]
  let m_high_b_one08_n = length(xo)
  let m_high_b_one08_t0 = tt[0]
  let m_high_b_one08_t1 = tt[19999]
  let m_high_b_one08_f0_c = 2*mean(xo*cos(2*pi*20950000000.0*tt))
  let m_high_b_one08_f0_s = 2*mean(xo*sin(2*pi*20950000000.0*tt))
  let m_high_b_one08_fl_lo_c = 2*mean(xo*cos(2*pi*20900000000.0*tt))
  let m_high_b_one08_fl_lo_s = 2*mean(xo*sin(2*pi*20900000000.0*tt))
  let m_high_b_one08_fl_hi_c = 2*mean(xo*cos(2*pi*21000000000.0*tt))
  let m_high_b_one08_fl_hi_s = 2*mean(xo*sin(2*pi*21000000000.0*tt))
  let m_high_b_one08_vce_q1_max = maximum(v(xdut.c1)[40000,59999] - v(xdut.e1)[40000,59999])
  let m_high_b_one08_vce_q1_min = minimum(v(xdut.c1)[40000,59999] - v(xdut.e1)[40000,59999])
  let m_high_b_one08_vce_q2_max = maximum(v(xdut.oc)[40000,59999] - v(xdut.c1)[40000,59999])
  let m_high_b_one08_vce_q2_min = minimum(v(xdut.oc)[40000,59999] - v(xdut.c1)[40000,59999])
  let m_high_b_one08_vbe_q1_max = maximum(v(xdut.b1)[40000,59999] - v(xdut.e1)[40000,59999])
  let m_high_b_one08_vbe_q1_min = minimum(v(xdut.b1)[40000,59999] - v(xdut.e1)[40000,59999])
  let m_high_b_one08_vbe_q2_max = maximum(v(xdut.b2)[40000,59999] - v(xdut.c1)[40000,59999])
  let m_high_b_one08_vbe_q2_min = minimum(v(xdut.b2)[40000,59999] - v(xdut.c1)[40000,59999])
  let w_high_b_one08_ic_q1 = @q.xdut.xq1.qnpn13g2[ic][40000,59999]
  let m_high_b_one08_ic_q1_max = maximum(w_high_b_one08_ic_q1)
  let m_high_b_one08_ic_q1_min = minimum(w_high_b_one08_ic_q1)
  let w_high_b_one08_ic_q2 = @q.xdut.xq2.qnpn13g2[ic][40000,59999]
  let m_high_b_one08_ic_q2_max = maximum(w_high_b_one08_ic_q2)
  let m_high_b_one08_ic_q2_min = minimum(w_high_b_one08_ic_q2)
  print m_high_b_one08_n m_high_b_one08_t0 m_high_b_one08_t1 m_high_b_one08_f0_c m_high_b_one08_f0_s m_high_b_one08_fl_lo_c
  print m_high_b_one08_fl_lo_s m_high_b_one08_fl_hi_c m_high_b_one08_fl_hi_s m_high_b_one08_vce_q1_max m_high_b_one08_vce_q1_min m_high_b_one08_vce_q2_max
  print m_high_b_one08_vce_q2_min m_high_b_one08_vbe_q1_max m_high_b_one08_vbe_q1_min m_high_b_one08_vbe_q2_max m_high_b_one08_vbe_q2_min m_high_b_one08_ic_q1_max
  print m_high_b_one08_ic_q1_min m_high_b_one08_ic_q2_max m_high_b_one08_ic_q2_min
  * run high_b_one09: one-tone, available power -38 dBm per tone
  alterparam fq1 = 20950000000.0
  alterparam fq2 = 20950000000.0
  alterparam va1 = 0.00796214341106995
  alterparam va2 = 0.0
  reset
  save all @q.xdut.xq1.qnpn13g2[ic] @q.xdut.xq2.qnpn13g2[ic]
  tran 1e-12 6e-08 0 1e-12
  linearize v(p2) v(xdut.c1) v(xdut.e1) v(xdut.oc) v(xdut.b1) v(xdut.b2) @q.xdut.xq1.qnpn13g2[ic] @q.xdut.xq2.qnpn13g2[ic]
  let tt = time[40000,59999]
  let xo = v(p2)[40000,59999]
  let m_high_b_one09_n = length(xo)
  let m_high_b_one09_t0 = tt[0]
  let m_high_b_one09_t1 = tt[19999]
  let m_high_b_one09_f0_c = 2*mean(xo*cos(2*pi*20950000000.0*tt))
  let m_high_b_one09_f0_s = 2*mean(xo*sin(2*pi*20950000000.0*tt))
  let m_high_b_one09_fl_lo_c = 2*mean(xo*cos(2*pi*20900000000.0*tt))
  let m_high_b_one09_fl_lo_s = 2*mean(xo*sin(2*pi*20900000000.0*tt))
  let m_high_b_one09_fl_hi_c = 2*mean(xo*cos(2*pi*21000000000.0*tt))
  let m_high_b_one09_fl_hi_s = 2*mean(xo*sin(2*pi*21000000000.0*tt))
  let m_high_b_one09_vce_q1_max = maximum(v(xdut.c1)[40000,59999] - v(xdut.e1)[40000,59999])
  let m_high_b_one09_vce_q1_min = minimum(v(xdut.c1)[40000,59999] - v(xdut.e1)[40000,59999])
  let m_high_b_one09_vce_q2_max = maximum(v(xdut.oc)[40000,59999] - v(xdut.c1)[40000,59999])
  let m_high_b_one09_vce_q2_min = minimum(v(xdut.oc)[40000,59999] - v(xdut.c1)[40000,59999])
  let m_high_b_one09_vbe_q1_max = maximum(v(xdut.b1)[40000,59999] - v(xdut.e1)[40000,59999])
  let m_high_b_one09_vbe_q1_min = minimum(v(xdut.b1)[40000,59999] - v(xdut.e1)[40000,59999])
  let m_high_b_one09_vbe_q2_max = maximum(v(xdut.b2)[40000,59999] - v(xdut.c1)[40000,59999])
  let m_high_b_one09_vbe_q2_min = minimum(v(xdut.b2)[40000,59999] - v(xdut.c1)[40000,59999])
  let w_high_b_one09_ic_q1 = @q.xdut.xq1.qnpn13g2[ic][40000,59999]
  let m_high_b_one09_ic_q1_max = maximum(w_high_b_one09_ic_q1)
  let m_high_b_one09_ic_q1_min = minimum(w_high_b_one09_ic_q1)
  let w_high_b_one09_ic_q2 = @q.xdut.xq2.qnpn13g2[ic][40000,59999]
  let m_high_b_one09_ic_q2_max = maximum(w_high_b_one09_ic_q2)
  let m_high_b_one09_ic_q2_min = minimum(w_high_b_one09_ic_q2)
  print m_high_b_one09_n m_high_b_one09_t0 m_high_b_one09_t1 m_high_b_one09_f0_c m_high_b_one09_f0_s m_high_b_one09_fl_lo_c
  print m_high_b_one09_fl_lo_s m_high_b_one09_fl_hi_c m_high_b_one09_fl_hi_s m_high_b_one09_vce_q1_max m_high_b_one09_vce_q1_min m_high_b_one09_vce_q2_max
  print m_high_b_one09_vce_q2_min m_high_b_one09_vbe_q1_max m_high_b_one09_vbe_q1_min m_high_b_one09_vbe_q2_max m_high_b_one09_vbe_q2_min m_high_b_one09_ic_q1_max
  print m_high_b_one09_ic_q1_min m_high_b_one09_ic_q2_max m_high_b_one09_ic_q2_min
  * run high_b_one10: one-tone, available power -36 dBm per tone
  alterparam fq1 = 20950000000.0
  alterparam fq2 = 20950000000.0
  alterparam va1 = 0.0100237446725454
  alterparam va2 = 0.0
  reset
  save all @q.xdut.xq1.qnpn13g2[ic] @q.xdut.xq2.qnpn13g2[ic]
  tran 1e-12 6e-08 0 1e-12
  linearize v(p2) v(xdut.c1) v(xdut.e1) v(xdut.oc) v(xdut.b1) v(xdut.b2) @q.xdut.xq1.qnpn13g2[ic] @q.xdut.xq2.qnpn13g2[ic]
  let tt = time[40000,59999]
  let xo = v(p2)[40000,59999]
  let m_high_b_one10_n = length(xo)
  let m_high_b_one10_t0 = tt[0]
  let m_high_b_one10_t1 = tt[19999]
  let m_high_b_one10_f0_c = 2*mean(xo*cos(2*pi*20950000000.0*tt))
  let m_high_b_one10_f0_s = 2*mean(xo*sin(2*pi*20950000000.0*tt))
  let m_high_b_one10_fl_lo_c = 2*mean(xo*cos(2*pi*20900000000.0*tt))
  let m_high_b_one10_fl_lo_s = 2*mean(xo*sin(2*pi*20900000000.0*tt))
  let m_high_b_one10_fl_hi_c = 2*mean(xo*cos(2*pi*21000000000.0*tt))
  let m_high_b_one10_fl_hi_s = 2*mean(xo*sin(2*pi*21000000000.0*tt))
  let m_high_b_one10_vce_q1_max = maximum(v(xdut.c1)[40000,59999] - v(xdut.e1)[40000,59999])
  let m_high_b_one10_vce_q1_min = minimum(v(xdut.c1)[40000,59999] - v(xdut.e1)[40000,59999])
  let m_high_b_one10_vce_q2_max = maximum(v(xdut.oc)[40000,59999] - v(xdut.c1)[40000,59999])
  let m_high_b_one10_vce_q2_min = minimum(v(xdut.oc)[40000,59999] - v(xdut.c1)[40000,59999])
  let m_high_b_one10_vbe_q1_max = maximum(v(xdut.b1)[40000,59999] - v(xdut.e1)[40000,59999])
  let m_high_b_one10_vbe_q1_min = minimum(v(xdut.b1)[40000,59999] - v(xdut.e1)[40000,59999])
  let m_high_b_one10_vbe_q2_max = maximum(v(xdut.b2)[40000,59999] - v(xdut.c1)[40000,59999])
  let m_high_b_one10_vbe_q2_min = minimum(v(xdut.b2)[40000,59999] - v(xdut.c1)[40000,59999])
  let w_high_b_one10_ic_q1 = @q.xdut.xq1.qnpn13g2[ic][40000,59999]
  let m_high_b_one10_ic_q1_max = maximum(w_high_b_one10_ic_q1)
  let m_high_b_one10_ic_q1_min = minimum(w_high_b_one10_ic_q1)
  let w_high_b_one10_ic_q2 = @q.xdut.xq2.qnpn13g2[ic][40000,59999]
  let m_high_b_one10_ic_q2_max = maximum(w_high_b_one10_ic_q2)
  let m_high_b_one10_ic_q2_min = minimum(w_high_b_one10_ic_q2)
  print m_high_b_one10_n m_high_b_one10_t0 m_high_b_one10_t1 m_high_b_one10_f0_c m_high_b_one10_f0_s m_high_b_one10_fl_lo_c
  print m_high_b_one10_fl_lo_s m_high_b_one10_fl_hi_c m_high_b_one10_fl_hi_s m_high_b_one10_vce_q1_max m_high_b_one10_vce_q1_min m_high_b_one10_vce_q2_max
  print m_high_b_one10_vce_q2_min m_high_b_one10_vbe_q1_max m_high_b_one10_vbe_q1_min m_high_b_one10_vbe_q2_max m_high_b_one10_vbe_q2_min m_high_b_one10_ic_q1_max
  print m_high_b_one10_ic_q1_min m_high_b_one10_ic_q2_max m_high_b_one10_ic_q2_min
  * run high_b_one11: one-tone, available power -34 dBm per tone
  alterparam fq1 = 20950000000.0
  alterparam fq2 = 20950000000.0
  alterparam va1 = 0.0126191468896039
  alterparam va2 = 0.0
  reset
  save all @q.xdut.xq1.qnpn13g2[ic] @q.xdut.xq2.qnpn13g2[ic]
  tran 1e-12 6e-08 0 1e-12
  linearize v(p2) v(xdut.c1) v(xdut.e1) v(xdut.oc) v(xdut.b1) v(xdut.b2) @q.xdut.xq1.qnpn13g2[ic] @q.xdut.xq2.qnpn13g2[ic]
  let tt = time[40000,59999]
  let xo = v(p2)[40000,59999]
  let m_high_b_one11_n = length(xo)
  let m_high_b_one11_t0 = tt[0]
  let m_high_b_one11_t1 = tt[19999]
  let m_high_b_one11_f0_c = 2*mean(xo*cos(2*pi*20950000000.0*tt))
  let m_high_b_one11_f0_s = 2*mean(xo*sin(2*pi*20950000000.0*tt))
  let m_high_b_one11_fl_lo_c = 2*mean(xo*cos(2*pi*20900000000.0*tt))
  let m_high_b_one11_fl_lo_s = 2*mean(xo*sin(2*pi*20900000000.0*tt))
  let m_high_b_one11_fl_hi_c = 2*mean(xo*cos(2*pi*21000000000.0*tt))
  let m_high_b_one11_fl_hi_s = 2*mean(xo*sin(2*pi*21000000000.0*tt))
  let m_high_b_one11_vce_q1_max = maximum(v(xdut.c1)[40000,59999] - v(xdut.e1)[40000,59999])
  let m_high_b_one11_vce_q1_min = minimum(v(xdut.c1)[40000,59999] - v(xdut.e1)[40000,59999])
  let m_high_b_one11_vce_q2_max = maximum(v(xdut.oc)[40000,59999] - v(xdut.c1)[40000,59999])
  let m_high_b_one11_vce_q2_min = minimum(v(xdut.oc)[40000,59999] - v(xdut.c1)[40000,59999])
  let m_high_b_one11_vbe_q1_max = maximum(v(xdut.b1)[40000,59999] - v(xdut.e1)[40000,59999])
  let m_high_b_one11_vbe_q1_min = minimum(v(xdut.b1)[40000,59999] - v(xdut.e1)[40000,59999])
  let m_high_b_one11_vbe_q2_max = maximum(v(xdut.b2)[40000,59999] - v(xdut.c1)[40000,59999])
  let m_high_b_one11_vbe_q2_min = minimum(v(xdut.b2)[40000,59999] - v(xdut.c1)[40000,59999])
  let w_high_b_one11_ic_q1 = @q.xdut.xq1.qnpn13g2[ic][40000,59999]
  let m_high_b_one11_ic_q1_max = maximum(w_high_b_one11_ic_q1)
  let m_high_b_one11_ic_q1_min = minimum(w_high_b_one11_ic_q1)
  let w_high_b_one11_ic_q2 = @q.xdut.xq2.qnpn13g2[ic][40000,59999]
  let m_high_b_one11_ic_q2_max = maximum(w_high_b_one11_ic_q2)
  let m_high_b_one11_ic_q2_min = minimum(w_high_b_one11_ic_q2)
  print m_high_b_one11_n m_high_b_one11_t0 m_high_b_one11_t1 m_high_b_one11_f0_c m_high_b_one11_f0_s m_high_b_one11_fl_lo_c
  print m_high_b_one11_fl_lo_s m_high_b_one11_fl_hi_c m_high_b_one11_fl_hi_s m_high_b_one11_vce_q1_max m_high_b_one11_vce_q1_min m_high_b_one11_vce_q2_max
  print m_high_b_one11_vce_q2_min m_high_b_one11_vbe_q1_max m_high_b_one11_vbe_q1_min m_high_b_one11_vbe_q2_max m_high_b_one11_vbe_q2_min m_high_b_one11_ic_q1_max
  print m_high_b_one11_ic_q1_min m_high_b_one11_ic_q2_max m_high_b_one11_ic_q2_min
  * run high_b_one12: one-tone, available power -32 dBm per tone
  alterparam fq1 = 20950000000.0
  alterparam fq2 = 20950000000.0
  alterparam va1 = 0.0158865646944856
  alterparam va2 = 0.0
  reset
  save all @q.xdut.xq1.qnpn13g2[ic] @q.xdut.xq2.qnpn13g2[ic]
  tran 1e-12 6e-08 0 1e-12
  linearize v(p2) v(xdut.c1) v(xdut.e1) v(xdut.oc) v(xdut.b1) v(xdut.b2) @q.xdut.xq1.qnpn13g2[ic] @q.xdut.xq2.qnpn13g2[ic]
  let tt = time[40000,59999]
  let xo = v(p2)[40000,59999]
  let m_high_b_one12_n = length(xo)
  let m_high_b_one12_t0 = tt[0]
  let m_high_b_one12_t1 = tt[19999]
  let m_high_b_one12_f0_c = 2*mean(xo*cos(2*pi*20950000000.0*tt))
  let m_high_b_one12_f0_s = 2*mean(xo*sin(2*pi*20950000000.0*tt))
  let m_high_b_one12_fl_lo_c = 2*mean(xo*cos(2*pi*20900000000.0*tt))
  let m_high_b_one12_fl_lo_s = 2*mean(xo*sin(2*pi*20900000000.0*tt))
  let m_high_b_one12_fl_hi_c = 2*mean(xo*cos(2*pi*21000000000.0*tt))
  let m_high_b_one12_fl_hi_s = 2*mean(xo*sin(2*pi*21000000000.0*tt))
  let m_high_b_one12_vce_q1_max = maximum(v(xdut.c1)[40000,59999] - v(xdut.e1)[40000,59999])
  let m_high_b_one12_vce_q1_min = minimum(v(xdut.c1)[40000,59999] - v(xdut.e1)[40000,59999])
  let m_high_b_one12_vce_q2_max = maximum(v(xdut.oc)[40000,59999] - v(xdut.c1)[40000,59999])
  let m_high_b_one12_vce_q2_min = minimum(v(xdut.oc)[40000,59999] - v(xdut.c1)[40000,59999])
  let m_high_b_one12_vbe_q1_max = maximum(v(xdut.b1)[40000,59999] - v(xdut.e1)[40000,59999])
  let m_high_b_one12_vbe_q1_min = minimum(v(xdut.b1)[40000,59999] - v(xdut.e1)[40000,59999])
  let m_high_b_one12_vbe_q2_max = maximum(v(xdut.b2)[40000,59999] - v(xdut.c1)[40000,59999])
  let m_high_b_one12_vbe_q2_min = minimum(v(xdut.b2)[40000,59999] - v(xdut.c1)[40000,59999])
  let w_high_b_one12_ic_q1 = @q.xdut.xq1.qnpn13g2[ic][40000,59999]
  let m_high_b_one12_ic_q1_max = maximum(w_high_b_one12_ic_q1)
  let m_high_b_one12_ic_q1_min = minimum(w_high_b_one12_ic_q1)
  let w_high_b_one12_ic_q2 = @q.xdut.xq2.qnpn13g2[ic][40000,59999]
  let m_high_b_one12_ic_q2_max = maximum(w_high_b_one12_ic_q2)
  let m_high_b_one12_ic_q2_min = minimum(w_high_b_one12_ic_q2)
  print m_high_b_one12_n m_high_b_one12_t0 m_high_b_one12_t1 m_high_b_one12_f0_c m_high_b_one12_f0_s m_high_b_one12_fl_lo_c
  print m_high_b_one12_fl_lo_s m_high_b_one12_fl_hi_c m_high_b_one12_fl_hi_s m_high_b_one12_vce_q1_max m_high_b_one12_vce_q1_min m_high_b_one12_vce_q2_max
  print m_high_b_one12_vce_q2_min m_high_b_one12_vbe_q1_max m_high_b_one12_vbe_q1_min m_high_b_one12_vbe_q2_max m_high_b_one12_vbe_q2_min m_high_b_one12_ic_q1_max
  print m_high_b_one12_ic_q1_min m_high_b_one12_ic_q2_max m_high_b_one12_ic_q2_min
  * run high_b_one13: one-tone, available power -30 dBm per tone
  alterparam fq1 = 20950000000.0
  alterparam fq2 = 20950000000.0
  alterparam va1 = 0.02
  alterparam va2 = 0.0
  reset
  save all @q.xdut.xq1.qnpn13g2[ic] @q.xdut.xq2.qnpn13g2[ic]
  tran 1e-12 6e-08 0 1e-12
  linearize v(p2) v(xdut.c1) v(xdut.e1) v(xdut.oc) v(xdut.b1) v(xdut.b2) @q.xdut.xq1.qnpn13g2[ic] @q.xdut.xq2.qnpn13g2[ic]
  let tt = time[40000,59999]
  let xo = v(p2)[40000,59999]
  let m_high_b_one13_n = length(xo)
  let m_high_b_one13_t0 = tt[0]
  let m_high_b_one13_t1 = tt[19999]
  let m_high_b_one13_f0_c = 2*mean(xo*cos(2*pi*20950000000.0*tt))
  let m_high_b_one13_f0_s = 2*mean(xo*sin(2*pi*20950000000.0*tt))
  let m_high_b_one13_fl_lo_c = 2*mean(xo*cos(2*pi*20900000000.0*tt))
  let m_high_b_one13_fl_lo_s = 2*mean(xo*sin(2*pi*20900000000.0*tt))
  let m_high_b_one13_fl_hi_c = 2*mean(xo*cos(2*pi*21000000000.0*tt))
  let m_high_b_one13_fl_hi_s = 2*mean(xo*sin(2*pi*21000000000.0*tt))
  let m_high_b_one13_vce_q1_max = maximum(v(xdut.c1)[40000,59999] - v(xdut.e1)[40000,59999])
  let m_high_b_one13_vce_q1_min = minimum(v(xdut.c1)[40000,59999] - v(xdut.e1)[40000,59999])
  let m_high_b_one13_vce_q2_max = maximum(v(xdut.oc)[40000,59999] - v(xdut.c1)[40000,59999])
  let m_high_b_one13_vce_q2_min = minimum(v(xdut.oc)[40000,59999] - v(xdut.c1)[40000,59999])
  let m_high_b_one13_vbe_q1_max = maximum(v(xdut.b1)[40000,59999] - v(xdut.e1)[40000,59999])
  let m_high_b_one13_vbe_q1_min = minimum(v(xdut.b1)[40000,59999] - v(xdut.e1)[40000,59999])
  let m_high_b_one13_vbe_q2_max = maximum(v(xdut.b2)[40000,59999] - v(xdut.c1)[40000,59999])
  let m_high_b_one13_vbe_q2_min = minimum(v(xdut.b2)[40000,59999] - v(xdut.c1)[40000,59999])
  let w_high_b_one13_ic_q1 = @q.xdut.xq1.qnpn13g2[ic][40000,59999]
  let m_high_b_one13_ic_q1_max = maximum(w_high_b_one13_ic_q1)
  let m_high_b_one13_ic_q1_min = minimum(w_high_b_one13_ic_q1)
  let w_high_b_one13_ic_q2 = @q.xdut.xq2.qnpn13g2[ic][40000,59999]
  let m_high_b_one13_ic_q2_max = maximum(w_high_b_one13_ic_q2)
  let m_high_b_one13_ic_q2_min = minimum(w_high_b_one13_ic_q2)
  print m_high_b_one13_n m_high_b_one13_t0 m_high_b_one13_t1 m_high_b_one13_f0_c m_high_b_one13_f0_s m_high_b_one13_fl_lo_c
  print m_high_b_one13_fl_lo_s m_high_b_one13_fl_hi_c m_high_b_one13_fl_hi_s m_high_b_one13_vce_q1_max m_high_b_one13_vce_q1_min m_high_b_one13_vce_q2_max
  print m_high_b_one13_vce_q2_min m_high_b_one13_vbe_q1_max m_high_b_one13_vbe_q1_min m_high_b_one13_vbe_q2_max m_high_b_one13_vbe_q2_min m_high_b_one13_ic_q1_max
  print m_high_b_one13_ic_q1_min m_high_b_one13_ic_q2_max m_high_b_one13_ic_q2_min
  * run high_b_one14: one-tone, available power -28 dBm per tone
  alterparam fq1 = 20950000000.0
  alterparam fq2 = 20950000000.0
  alterparam va1 = 0.0251785082358833
  alterparam va2 = 0.0
  reset
  save all @q.xdut.xq1.qnpn13g2[ic] @q.xdut.xq2.qnpn13g2[ic]
  tran 1e-12 6e-08 0 1e-12
  linearize v(p2) v(xdut.c1) v(xdut.e1) v(xdut.oc) v(xdut.b1) v(xdut.b2) @q.xdut.xq1.qnpn13g2[ic] @q.xdut.xq2.qnpn13g2[ic]
  let tt = time[40000,59999]
  let xo = v(p2)[40000,59999]
  let m_high_b_one14_n = length(xo)
  let m_high_b_one14_t0 = tt[0]
  let m_high_b_one14_t1 = tt[19999]
  let m_high_b_one14_f0_c = 2*mean(xo*cos(2*pi*20950000000.0*tt))
  let m_high_b_one14_f0_s = 2*mean(xo*sin(2*pi*20950000000.0*tt))
  let m_high_b_one14_fl_lo_c = 2*mean(xo*cos(2*pi*20900000000.0*tt))
  let m_high_b_one14_fl_lo_s = 2*mean(xo*sin(2*pi*20900000000.0*tt))
  let m_high_b_one14_fl_hi_c = 2*mean(xo*cos(2*pi*21000000000.0*tt))
  let m_high_b_one14_fl_hi_s = 2*mean(xo*sin(2*pi*21000000000.0*tt))
  let m_high_b_one14_vce_q1_max = maximum(v(xdut.c1)[40000,59999] - v(xdut.e1)[40000,59999])
  let m_high_b_one14_vce_q1_min = minimum(v(xdut.c1)[40000,59999] - v(xdut.e1)[40000,59999])
  let m_high_b_one14_vce_q2_max = maximum(v(xdut.oc)[40000,59999] - v(xdut.c1)[40000,59999])
  let m_high_b_one14_vce_q2_min = minimum(v(xdut.oc)[40000,59999] - v(xdut.c1)[40000,59999])
  let m_high_b_one14_vbe_q1_max = maximum(v(xdut.b1)[40000,59999] - v(xdut.e1)[40000,59999])
  let m_high_b_one14_vbe_q1_min = minimum(v(xdut.b1)[40000,59999] - v(xdut.e1)[40000,59999])
  let m_high_b_one14_vbe_q2_max = maximum(v(xdut.b2)[40000,59999] - v(xdut.c1)[40000,59999])
  let m_high_b_one14_vbe_q2_min = minimum(v(xdut.b2)[40000,59999] - v(xdut.c1)[40000,59999])
  let w_high_b_one14_ic_q1 = @q.xdut.xq1.qnpn13g2[ic][40000,59999]
  let m_high_b_one14_ic_q1_max = maximum(w_high_b_one14_ic_q1)
  let m_high_b_one14_ic_q1_min = minimum(w_high_b_one14_ic_q1)
  let w_high_b_one14_ic_q2 = @q.xdut.xq2.qnpn13g2[ic][40000,59999]
  let m_high_b_one14_ic_q2_max = maximum(w_high_b_one14_ic_q2)
  let m_high_b_one14_ic_q2_min = minimum(w_high_b_one14_ic_q2)
  print m_high_b_one14_n m_high_b_one14_t0 m_high_b_one14_t1 m_high_b_one14_f0_c m_high_b_one14_f0_s m_high_b_one14_fl_lo_c
  print m_high_b_one14_fl_lo_s m_high_b_one14_fl_hi_c m_high_b_one14_fl_hi_s m_high_b_one14_vce_q1_max m_high_b_one14_vce_q1_min m_high_b_one14_vce_q2_max
  print m_high_b_one14_vce_q2_min m_high_b_one14_vbe_q1_max m_high_b_one14_vbe_q1_min m_high_b_one14_vbe_q2_max m_high_b_one14_vbe_q2_min m_high_b_one14_ic_q1_max
  print m_high_b_one14_ic_q1_min m_high_b_one14_ic_q2_max m_high_b_one14_ic_q2_min
  * run high_b_one15: one-tone, available power -26 dBm per tone
  alterparam fq1 = 20950000000.0
  alterparam fq2 = 20950000000.0
  alterparam va1 = 0.0316978638492223
  alterparam va2 = 0.0
  reset
  save all @q.xdut.xq1.qnpn13g2[ic] @q.xdut.xq2.qnpn13g2[ic]
  tran 1e-12 6e-08 0 1e-12
  linearize v(p2) v(xdut.c1) v(xdut.e1) v(xdut.oc) v(xdut.b1) v(xdut.b2) @q.xdut.xq1.qnpn13g2[ic] @q.xdut.xq2.qnpn13g2[ic]
  let tt = time[40000,59999]
  let xo = v(p2)[40000,59999]
  let m_high_b_one15_n = length(xo)
  let m_high_b_one15_t0 = tt[0]
  let m_high_b_one15_t1 = tt[19999]
  let m_high_b_one15_f0_c = 2*mean(xo*cos(2*pi*20950000000.0*tt))
  let m_high_b_one15_f0_s = 2*mean(xo*sin(2*pi*20950000000.0*tt))
  let m_high_b_one15_fl_lo_c = 2*mean(xo*cos(2*pi*20900000000.0*tt))
  let m_high_b_one15_fl_lo_s = 2*mean(xo*sin(2*pi*20900000000.0*tt))
  let m_high_b_one15_fl_hi_c = 2*mean(xo*cos(2*pi*21000000000.0*tt))
  let m_high_b_one15_fl_hi_s = 2*mean(xo*sin(2*pi*21000000000.0*tt))
  let m_high_b_one15_vce_q1_max = maximum(v(xdut.c1)[40000,59999] - v(xdut.e1)[40000,59999])
  let m_high_b_one15_vce_q1_min = minimum(v(xdut.c1)[40000,59999] - v(xdut.e1)[40000,59999])
  let m_high_b_one15_vce_q2_max = maximum(v(xdut.oc)[40000,59999] - v(xdut.c1)[40000,59999])
  let m_high_b_one15_vce_q2_min = minimum(v(xdut.oc)[40000,59999] - v(xdut.c1)[40000,59999])
  let m_high_b_one15_vbe_q1_max = maximum(v(xdut.b1)[40000,59999] - v(xdut.e1)[40000,59999])
  let m_high_b_one15_vbe_q1_min = minimum(v(xdut.b1)[40000,59999] - v(xdut.e1)[40000,59999])
  let m_high_b_one15_vbe_q2_max = maximum(v(xdut.b2)[40000,59999] - v(xdut.c1)[40000,59999])
  let m_high_b_one15_vbe_q2_min = minimum(v(xdut.b2)[40000,59999] - v(xdut.c1)[40000,59999])
  let w_high_b_one15_ic_q1 = @q.xdut.xq1.qnpn13g2[ic][40000,59999]
  let m_high_b_one15_ic_q1_max = maximum(w_high_b_one15_ic_q1)
  let m_high_b_one15_ic_q1_min = minimum(w_high_b_one15_ic_q1)
  let w_high_b_one15_ic_q2 = @q.xdut.xq2.qnpn13g2[ic][40000,59999]
  let m_high_b_one15_ic_q2_max = maximum(w_high_b_one15_ic_q2)
  let m_high_b_one15_ic_q2_min = minimum(w_high_b_one15_ic_q2)
  print m_high_b_one15_n m_high_b_one15_t0 m_high_b_one15_t1 m_high_b_one15_f0_c m_high_b_one15_f0_s m_high_b_one15_fl_lo_c
  print m_high_b_one15_fl_lo_s m_high_b_one15_fl_hi_c m_high_b_one15_fl_hi_s m_high_b_one15_vce_q1_max m_high_b_one15_vce_q1_min m_high_b_one15_vce_q2_max
  print m_high_b_one15_vce_q2_min m_high_b_one15_vbe_q1_max m_high_b_one15_vbe_q1_min m_high_b_one15_vbe_q2_max m_high_b_one15_vbe_q2_min m_high_b_one15_ic_q1_max
  print m_high_b_one15_ic_q1_min m_high_b_one15_ic_q2_max m_high_b_one15_ic_q2_min
  * run high_b_one16: one-tone, available power -24 dBm per tone
  alterparam fq1 = 20950000000.0
  alterparam fq2 = 20950000000.0
  alterparam va1 = 0.0399052462993776
  alterparam va2 = 0.0
  reset
  save all @q.xdut.xq1.qnpn13g2[ic] @q.xdut.xq2.qnpn13g2[ic]
  tran 1e-12 6e-08 0 1e-12
  linearize v(p2) v(xdut.c1) v(xdut.e1) v(xdut.oc) v(xdut.b1) v(xdut.b2) @q.xdut.xq1.qnpn13g2[ic] @q.xdut.xq2.qnpn13g2[ic]
  let tt = time[40000,59999]
  let xo = v(p2)[40000,59999]
  let m_high_b_one16_n = length(xo)
  let m_high_b_one16_t0 = tt[0]
  let m_high_b_one16_t1 = tt[19999]
  let m_high_b_one16_f0_c = 2*mean(xo*cos(2*pi*20950000000.0*tt))
  let m_high_b_one16_f0_s = 2*mean(xo*sin(2*pi*20950000000.0*tt))
  let m_high_b_one16_fl_lo_c = 2*mean(xo*cos(2*pi*20900000000.0*tt))
  let m_high_b_one16_fl_lo_s = 2*mean(xo*sin(2*pi*20900000000.0*tt))
  let m_high_b_one16_fl_hi_c = 2*mean(xo*cos(2*pi*21000000000.0*tt))
  let m_high_b_one16_fl_hi_s = 2*mean(xo*sin(2*pi*21000000000.0*tt))
  let m_high_b_one16_vce_q1_max = maximum(v(xdut.c1)[40000,59999] - v(xdut.e1)[40000,59999])
  let m_high_b_one16_vce_q1_min = minimum(v(xdut.c1)[40000,59999] - v(xdut.e1)[40000,59999])
  let m_high_b_one16_vce_q2_max = maximum(v(xdut.oc)[40000,59999] - v(xdut.c1)[40000,59999])
  let m_high_b_one16_vce_q2_min = minimum(v(xdut.oc)[40000,59999] - v(xdut.c1)[40000,59999])
  let m_high_b_one16_vbe_q1_max = maximum(v(xdut.b1)[40000,59999] - v(xdut.e1)[40000,59999])
  let m_high_b_one16_vbe_q1_min = minimum(v(xdut.b1)[40000,59999] - v(xdut.e1)[40000,59999])
  let m_high_b_one16_vbe_q2_max = maximum(v(xdut.b2)[40000,59999] - v(xdut.c1)[40000,59999])
  let m_high_b_one16_vbe_q2_min = minimum(v(xdut.b2)[40000,59999] - v(xdut.c1)[40000,59999])
  let w_high_b_one16_ic_q1 = @q.xdut.xq1.qnpn13g2[ic][40000,59999]
  let m_high_b_one16_ic_q1_max = maximum(w_high_b_one16_ic_q1)
  let m_high_b_one16_ic_q1_min = minimum(w_high_b_one16_ic_q1)
  let w_high_b_one16_ic_q2 = @q.xdut.xq2.qnpn13g2[ic][40000,59999]
  let m_high_b_one16_ic_q2_max = maximum(w_high_b_one16_ic_q2)
  let m_high_b_one16_ic_q2_min = minimum(w_high_b_one16_ic_q2)
  print m_high_b_one16_n m_high_b_one16_t0 m_high_b_one16_t1 m_high_b_one16_f0_c m_high_b_one16_f0_s m_high_b_one16_fl_lo_c
  print m_high_b_one16_fl_lo_s m_high_b_one16_fl_hi_c m_high_b_one16_fl_hi_s m_high_b_one16_vce_q1_max m_high_b_one16_vce_q1_min m_high_b_one16_vce_q2_max
  print m_high_b_one16_vce_q2_min m_high_b_one16_vbe_q1_max m_high_b_one16_vbe_q1_min m_high_b_one16_vbe_q2_max m_high_b_one16_vbe_q2_min m_high_b_one16_ic_q1_max
  print m_high_b_one16_ic_q1_min m_high_b_one16_ic_q2_max m_high_b_one16_ic_q2_min
  * run high_b_one17: one-tone, available power -22 dBm per tone
  alterparam fq1 = 20950000000.0
  alterparam fq2 = 20950000000.0
  alterparam va1 = 0.0502377286301916
  alterparam va2 = 0.0
  reset
  save all @q.xdut.xq1.qnpn13g2[ic] @q.xdut.xq2.qnpn13g2[ic]
  tran 1e-12 6e-08 0 1e-12
  linearize v(p2) v(xdut.c1) v(xdut.e1) v(xdut.oc) v(xdut.b1) v(xdut.b2) @q.xdut.xq1.qnpn13g2[ic] @q.xdut.xq2.qnpn13g2[ic]
  let tt = time[40000,59999]
  let xo = v(p2)[40000,59999]
  let m_high_b_one17_n = length(xo)
  let m_high_b_one17_t0 = tt[0]
  let m_high_b_one17_t1 = tt[19999]
  let m_high_b_one17_f0_c = 2*mean(xo*cos(2*pi*20950000000.0*tt))
  let m_high_b_one17_f0_s = 2*mean(xo*sin(2*pi*20950000000.0*tt))
  let m_high_b_one17_fl_lo_c = 2*mean(xo*cos(2*pi*20900000000.0*tt))
  let m_high_b_one17_fl_lo_s = 2*mean(xo*sin(2*pi*20900000000.0*tt))
  let m_high_b_one17_fl_hi_c = 2*mean(xo*cos(2*pi*21000000000.0*tt))
  let m_high_b_one17_fl_hi_s = 2*mean(xo*sin(2*pi*21000000000.0*tt))
  let m_high_b_one17_vce_q1_max = maximum(v(xdut.c1)[40000,59999] - v(xdut.e1)[40000,59999])
  let m_high_b_one17_vce_q1_min = minimum(v(xdut.c1)[40000,59999] - v(xdut.e1)[40000,59999])
  let m_high_b_one17_vce_q2_max = maximum(v(xdut.oc)[40000,59999] - v(xdut.c1)[40000,59999])
  let m_high_b_one17_vce_q2_min = minimum(v(xdut.oc)[40000,59999] - v(xdut.c1)[40000,59999])
  let m_high_b_one17_vbe_q1_max = maximum(v(xdut.b1)[40000,59999] - v(xdut.e1)[40000,59999])
  let m_high_b_one17_vbe_q1_min = minimum(v(xdut.b1)[40000,59999] - v(xdut.e1)[40000,59999])
  let m_high_b_one17_vbe_q2_max = maximum(v(xdut.b2)[40000,59999] - v(xdut.c1)[40000,59999])
  let m_high_b_one17_vbe_q2_min = minimum(v(xdut.b2)[40000,59999] - v(xdut.c1)[40000,59999])
  let w_high_b_one17_ic_q1 = @q.xdut.xq1.qnpn13g2[ic][40000,59999]
  let m_high_b_one17_ic_q1_max = maximum(w_high_b_one17_ic_q1)
  let m_high_b_one17_ic_q1_min = minimum(w_high_b_one17_ic_q1)
  let w_high_b_one17_ic_q2 = @q.xdut.xq2.qnpn13g2[ic][40000,59999]
  let m_high_b_one17_ic_q2_max = maximum(w_high_b_one17_ic_q2)
  let m_high_b_one17_ic_q2_min = minimum(w_high_b_one17_ic_q2)
  print m_high_b_one17_n m_high_b_one17_t0 m_high_b_one17_t1 m_high_b_one17_f0_c m_high_b_one17_f0_s m_high_b_one17_fl_lo_c
  print m_high_b_one17_fl_lo_s m_high_b_one17_fl_hi_c m_high_b_one17_fl_hi_s m_high_b_one17_vce_q1_max m_high_b_one17_vce_q1_min m_high_b_one17_vce_q2_max
  print m_high_b_one17_vce_q2_min m_high_b_one17_vbe_q1_max m_high_b_one17_vbe_q1_min m_high_b_one17_vbe_q2_max m_high_b_one17_vbe_q2_min m_high_b_one17_ic_q1_max
  print m_high_b_one17_ic_q1_min m_high_b_one17_ic_q2_max m_high_b_one17_ic_q2_min
  * run high_b_one18: one-tone, available power -20 dBm per tone
  alterparam fq1 = 20950000000.0
  alterparam fq2 = 20950000000.0
  alterparam va1 = 0.0632455532033676
  alterparam va2 = 0.0
  reset
  save all @q.xdut.xq1.qnpn13g2[ic] @q.xdut.xq2.qnpn13g2[ic]
  tran 1e-12 6e-08 0 1e-12
  linearize v(p2) v(xdut.c1) v(xdut.e1) v(xdut.oc) v(xdut.b1) v(xdut.b2) @q.xdut.xq1.qnpn13g2[ic] @q.xdut.xq2.qnpn13g2[ic]
  let tt = time[40000,59999]
  let xo = v(p2)[40000,59999]
  let m_high_b_one18_n = length(xo)
  let m_high_b_one18_t0 = tt[0]
  let m_high_b_one18_t1 = tt[19999]
  let m_high_b_one18_f0_c = 2*mean(xo*cos(2*pi*20950000000.0*tt))
  let m_high_b_one18_f0_s = 2*mean(xo*sin(2*pi*20950000000.0*tt))
  let m_high_b_one18_fl_lo_c = 2*mean(xo*cos(2*pi*20900000000.0*tt))
  let m_high_b_one18_fl_lo_s = 2*mean(xo*sin(2*pi*20900000000.0*tt))
  let m_high_b_one18_fl_hi_c = 2*mean(xo*cos(2*pi*21000000000.0*tt))
  let m_high_b_one18_fl_hi_s = 2*mean(xo*sin(2*pi*21000000000.0*tt))
  let m_high_b_one18_vce_q1_max = maximum(v(xdut.c1)[40000,59999] - v(xdut.e1)[40000,59999])
  let m_high_b_one18_vce_q1_min = minimum(v(xdut.c1)[40000,59999] - v(xdut.e1)[40000,59999])
  let m_high_b_one18_vce_q2_max = maximum(v(xdut.oc)[40000,59999] - v(xdut.c1)[40000,59999])
  let m_high_b_one18_vce_q2_min = minimum(v(xdut.oc)[40000,59999] - v(xdut.c1)[40000,59999])
  let m_high_b_one18_vbe_q1_max = maximum(v(xdut.b1)[40000,59999] - v(xdut.e1)[40000,59999])
  let m_high_b_one18_vbe_q1_min = minimum(v(xdut.b1)[40000,59999] - v(xdut.e1)[40000,59999])
  let m_high_b_one18_vbe_q2_max = maximum(v(xdut.b2)[40000,59999] - v(xdut.c1)[40000,59999])
  let m_high_b_one18_vbe_q2_min = minimum(v(xdut.b2)[40000,59999] - v(xdut.c1)[40000,59999])
  let w_high_b_one18_ic_q1 = @q.xdut.xq1.qnpn13g2[ic][40000,59999]
  let m_high_b_one18_ic_q1_max = maximum(w_high_b_one18_ic_q1)
  let m_high_b_one18_ic_q1_min = minimum(w_high_b_one18_ic_q1)
  let w_high_b_one18_ic_q2 = @q.xdut.xq2.qnpn13g2[ic][40000,59999]
  let m_high_b_one18_ic_q2_max = maximum(w_high_b_one18_ic_q2)
  let m_high_b_one18_ic_q2_min = minimum(w_high_b_one18_ic_q2)
  print m_high_b_one18_n m_high_b_one18_t0 m_high_b_one18_t1 m_high_b_one18_f0_c m_high_b_one18_f0_s m_high_b_one18_fl_lo_c
  print m_high_b_one18_fl_lo_s m_high_b_one18_fl_hi_c m_high_b_one18_fl_hi_s m_high_b_one18_vce_q1_max m_high_b_one18_vce_q1_min m_high_b_one18_vce_q2_max
  print m_high_b_one18_vce_q2_min m_high_b_one18_vbe_q1_max m_high_b_one18_vbe_q1_min m_high_b_one18_vbe_q2_max m_high_b_one18_vbe_q2_min m_high_b_one18_ic_q1_max
  print m_high_b_one18_ic_q1_min m_high_b_one18_ic_q2_max m_high_b_one18_ic_q2_min
  * run high_b_one19: one-tone, available power -18 dBm per tone
  alterparam fq1 = 20950000000.0
  alterparam fq2 = 20950000000.0
  alterparam va1 = 0.0796214341106995
  alterparam va2 = 0.0
  reset
  save all @q.xdut.xq1.qnpn13g2[ic] @q.xdut.xq2.qnpn13g2[ic]
  tran 1e-12 6e-08 0 1e-12
  linearize v(p2) v(xdut.c1) v(xdut.e1) v(xdut.oc) v(xdut.b1) v(xdut.b2) @q.xdut.xq1.qnpn13g2[ic] @q.xdut.xq2.qnpn13g2[ic]
  let tt = time[40000,59999]
  let xo = v(p2)[40000,59999]
  let m_high_b_one19_n = length(xo)
  let m_high_b_one19_t0 = tt[0]
  let m_high_b_one19_t1 = tt[19999]
  let m_high_b_one19_f0_c = 2*mean(xo*cos(2*pi*20950000000.0*tt))
  let m_high_b_one19_f0_s = 2*mean(xo*sin(2*pi*20950000000.0*tt))
  let m_high_b_one19_fl_lo_c = 2*mean(xo*cos(2*pi*20900000000.0*tt))
  let m_high_b_one19_fl_lo_s = 2*mean(xo*sin(2*pi*20900000000.0*tt))
  let m_high_b_one19_fl_hi_c = 2*mean(xo*cos(2*pi*21000000000.0*tt))
  let m_high_b_one19_fl_hi_s = 2*mean(xo*sin(2*pi*21000000000.0*tt))
  let m_high_b_one19_vce_q1_max = maximum(v(xdut.c1)[40000,59999] - v(xdut.e1)[40000,59999])
  let m_high_b_one19_vce_q1_min = minimum(v(xdut.c1)[40000,59999] - v(xdut.e1)[40000,59999])
  let m_high_b_one19_vce_q2_max = maximum(v(xdut.oc)[40000,59999] - v(xdut.c1)[40000,59999])
  let m_high_b_one19_vce_q2_min = minimum(v(xdut.oc)[40000,59999] - v(xdut.c1)[40000,59999])
  let m_high_b_one19_vbe_q1_max = maximum(v(xdut.b1)[40000,59999] - v(xdut.e1)[40000,59999])
  let m_high_b_one19_vbe_q1_min = minimum(v(xdut.b1)[40000,59999] - v(xdut.e1)[40000,59999])
  let m_high_b_one19_vbe_q2_max = maximum(v(xdut.b2)[40000,59999] - v(xdut.c1)[40000,59999])
  let m_high_b_one19_vbe_q2_min = minimum(v(xdut.b2)[40000,59999] - v(xdut.c1)[40000,59999])
  let w_high_b_one19_ic_q1 = @q.xdut.xq1.qnpn13g2[ic][40000,59999]
  let m_high_b_one19_ic_q1_max = maximum(w_high_b_one19_ic_q1)
  let m_high_b_one19_ic_q1_min = minimum(w_high_b_one19_ic_q1)
  let w_high_b_one19_ic_q2 = @q.xdut.xq2.qnpn13g2[ic][40000,59999]
  let m_high_b_one19_ic_q2_max = maximum(w_high_b_one19_ic_q2)
  let m_high_b_one19_ic_q2_min = minimum(w_high_b_one19_ic_q2)
  print m_high_b_one19_n m_high_b_one19_t0 m_high_b_one19_t1 m_high_b_one19_f0_c m_high_b_one19_f0_s m_high_b_one19_fl_lo_c
  print m_high_b_one19_fl_lo_s m_high_b_one19_fl_hi_c m_high_b_one19_fl_hi_s m_high_b_one19_vce_q1_max m_high_b_one19_vce_q1_min m_high_b_one19_vce_q2_max
  print m_high_b_one19_vce_q2_min m_high_b_one19_vbe_q1_max m_high_b_one19_vbe_q1_min m_high_b_one19_vbe_q2_max m_high_b_one19_vbe_q2_min m_high_b_one19_ic_q1_max
  print m_high_b_one19_ic_q1_min m_high_b_one19_ic_q2_max m_high_b_one19_ic_q2_min
  * run high_b_one20: one-tone, available power -16 dBm per tone
  alterparam fq1 = 20950000000.0
  alterparam fq2 = 20950000000.0
  alterparam va1 = 0.100237446725454
  alterparam va2 = 0.0
  reset
  save all @q.xdut.xq1.qnpn13g2[ic] @q.xdut.xq2.qnpn13g2[ic]
  tran 1e-12 6e-08 0 1e-12
  linearize v(p2) v(xdut.c1) v(xdut.e1) v(xdut.oc) v(xdut.b1) v(xdut.b2) @q.xdut.xq1.qnpn13g2[ic] @q.xdut.xq2.qnpn13g2[ic]
  let tt = time[40000,59999]
  let xo = v(p2)[40000,59999]
  let m_high_b_one20_n = length(xo)
  let m_high_b_one20_t0 = tt[0]
  let m_high_b_one20_t1 = tt[19999]
  let m_high_b_one20_f0_c = 2*mean(xo*cos(2*pi*20950000000.0*tt))
  let m_high_b_one20_f0_s = 2*mean(xo*sin(2*pi*20950000000.0*tt))
  let m_high_b_one20_fl_lo_c = 2*mean(xo*cos(2*pi*20900000000.0*tt))
  let m_high_b_one20_fl_lo_s = 2*mean(xo*sin(2*pi*20900000000.0*tt))
  let m_high_b_one20_fl_hi_c = 2*mean(xo*cos(2*pi*21000000000.0*tt))
  let m_high_b_one20_fl_hi_s = 2*mean(xo*sin(2*pi*21000000000.0*tt))
  let m_high_b_one20_vce_q1_max = maximum(v(xdut.c1)[40000,59999] - v(xdut.e1)[40000,59999])
  let m_high_b_one20_vce_q1_min = minimum(v(xdut.c1)[40000,59999] - v(xdut.e1)[40000,59999])
  let m_high_b_one20_vce_q2_max = maximum(v(xdut.oc)[40000,59999] - v(xdut.c1)[40000,59999])
  let m_high_b_one20_vce_q2_min = minimum(v(xdut.oc)[40000,59999] - v(xdut.c1)[40000,59999])
  let m_high_b_one20_vbe_q1_max = maximum(v(xdut.b1)[40000,59999] - v(xdut.e1)[40000,59999])
  let m_high_b_one20_vbe_q1_min = minimum(v(xdut.b1)[40000,59999] - v(xdut.e1)[40000,59999])
  let m_high_b_one20_vbe_q2_max = maximum(v(xdut.b2)[40000,59999] - v(xdut.c1)[40000,59999])
  let m_high_b_one20_vbe_q2_min = minimum(v(xdut.b2)[40000,59999] - v(xdut.c1)[40000,59999])
  let w_high_b_one20_ic_q1 = @q.xdut.xq1.qnpn13g2[ic][40000,59999]
  let m_high_b_one20_ic_q1_max = maximum(w_high_b_one20_ic_q1)
  let m_high_b_one20_ic_q1_min = minimum(w_high_b_one20_ic_q1)
  let w_high_b_one20_ic_q2 = @q.xdut.xq2.qnpn13g2[ic][40000,59999]
  let m_high_b_one20_ic_q2_max = maximum(w_high_b_one20_ic_q2)
  let m_high_b_one20_ic_q2_min = minimum(w_high_b_one20_ic_q2)
  print m_high_b_one20_n m_high_b_one20_t0 m_high_b_one20_t1 m_high_b_one20_f0_c m_high_b_one20_f0_s m_high_b_one20_fl_lo_c
  print m_high_b_one20_fl_lo_s m_high_b_one20_fl_hi_c m_high_b_one20_fl_hi_s m_high_b_one20_vce_q1_max m_high_b_one20_vce_q1_min m_high_b_one20_vce_q2_max
  print m_high_b_one20_vce_q2_min m_high_b_one20_vbe_q1_max m_high_b_one20_vbe_q1_min m_high_b_one20_vbe_q2_max m_high_b_one20_vbe_q2_min m_high_b_one20_ic_q1_max
  print m_high_b_one20_ic_q1_min m_high_b_one20_ic_q2_max m_high_b_one20_ic_q2_min
  echo LNLIN_DONE
.endc
