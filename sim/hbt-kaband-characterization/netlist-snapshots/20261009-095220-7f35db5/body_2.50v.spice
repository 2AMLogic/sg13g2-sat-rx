* hbt-kaband-characterization: klt sim body, supply 2.50 V -- GENERATED by run.py, do not edit
.param vdd_val=2.5

* Ka-band npn13G2 DEVICE characterization fixture (issue #17).
*
* DEVICE-LEVEL BENCH, NOT A CIRCUIT. Two identical copies of one bare
* npn13G2 (common emitter, emitter grounded, substrate tied to ground), each
* behind ideal bias tees, sharing the same ideal regulated bias sources.
* Nothing here is a matching network, a degeneration, or a design candidate;
* numbers from this fixture are two-port device parameters (noise
* parameters, Y/S-parameters, h21) of the bare transistor and are NOT
* matched-amplifier results. See ../README.md.
*
* This file is a harness fragment (sim/harness/testbench.py rules: no
* .lib/.temp/.include/.control/.end). The bias sweep, the per-point
* analyses and every printed quantity are generated by ../kaband.py
* (build_control_lines) and appended as the deck's .control block -- either
* by sim/harness/runner.compose_deck (smoke/selftest, one PVT point per
* ngspice process) or inlined into a klt sim request body (full grid).
*
* ---- Bias (ideal regulated) ----------------------------------------------
* vbe_src / vce_src are ideal DC sources. Each copy's base and collector see
* them through an ideal 1 mH choke (2*pi*f*L = 1.1e8 ohm at 17.7 GHz, an RF
* open next to a device impedance of order 10-1000 ohm; a DC short, so the
* device terminal voltages ARE the swept values -- printed back per point as
* v(bn)/v(cn)). RF ports are AC-coupled through ideal 1 nF DC blocks
* (-0.009 ohm at 17.7 GHz).
*
* Why 1 mH / 1 nF and not the textbook "1 H / 1 F": with 1 H / 1 F (element
* impedances spanning ~23 decades at 20 GHz) ngspice-46's .noise result is
* only accurate to ~1e-3 relative -- measured: the noise-parameter fit
* residual was 1.3e-3 and the independently simulated optimum came out up to
* 0.0018 dB BELOW the fitted minimum, which no exact linear two-port can do.
* With 1 mH / 1 nF the residual is ~1e-10 and NFmin is unchanged (to 1e-5 dB)
* by a further 100x on the choke or 1000x on the block. The source chain's
* own DC block (csz) is included EXACTLY in every source impedance the
* postprocessor uses, so its small reactance is not an approximation.
*
* The DC operating point is identical in both copies; the generated control
* block prints both copies' Ic and the postprocessor rejects a point whose
* two copies disagree.
*
* ---- Supply axis ------------------------------------------------------------
* vsupply is the PVT grid's supply rail (vdd_val: 2.25 / 2.50 / 2.75 V). It
* is deliberately NOT connected to the DUT path: the bias above is an ideal
* regulator whose output (VCE, VBE) does not depend on the rail. The supply
* axis is therefore present in every deck (and its value printed per point
* as v(vsupply)), but has NO physical effect on any measured quantity in
* this bench -- by construction, not by accident. The record states this;
* no supply-sensitivity floor is attached to it.

.param nx_dut=4 vce_dut=1.0 vbe_dut=0.88

Vsupply vsupply 0 DC {vdd_val}
Rsupply vsupply 0 1meg noisy=0

vbe_src vbias_b 0 DC {vbe_dut}
vce_src vbias_c 0 DC {vce_dut}

* ---- Copy N: noise-parameter branch ------------------------------------------
* Source: vsn (AC 1, the .noise input reference) in series with a NOISELESS
* source impedance Zs = rsz + j*w*lsz + 1/(j*w*csz). noisy=0 removes the
* resistor's own thermal noise from the simulation entirely; the source's
* thermal noise is reintroduced ANALYTICALLY at an explicit T0 by the
* postprocessor (F = 1 + Sv_device / (4 k T0 Re Zs)). This replaces the
* per-instance resistor temp= convention, which does not do what it claims
* in ngspice-46 -- see ../README.md "Source-noise reference temperature"
* and testbench/resistor_noise_temp_probe.spice.
* csz doubles as the DC block (the base is biased only through lbn). The
* default element values below are placeholders; every noise analysis alters
* all three before it runs.
vsn sn 0 DC 0 AC 1
rsz sn sz1 50 noisy=0
lsz sz1 sz2 1e-15
csz sz2 bn 1n
lbn vbias_b bn 1m
xqn cn bn 0 0 npn13G2 Nx={nx_dut}
lcn vbias_c cn 1m
* Load: noiseless 50 ohm behind a DC block. The two-port noise parameters
* (Fmin, Zopt, Rn) are intrinsic to the DUT and do not depend on the load;
* the load's own noise belongs to the NEXT stage of a cascade, not to this
* device's figure, so it is excluded (noisy=0) rather than modelled at some
* assumed temperature.
con cn on 1n
rln on 0 50 noisy=0

* ---- Copy Y: Y-parameter / h21 branch ---------------------------------------
* Ideal AC voltage drive at each port through a 1 nF DC block: forward
* (vy1 AC 1, vy2 AC 0) gives y11 = -i(vy1), y21 = -i(vy2), and
* h21 = y21/y11 (the short-circuit current gain fT is read from); reverse
* (vy1 AC 0, vy2 AC 1) gives y12, y22. The generated control block alters
* the two AC magnitudes between the .ac runs.
vy1 py1 0 DC 0 AC 1
cy1 py1 by 1n
lby vbias_b by 1m
xqy cy by 0 0 npn13G2 Nx={nx_dut}
lcy vbias_c cy 1m
vy2 py2 0 DC 0 AC 0
cy2 py2 cy 1n

.control
set numdgt=10
set noaskquit
echo "KA_DECK_BEGIN"
foreach ka_nx 1 4 8
  alterparam nx_dut = $ka_nx
  reset
  foreach ka_vce 0.600 1.000 1.400
    alter vce_src dc = $ka_vce
    foreach ka_vbe 0.6000 0.6100 0.6200 0.6300 0.6400 0.6500 0.6600 0.6700 0.6800 0.6900 0.7000 0.7100 0.7200 0.7300 0.7400 0.7500 0.7600 0.7700 0.7800 0.7900 0.8000 0.8100 0.8200 0.8300 0.8400 0.8500 0.8600 0.8700 0.8800 0.8900 0.9000 0.9100 0.9200 0.9300 0.9400 0.9500 0.9600 0.9700 0.9800 0.9900 1.0000 1.0100 1.0200 1.0300 1.0400
      alter vbe_src dc = $ka_vbe
      echo "KA_POINT nx=$ka_nx vce=$ka_vce vbe=$ka_vbe"
      destroy all
      op
      echo "KA_BLOCK op"
      let ka_icn = @q.xqn.qnpn13g2[ic]
      print ka_icn
      let ka_ibn = @q.xqn.qnpn13g2[ib]
      print ka_ibn
      let ka_icy = @q.xqy.qnpn13g2[ic]
      print ka_icy
      let ka_iby = @q.xqy.qnpn13g2[ib]
      print ka_iby
      let ka_vb = v(bn)
      print ka_vb
      let ka_vc = v(cn)
      print ka_vc
      let ka_dtj = v(xqn.t)
      print ka_dtj
      let ka_vsup = v(vsupply)
      print ka_vsup
      destroy all
      alter vy1 ac = 1
      alter vy2 ac = 0
      ac lin 3 1.77e+10 2.12e+10
      echo "KA_BLOCK yfwd"
      print @q.xqy.qnpn13g2[ic]
      let ka_t1 = -i(vy1)
      let ka_t2 = -i(vy2)
      let ka_y11r_0 = real(ka_t1[0])
      print ka_y11r_0
      let ka_y11i_0 = imag(ka_t1[0])
      print ka_y11i_0
      let ka_y21r_0 = real(ka_t2[0])
      print ka_y21r_0
      let ka_y21i_0 = imag(ka_t2[0])
      print ka_y21i_0
      let ka_y11r_1 = real(ka_t1[1])
      print ka_y11r_1
      let ka_y11i_1 = imag(ka_t1[1])
      print ka_y11i_1
      let ka_y21r_1 = real(ka_t2[1])
      print ka_y21r_1
      let ka_y21i_1 = imag(ka_t2[1])
      print ka_y21i_1
      let ka_y11r_2 = real(ka_t1[2])
      print ka_y11r_2
      let ka_y11i_2 = imag(ka_t1[2])
      print ka_y11i_2
      let ka_y21r_2 = real(ka_t2[2])
      print ka_y21r_2
      let ka_y21i_2 = imag(ka_t2[2])
      print ka_y21i_2
      destroy all
      alter vy1 ac = 0
      alter vy2 ac = 1
      ac lin 3 1.77e+10 2.12e+10
      echo "KA_BLOCK yrev"
      print @q.xqy.qnpn13g2[ic]
      let ka_t1 = -i(vy1)
      let ka_t2 = -i(vy2)
      let ka_y12r_0 = real(ka_t1[0])
      print ka_y12r_0
      let ka_y12i_0 = imag(ka_t1[0])
      print ka_y12i_0
      let ka_y22r_0 = real(ka_t2[0])
      print ka_y22r_0
      let ka_y22i_0 = imag(ka_t2[0])
      print ka_y22i_0
      let ka_y12r_1 = real(ka_t1[1])
      print ka_y12r_1
      let ka_y12i_1 = imag(ka_t1[1])
      print ka_y12i_1
      let ka_y22r_1 = real(ka_t2[1])
      print ka_y22r_1
      let ka_y22i_1 = imag(ka_t2[1])
      print ka_y22i_1
      let ka_y12r_2 = real(ka_t1[2])
      print ka_y12r_2
      let ka_y12i_2 = imag(ka_t1[2])
      print ka_y12i_2
      let ka_y22r_2 = real(ka_t2[2])
      print ka_y22r_2
      let ka_y22i_2 = imag(ka_t2[2])
      print ka_y22i_2
      destroy all
      alter vy1 ac = 1
      alter vy2 ac = 0
      ac dec 10 1e9 3e12
      echo "KA_BLOCK h21"
      print @q.xqy.qnpn13g2[ic]
      let ka_h21 = mag(i(vy2)/i(vy1))
      print ka_h21
      setplot const
      unlet ka_h0 ka_h1 ka_h2 ka_h3 ka_ok ka_ro ka_lv ka_cv
      destroy all
      alter rsz = 25
      alter lsz = 1e-15
      alter csz = 1e-09
      noise v(on) vsn lin 1 1.77e+10 1.77e+10
      echo "KA_BLOCK nz f=0 z=0"
      print @q.xqn.qnpn13g2[ic]
      let ka_isp = inoise_spectrum
      print ka_isp
      set ka_pl = $curplot
      setplot const
      let ka_h0 = {$ka_pl}.inoise_spectrum
      destroy all
      alter rsz = 400
      alter lsz = 1e-15
      alter csz = 1e-09
      noise v(on) vsn lin 1 1.77e+10 1.77e+10
      echo "KA_BLOCK nz f=0 z=1"
      print @q.xqn.qnpn13g2[ic]
      let ka_isp = inoise_spectrum
      print ka_isp
      set ka_pl = $curplot
      setplot const
      let ka_h1 = {$ka_pl}.inoise_spectrum
      destroy all
      alter rsz = 25
      alter lsz = 1.798360939e-09
      alter csz = 1e-09
      noise v(on) vsn lin 1 1.77e+10 1.77e+10
      echo "KA_BLOCK nz f=0 z=2"
      print @q.xqn.qnpn13g2[ic]
      let ka_isp = inoise_spectrum
      print ka_isp
      set ka_pl = $curplot
      setplot const
      let ka_h2 = {$ka_pl}.inoise_spectrum
      destroy all
      alter rsz = 25
      alter lsz = 1e-15
      alter csz = 4.495902347e-14
      noise v(on) vsn lin 1 1.77e+10 1.77e+10
      echo "KA_BLOCK nz f=0 z=3"
      print @q.xqn.qnpn13g2[ic]
      let ka_isp = inoise_spectrum
      print ka_isp
      set ka_pl = $curplot
      setplot const
      let ka_h3 = {$ka_pl}.inoise_spectrum
      setplot const
      let ka_q0 = ka_h0*ka_h0
      let ka_q1 = ka_h1*ka_h1
      let ka_q2 = ka_h2*ka_h2
      let ka_q3 = ka_h3*ka_h3
      let ka_dd = (ka_q2 - ka_q3)/(2*200)
      let ka_bb = ((ka_q2 + ka_q3)/2 - ka_q0)/(40000)
      let ka_cc = ((ka_q1 - ka_q0) - ka_bb*(159375))/(375)
      let ka_aa = ka_q0 - ka_bb*625 - ka_cc*25
      let ka_xo = -ka_dd/(2*ka_bb)
      let ka_ap = ka_aa - ka_dd*ka_dd/(4*ka_bb)
      let ka_ok = 0
      if ka_bb > 0
        if ka_ap > 0
          let ka_ok = 1
        end
      end
      if ka_ok > 0
        let ka_ro = sqrt(ka_ap/ka_bb)
        if ka_xo > 0
          let ka_lv = ka_xo/1.112123799e+11
          let ka_cv = 1e-09
        else
          let ka_lv = 1e-15
          let ka_cv = -1/(1.112123799e+11*ka_xo)
        end
        alter rsz = ka_ro
        alter lsz = ka_lv
        alter csz = ka_cv
        destroy all
        noise v(on) vsn lin 1 1.77e+10 1.77e+10
        echo "KA_BLOCK zopt f=0"
        print @q.xqn.qnpn13g2[ic]
        let ka_isp = inoise_spectrum
        print ka_isp
        print @rsz[resistance]
        print @lsz[inductance]
        print @csz[capacitance]
      else
        echo "KA_BLOCK zopt_skip f=0"
      end
      destroy all
      alter rsz = 100
      alter lsz = 1e-15
      alter csz = 1e-09
      noise v(on) vsn lin 1 1.77e+10 1.77e+10
      echo "KA_BLOCK nz f=0 z=4"
      print @q.xqn.qnpn13g2[ic]
      let ka_isp = inoise_spectrum
      print ka_isp
      destroy all
      alter rsz = 100
      alter lsz = 1e-15
      alter csz = 8.991804694e-14
      noise v(on) vsn lin 1 1.77e+10 1.77e+10
      echo "KA_BLOCK nz f=0 z=5"
      print @q.xqn.qnpn13g2[ic]
      let ka_isp = inoise_spectrum
      print ka_isp
      destroy all
      alter rsz = 200
      alter lsz = 1.798360939e-09
      alter csz = 1e-09
      noise v(on) vsn lin 1 1.77e+10 1.77e+10
      echo "KA_BLOCK nz f=0 z=6"
      print @q.xqn.qnpn13g2[ic]
      let ka_isp = inoise_spectrum
      print ka_isp
      destroy all
      alter rsz = 50
      alter lsz = 1.348770704e-09
      alter csz = 1e-09
      noise v(on) vsn lin 1 1.77e+10 1.77e+10
      echo "KA_BLOCK nz f=0 z=7"
      print @q.xqn.qnpn13g2[ic]
      let ka_isp = inoise_spectrum
      print ka_isp
      destroy all
      alter rsz = 400
      alter lsz = 3.596721878e-09
      alter csz = 1e-09
      noise v(on) vsn lin 1 1.77e+10 1.77e+10
      echo "KA_BLOCK nz f=0 z=8"
      print @q.xqn.qnpn13g2[ic]
      let ka_isp = inoise_spectrum
      print ka_isp
      destroy all
      alter rsz = 1000
      alter lsz = 1.348770704e-08
      alter csz = 1e-09
      noise v(on) vsn lin 1 1.77e+10 1.77e+10
      echo "KA_BLOCK nz f=0 z=9"
      print @q.xqn.qnpn13g2[ic]
      let ka_isp = inoise_spectrum
      print ka_isp
      destroy all
      alter rsz = 50
      alter lsz = 1e-15
      alter csz = 1e-09
      noise v(on) vsn lin 1 1.77e+10 1.77e+10
      echo "KA_BLOCK nf50 f=0"
      print @q.xqn.qnpn13g2[ic]
      let ka_isp = inoise_spectrum
      print ka_isp
      setplot const
      unlet ka_h0 ka_h1 ka_h2 ka_h3 ka_ok ka_ro ka_lv ka_cv
      destroy all
      alter rsz = 25
      alter lsz = 1e-15
      alter csz = 1e-09
      noise v(on) vsn lin 1 1.945e+10 1.945e+10
      echo "KA_BLOCK nz f=1 z=0"
      print @q.xqn.qnpn13g2[ic]
      let ka_isp = inoise_spectrum
      print ka_isp
      set ka_pl = $curplot
      setplot const
      let ka_h0 = {$ka_pl}.inoise_spectrum
      destroy all
      alter rsz = 400
      alter lsz = 1e-15
      alter csz = 1e-09
      noise v(on) vsn lin 1 1.945e+10 1.945e+10
      echo "KA_BLOCK nz f=1 z=1"
      print @q.xqn.qnpn13g2[ic]
      let ka_isp = inoise_spectrum
      print ka_isp
      set ka_pl = $curplot
      setplot const
      let ka_h1 = {$ka_pl}.inoise_spectrum
      destroy all
      alter rsz = 25
      alter lsz = 1.636554685e-09
      alter csz = 1e-09
      noise v(on) vsn lin 1 1.945e+10 1.945e+10
      echo "KA_BLOCK nz f=1 z=2"
      print @q.xqn.qnpn13g2[ic]
      let ka_isp = inoise_spectrum
      print ka_isp
      set ka_pl = $curplot
      setplot const
      let ka_h2 = {$ka_pl}.inoise_spectrum
      destroy all
      alter rsz = 25
      alter lsz = 1e-15
      alter csz = 4.091386712e-14
      noise v(on) vsn lin 1 1.945e+10 1.945e+10
      echo "KA_BLOCK nz f=1 z=3"
      print @q.xqn.qnpn13g2[ic]
      let ka_isp = inoise_spectrum
      print ka_isp
      set ka_pl = $curplot
      setplot const
      let ka_h3 = {$ka_pl}.inoise_spectrum
      setplot const
      let ka_q0 = ka_h0*ka_h0
      let ka_q1 = ka_h1*ka_h1
      let ka_q2 = ka_h2*ka_h2
      let ka_q3 = ka_h3*ka_h3
      let ka_dd = (ka_q2 - ka_q3)/(2*200)
      let ka_bb = ((ka_q2 + ka_q3)/2 - ka_q0)/(40000)
      let ka_cc = ((ka_q1 - ka_q0) - ka_bb*(159375))/(375)
      let ka_aa = ka_q0 - ka_bb*625 - ka_cc*25
      let ka_xo = -ka_dd/(2*ka_bb)
      let ka_ap = ka_aa - ka_dd*ka_dd/(4*ka_bb)
      let ka_ok = 0
      if ka_bb > 0
        if ka_ap > 0
          let ka_ok = 1
        end
      end
      if ka_ok > 0
        let ka_ro = sqrt(ka_ap/ka_bb)
        if ka_xo > 0
          let ka_lv = ka_xo/1.222079542e+11
          let ka_cv = 1e-09
        else
          let ka_lv = 1e-15
          let ka_cv = -1/(1.222079542e+11*ka_xo)
        end
        alter rsz = ka_ro
        alter lsz = ka_lv
        alter csz = ka_cv
        destroy all
        noise v(on) vsn lin 1 1.945e+10 1.945e+10
        echo "KA_BLOCK zopt f=1"
        print @q.xqn.qnpn13g2[ic]
        let ka_isp = inoise_spectrum
        print ka_isp
        print @rsz[resistance]
        print @lsz[inductance]
        print @csz[capacitance]
      else
        echo "KA_BLOCK zopt_skip f=1"
      end
      destroy all
      alter rsz = 100
      alter lsz = 1e-15
      alter csz = 1e-09
      noise v(on) vsn lin 1 1.945e+10 1.945e+10
      echo "KA_BLOCK nz f=1 z=4"
      print @q.xqn.qnpn13g2[ic]
      let ka_isp = inoise_spectrum
      print ka_isp
      destroy all
      alter rsz = 100
      alter lsz = 1e-15
      alter csz = 8.182773424e-14
      noise v(on) vsn lin 1 1.945e+10 1.945e+10
      echo "KA_BLOCK nz f=1 z=5"
      print @q.xqn.qnpn13g2[ic]
      let ka_isp = inoise_spectrum
      print ka_isp
      destroy all
      alter rsz = 200
      alter lsz = 1.636554685e-09
      alter csz = 1e-09
      noise v(on) vsn lin 1 1.945e+10 1.945e+10
      echo "KA_BLOCK nz f=1 z=6"
      print @q.xqn.qnpn13g2[ic]
      let ka_isp = inoise_spectrum
      print ka_isp
      destroy all
      alter rsz = 50
      alter lsz = 1.227416014e-09
      alter csz = 1e-09
      noise v(on) vsn lin 1 1.945e+10 1.945e+10
      echo "KA_BLOCK nz f=1 z=7"
      print @q.xqn.qnpn13g2[ic]
      let ka_isp = inoise_spectrum
      print ka_isp
      destroy all
      alter rsz = 400
      alter lsz = 3.273109369e-09
      alter csz = 1e-09
      noise v(on) vsn lin 1 1.945e+10 1.945e+10
      echo "KA_BLOCK nz f=1 z=8"
      print @q.xqn.qnpn13g2[ic]
      let ka_isp = inoise_spectrum
      print ka_isp
      destroy all
      alter rsz = 1000
      alter lsz = 1.227416014e-08
      alter csz = 1e-09
      noise v(on) vsn lin 1 1.945e+10 1.945e+10
      echo "KA_BLOCK nz f=1 z=9"
      print @q.xqn.qnpn13g2[ic]
      let ka_isp = inoise_spectrum
      print ka_isp
      destroy all
      alter rsz = 50
      alter lsz = 1e-15
      alter csz = 1e-09
      noise v(on) vsn lin 1 1.945e+10 1.945e+10
      echo "KA_BLOCK nf50 f=1"
      print @q.xqn.qnpn13g2[ic]
      let ka_isp = inoise_spectrum
      print ka_isp
      setplot const
      unlet ka_h0 ka_h1 ka_h2 ka_h3 ka_ok ka_ro ka_lv ka_cv
      destroy all
      alter rsz = 25
      alter lsz = 1e-15
      alter csz = 1e-09
      noise v(on) vsn lin 1 2.12e+10 2.12e+10
      echo "KA_BLOCK nz f=2 z=0"
      print @q.xqn.qnpn13g2[ic]
      let ka_isp = inoise_spectrum
      print ka_isp
      set ka_pl = $curplot
      setplot const
      let ka_h0 = {$ka_pl}.inoise_spectrum
      destroy all
      alter rsz = 400
      alter lsz = 1e-15
      alter csz = 1e-09
      noise v(on) vsn lin 1 2.12e+10 2.12e+10
      echo "KA_BLOCK nz f=2 z=1"
      print @q.xqn.qnpn13g2[ic]
      let ka_isp = inoise_spectrum
      print ka_isp
      set ka_pl = $curplot
      setplot const
      let ka_h1 = {$ka_pl}.inoise_spectrum
      destroy all
      alter rsz = 25
      alter lsz = 1.501461727e-09
      alter csz = 1e-09
      noise v(on) vsn lin 1 2.12e+10 2.12e+10
      echo "KA_BLOCK nz f=2 z=2"
      print @q.xqn.qnpn13g2[ic]
      let ka_isp = inoise_spectrum
      print ka_isp
      set ka_pl = $curplot
      setplot const
      let ka_h2 = {$ka_pl}.inoise_spectrum
      destroy all
      alter rsz = 25
      alter lsz = 1e-15
      alter csz = 3.753654318e-14
      noise v(on) vsn lin 1 2.12e+10 2.12e+10
      echo "KA_BLOCK nz f=2 z=3"
      print @q.xqn.qnpn13g2[ic]
      let ka_isp = inoise_spectrum
      print ka_isp
      set ka_pl = $curplot
      setplot const
      let ka_h3 = {$ka_pl}.inoise_spectrum
      setplot const
      let ka_q0 = ka_h0*ka_h0
      let ka_q1 = ka_h1*ka_h1
      let ka_q2 = ka_h2*ka_h2
      let ka_q3 = ka_h3*ka_h3
      let ka_dd = (ka_q2 - ka_q3)/(2*200)
      let ka_bb = ((ka_q2 + ka_q3)/2 - ka_q0)/(40000)
      let ka_cc = ((ka_q1 - ka_q0) - ka_bb*(159375))/(375)
      let ka_aa = ka_q0 - ka_bb*625 - ka_cc*25
      let ka_xo = -ka_dd/(2*ka_bb)
      let ka_ap = ka_aa - ka_dd*ka_dd/(4*ka_bb)
      let ka_ok = 0
      if ka_bb > 0
        if ka_ap > 0
          let ka_ok = 1
        end
      end
      if ka_ok > 0
        let ka_ro = sqrt(ka_ap/ka_bb)
        if ka_xo > 0
          let ka_lv = ka_xo/1.332035285e+11
          let ka_cv = 1e-09
        else
          let ka_lv = 1e-15
          let ka_cv = -1/(1.332035285e+11*ka_xo)
        end
        alter rsz = ka_ro
        alter lsz = ka_lv
        alter csz = ka_cv
        destroy all
        noise v(on) vsn lin 1 2.12e+10 2.12e+10
        echo "KA_BLOCK zopt f=2"
        print @q.xqn.qnpn13g2[ic]
        let ka_isp = inoise_spectrum
        print ka_isp
        print @rsz[resistance]
        print @lsz[inductance]
        print @csz[capacitance]
      else
        echo "KA_BLOCK zopt_skip f=2"
      end
      destroy all
      alter rsz = 100
      alter lsz = 1e-15
      alter csz = 1e-09
      noise v(on) vsn lin 1 2.12e+10 2.12e+10
      echo "KA_BLOCK nz f=2 z=4"
      print @q.xqn.qnpn13g2[ic]
      let ka_isp = inoise_spectrum
      print ka_isp
      destroy all
      alter rsz = 100
      alter lsz = 1e-15
      alter csz = 7.507308636e-14
      noise v(on) vsn lin 1 2.12e+10 2.12e+10
      echo "KA_BLOCK nz f=2 z=5"
      print @q.xqn.qnpn13g2[ic]
      let ka_isp = inoise_spectrum
      print ka_isp
      destroy all
      alter rsz = 200
      alter lsz = 1.501461727e-09
      alter csz = 1e-09
      noise v(on) vsn lin 1 2.12e+10 2.12e+10
      echo "KA_BLOCK nz f=2 z=6"
      print @q.xqn.qnpn13g2[ic]
      let ka_isp = inoise_spectrum
      print ka_isp
      destroy all
      alter rsz = 50
      alter lsz = 1.126096295e-09
      alter csz = 1e-09
      noise v(on) vsn lin 1 2.12e+10 2.12e+10
      echo "KA_BLOCK nz f=2 z=7"
      print @q.xqn.qnpn13g2[ic]
      let ka_isp = inoise_spectrum
      print ka_isp
      destroy all
      alter rsz = 400
      alter lsz = 3.002923455e-09
      alter csz = 1e-09
      noise v(on) vsn lin 1 2.12e+10 2.12e+10
      echo "KA_BLOCK nz f=2 z=8"
      print @q.xqn.qnpn13g2[ic]
      let ka_isp = inoise_spectrum
      print ka_isp
      destroy all
      alter rsz = 1000
      alter lsz = 1.126096295e-08
      alter csz = 1e-09
      noise v(on) vsn lin 1 2.12e+10 2.12e+10
      echo "KA_BLOCK nz f=2 z=9"
      print @q.xqn.qnpn13g2[ic]
      let ka_isp = inoise_spectrum
      print ka_isp
      destroy all
      alter rsz = 50
      alter lsz = 1e-15
      alter csz = 1e-09
      noise v(on) vsn lin 1 2.12e+10 2.12e+10
      echo "KA_BLOCK nf50 f=2"
      print @q.xqn.qnpn13g2[ic]
      let ka_isp = inoise_spectrum
      print ka_isp
    end
  end
end
echo "KA_DECK_END"
alterparam nx_dut = 1
reset
.endc
