* Ka-band npn13G2 DEVICE characterization fixture (issue #17).
*
* DEVICE-LEVEL BENCH, NOT A CIRCUIT. Two identical copies of one bare
* npn13G2 (common emitter, emitter grounded, substrate tied to ground), each
* behind ideal bias tees, sharing the same ideal regulated bias sources.
* Nothing here is a matching network, a degeneration, or a design candidate;
* numbers from this fixture are two-port device parameters (noise
* parameters, Y/S-parameters, h21) of the bare transistor and are NOT
* matched-amplifier results. See ../README.md.
*
* This file is a harness fragment (sim/harness/testbench.py rules: no
* .lib/.temp/.include/.control/.end). The bias sweep, the per-point
* analyses and every printed quantity are generated by ../kaband.py
* (build_control_lines) and appended as the deck's .control block -- either
* by sim/harness/runner.compose_deck (smoke/selftest, one PVT point per
* ngspice process) or inlined into a klt sim request body (full grid).
*
* ---- Bias (ideal regulated) ----------------------------------------------
* vbe_src / vce_src are ideal DC sources. Each copy's base and collector see
* them through an ideal 1 mH choke (2*pi*f*L = 1.1e8 ohm at 17.7 GHz, an RF
* open next to a device impedance of order 10-1000 ohm; a DC short, so the
* device terminal voltages ARE the swept values -- printed back per point as
* v(bn)/v(cn)). RF ports are AC-coupled through ideal 1 nF DC blocks
* (-0.009 ohm at 17.7 GHz).
*
* Why 1 mH / 1 nF and not the textbook "1 H / 1 F": with 1 H / 1 F (element
* impedances spanning ~23 decades at 20 GHz) ngspice-46's .noise result is
* only accurate to ~1e-3 relative -- measured: the noise-parameter fit
* residual was 1.3e-3 and the independently simulated optimum came out up to
* 0.0018 dB BELOW the fitted minimum, which no exact linear two-port can do.
* With 1 mH / 1 nF the residual is ~1e-10 and NFmin is unchanged (to 1e-5 dB)
* by a further 100x on the choke or 1000x on the block. The source chain's
* own DC block (csz) is included EXACTLY in every source impedance the
* postprocessor uses, so its small reactance is not an approximation.
*
* The DC operating point is identical in both copies; the generated control
* block prints both copies' Ic and the postprocessor rejects a point whose
* two copies disagree.
*
* ---- Supply axis ------------------------------------------------------------
* vsupply is the PVT grid's supply rail (vdd_val: 2.25 / 2.50 / 2.75 V). It
* is deliberately NOT connected to the DUT path: the bias above is an ideal
* regulator whose output (VCE, VBE) does not depend on the rail. The supply
* axis is therefore present in every deck (and its value printed per point
* as v(vsupply)), but has NO physical effect on any measured quantity in
* this bench -- by construction, not by accident. The record states this;
* no supply-sensitivity floor is attached to it.

.param nx_dut=4 vce_dut=1.0 vbe_dut=0.88

Vsupply vsupply 0 DC {vdd_val}
Rsupply vsupply 0 1meg noisy=0

vbe_src vbias_b 0 DC {vbe_dut}
vce_src vbias_c 0 DC {vce_dut}

* ---- Copy N: noise-parameter branch ------------------------------------------
* Source: vsn (AC 1, the .noise input reference) in series with a NOISELESS
* source impedance Zs = rsz + j*w*lsz + 1/(j*w*csz). noisy=0 removes the
* resistor's own thermal noise from the simulation entirely; the source's
* thermal noise is reintroduced ANALYTICALLY at an explicit T0 by the
* postprocessor (F = 1 + Sv_device / (4 k T0 Re Zs)). This replaces the
* per-instance resistor temp= convention, which does not do what it claims
* in ngspice-46 -- see ../README.md "Source-noise reference temperature"
* and testbench/resistor_noise_temp_probe.spice.
* csz doubles as the DC block (the base is biased only through lbn). The
* default element values below are placeholders; every noise analysis alters
* all three before it runs.
vsn sn 0 DC 0 AC 1
rsz sn sz1 50 noisy=0
lsz sz1 sz2 1e-15
csz sz2 bn 1n
lbn vbias_b bn 1m
xqn cn bn 0 0 npn13G2 Nx={nx_dut}
lcn vbias_c cn 1m
* Load: noiseless 50 ohm behind a DC block. The two-port noise parameters
* (Fmin, Zopt, Rn) are intrinsic to the DUT and do not depend on the load;
* the load's own noise belongs to the NEXT stage of a cascade, not to this
* device's figure, so it is excluded (noisy=0) rather than modelled at some
* assumed temperature.
con cn on 1n
rln on 0 50 noisy=0

* ---- Copy Y: Y-parameter / h21 branch ---------------------------------------
* Ideal AC voltage drive at each port through a 1 nF DC block: forward
* (vy1 AC 1, vy2 AC 0) gives y11 = -i(vy1), y21 = -i(vy2), and
* h21 = y21/y11 (the short-circuit current gain fT is read from); reverse
* (vy1 AC 0, vy2 AC 1) gives y12, y22. The generated control block alters
* the two AC magnitudes between the .ac runs.
vy1 py1 0 DC 0 AC 1
cy1 py1 by 1n
lby vbias_b by 1m
xqy cy by 0 0 npn13G2 Nx={nx_dut}
lcy vbias_c cy 1m
vy2 py2 0 DC 0 AC 0
cy2 py2 cy 1n
