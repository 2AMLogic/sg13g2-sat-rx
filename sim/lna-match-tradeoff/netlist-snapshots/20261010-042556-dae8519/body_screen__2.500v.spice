* lna-match-tradeoff: screen__2.500v (klt sim body) -- GENERATED by matchstudy.py, do not edit
.param vdd_val=2.5
.param mag1=1 mag2=0
.param c_sh1=1.7e-13
.param l_in=1.41e-09
.param c_sh2=0.0

* ==== BEGIN design/netlist/lna_stage1.spice, input network parameterized ====
* lna_stage1 subcircuit, exported by xschem from design/lna_stage1.sch via 'klt netlist --block'
* tools: XSCHEM V3.4.4; klt 0.7.0+g5e5b55992a7f; sources sha256 (lna_stage1.sch then lna_stage1.sym concatenated): c1a3c91f0ec775b4287c195dee05f305f8b1bf34e5b6ee27e83021a884ff46d4
* DERIVED FILE: regenerate with design/export_netlist.sh, never edit by hand.
* Matching elements (Cshunt, Lin, Lfeed, Cm) are IDEAL lossless L/C: no PDK inductor model exists.
** sch_path: design/lna_stage1.sch
.subckt lna_stage1 in out vdd gnd
*.ipin in
*.opin out
*.iopin vdd
*.iopin gnd
Rref vdd nr 8k m=1
Xqr nr nr er gnd npn13G2 Nx=1
Rer er gnd 24 m=1
Rbias nr b1 2k m=1
Lfeed vdd oc 0.962n m=1
Rd vdd oc 465 m=1
Xq2 oc b2 c1 gnd npn13G2 Nx=8
Xq1 c1 b1 e1 gnd npn13G2 Nx=8
Re1 e1 gnd 3 m=1
R1b vdd b2 1.5k m=1
R2b b2 gnd 7k m=1
Cb2 b2 gnd 10p m=1
Cshunt in gnd {c_sh1} m=1
Lin in in2 {l_in} m=1
Csh2 in2 gnd {c_sh2} m=1
Cblk_in in2 b1 1n m=1
Cm oc out 57.8f m=1
.ends
* ==== END design/netlist/lna_stage1.spice ====

* ---- two-port test fixture (method of sim/lna-sparam-nf/testbench/lna_stage1.spice) ----
* Power-wave injection through a Thevenin z0 source per port; forward /
* reverse by alterparam mag1/mag2 + reset. Rs1 is NOISELESS: the source
* noise is added analytically at T0 (F = 1 + inoise^2 / (4 k T0 z0)).
.param z0=50
Vdd vdd 0 DC {vdd_val}
Xdut p1 p2 vdd 0 lna_stage1
Vs1 s1n 0 DC 0 AC {mag1}
Rs1 s1n p1 {z0} noisy=0
Vs2 s2n 0 DC 0 AC {mag2}
Rs2 s2n p2 {z0}

.control
set noaskquit
set width = 250
set height = 1000000
set numdgt = 10
alterparam c_sh1 = 1.7e-13
alterparam l_in = 1.41e-09
alterparam c_sh2 = 0.0
alterparam mag1 = 1
alterparam mag2 = 0
reset
op
let m_op_q1_vce = v(xdut.c1) - v(xdut.e1)
let m_op_q1_vbe = v(xdut.b1) - v(xdut.e1)
let m_op_q1_ic = @q.xdut.xq1.qnpn13g2[ic]
let m_op_q1_icfrac = @q.xdut.xq1.qnpn13g2[ic]/(3e-3*8)
let m_op_q1_dtj = v(xdut.xq1.t)
let m_op_q1_ft = @q.xdut.xq1.qnpn13g2[gm]/(2*3.14159265358979*(@q.xdut.xq1.qnpn13g2[cbe]+@q.xdut.xq1.qnpn13g2[cbex]+@q.xdut.xq1.qnpn13g2[cbc]+@q.xdut.xq1.qnpn13g2[cbcx]+@q.xdut.xq1.qnpn13g2[cbep]+@q.xdut.xq1.qnpn13g2[cbcp]))/1e9
let m_op_q2_vce = v(xdut.oc) - v(xdut.c1)
let m_op_q2_vbe = v(xdut.b2) - v(xdut.c1)
let m_op_q2_ic = @q.xdut.xq2.qnpn13g2[ic]
let m_op_q2_icfrac = @q.xdut.xq2.qnpn13g2[ic]/(3e-3*8)
let m_op_q2_dtj = v(xdut.xq2.t)
let m_op_q2_ft = @q.xdut.xq2.qnpn13g2[gm]/(2*3.14159265358979*(@q.xdut.xq2.qnpn13g2[cbe]+@q.xdut.xq2.qnpn13g2[cbex]+@q.xdut.xq2.qnpn13g2[cbc]+@q.xdut.xq2.qnpn13g2[cbcx]+@q.xdut.xq2.qnpn13g2[cbep]+@q.xdut.xq2.qnpn13g2[cbcp]))/1e9
let m_op_qr_vce = v(xdut.nr) - v(xdut.er)
let m_op_qr_vbe = v(xdut.nr) - v(xdut.er)
let m_op_qr_ic = @q.xdut.xqr.qnpn13g2[ic]
let m_op_qr_icfrac = @q.xdut.xqr.qnpn13g2[ic]/(3e-3*1)
let m_op_qr_dtj = v(xdut.xqr.t)
let m_op_qr_ft = @q.xdut.xqr.qnpn13g2[gm]/(2*3.14159265358979*(@q.xdut.xqr.qnpn13g2[cbe]+@q.xdut.xqr.qnpn13g2[cbex]+@q.xdut.xqr.qnpn13g2[cbc]+@q.xdut.xqr.qnpn13g2[cbcx]+@q.xdut.xqr.qnpn13g2[cbep]+@q.xdut.xqr.qnpn13g2[cbcp]))/1e9
let m_op_idd_ma = -i(vdd)*1e3
let m_op_pdc_mw = -i(vdd)*v(vdd)*1e3
print m_op_q1_vce
print m_op_q1_vbe
print m_op_q1_ic
print m_op_q1_icfrac
print m_op_q1_dtj
print m_op_q1_ft
print m_op_q2_vce
print m_op_q2_vbe
print m_op_q2_ic
print m_op_q2_icfrac
print m_op_q2_dtj
print m_op_q2_ft
print m_op_qr_vce
print m_op_qr_vbe
print m_op_qr_ic
print m_op_qr_icfrac
print m_op_qr_dtj
print m_op_qr_ft
print m_op_idd_ma
print m_op_pdc_mw
destroy all
alterparam c_sh1 = 1.7e-13
alterparam l_in = 1.41e-09
alterparam c_sh2 = 0.0
alterparam mag1 = 1
alterparam mag2 = 0
reset
ac lin 71 17700000000.0 21200000000.0
echo LM_BEGIN baseline fwd_dense
print real(v(p1)) imag(v(p1)) real(v(p2)) imag(v(p2))
echo LM_END baseline fwd_dense
noise v(p2) vs1 lin 71 17700000000.0 21200000000.0
setplot previous
echo LM_BEGIN baseline noise_dense
print inoise_spectrum
echo LM_END baseline noise_dense
ac lin 70 17725000000.0 21175000000.0
echo LM_BEGIN baseline fwd_mid
print real(v(p1)) imag(v(p1)) real(v(p2)) imag(v(p2))
echo LM_END baseline fwd_mid
noise v(p2) vs1 lin 70 17725000000.0 21175000000.0
setplot previous
echo LM_BEGIN baseline noise_mid
print inoise_spectrum
echo LM_END baseline noise_mid
ac dec 100 1000000000.0 100000000000.0
echo LM_BEGIN baseline fwd_wide
print real(v(p1)) imag(v(p1)) real(v(p2)) imag(v(p2))
echo LM_END baseline fwd_wide
destroy all
alterparam mag1 = 0
alterparam mag2 = 1
reset
ac lin 71 17700000000.0 21200000000.0
echo LM_BEGIN baseline rev_dense
print real(v(p1)) imag(v(p1)) real(v(p2)) imag(v(p2))
echo LM_END baseline rev_dense
ac lin 70 17725000000.0 21175000000.0
echo LM_BEGIN baseline rev_mid
print real(v(p1)) imag(v(p1)) real(v(p2)) imag(v(p2))
echo LM_END baseline rev_mid
ac dec 100 1000000000.0 100000000000.0
echo LM_BEGIN baseline rev_wide
print real(v(p1)) imag(v(p1)) real(v(p2)) imag(v(p2))
echo LM_END baseline rev_wide
destroy all
alterparam c_sh1 = 1.851e-13
alterparam l_in = 1.39e-09
alterparam c_sh2 = 0.0
alterparam mag1 = 1
alterparam mag2 = 0
reset
ac lin 71 17700000000.0 21200000000.0
echo LM_BEGIN seg0000_a fwd_dense
print real(v(p1)) imag(v(p1)) real(v(p2)) imag(v(p2))
echo LM_END seg0000_a fwd_dense
noise v(p2) vs1 lin 71 17700000000.0 21200000000.0
setplot previous
echo LM_BEGIN seg0000_a noise_dense
print inoise_spectrum
echo LM_END seg0000_a noise_dense
ac lin 70 17725000000.0 21175000000.0
echo LM_BEGIN seg0000_a fwd_mid
print real(v(p1)) imag(v(p1)) real(v(p2)) imag(v(p2))
echo LM_END seg0000_a fwd_mid
noise v(p2) vs1 lin 70 17725000000.0 21175000000.0
setplot previous
echo LM_BEGIN seg0000_a noise_mid
print inoise_spectrum
echo LM_END seg0000_a noise_mid
ac dec 100 1000000000.0 100000000000.0
echo LM_BEGIN seg0000_a fwd_wide
print real(v(p1)) imag(v(p1)) real(v(p2)) imag(v(p2))
echo LM_END seg0000_a fwd_wide
destroy all
alterparam mag1 = 0
alterparam mag2 = 1
reset
ac lin 71 17700000000.0 21200000000.0
echo LM_BEGIN seg0000_a rev_dense
print real(v(p1)) imag(v(p1)) real(v(p2)) imag(v(p2))
echo LM_END seg0000_a rev_dense
ac lin 70 17725000000.0 21175000000.0
echo LM_BEGIN seg0000_a rev_mid
print real(v(p1)) imag(v(p1)) real(v(p2)) imag(v(p2))
echo LM_END seg0000_a rev_mid
ac dec 100 1000000000.0 100000000000.0
echo LM_BEGIN seg0000_a rev_wide
print real(v(p1)) imag(v(p1)) real(v(p2)) imag(v(p2))
echo LM_END seg0000_a rev_wide
destroy all
alterparam c_sh1 = 1.104e-13
alterparam l_in = 1.4e-09
alterparam c_sh2 = 0.0
alterparam mag1 = 1
alterparam mag2 = 0
reset
ac lin 71 17700000000.0 21200000000.0
echo LM_BEGIN seg0125_a fwd_dense
print real(v(p1)) imag(v(p1)) real(v(p2)) imag(v(p2))
echo LM_END seg0125_a fwd_dense
noise v(p2) vs1 lin 71 17700000000.0 21200000000.0
setplot previous
echo LM_BEGIN seg0125_a noise_dense
print inoise_spectrum
echo LM_END seg0125_a noise_dense
ac lin 70 17725000000.0 21175000000.0
echo LM_BEGIN seg0125_a fwd_mid
print real(v(p1)) imag(v(p1)) real(v(p2)) imag(v(p2))
echo LM_END seg0125_a fwd_mid
noise v(p2) vs1 lin 70 17725000000.0 21175000000.0
setplot previous
echo LM_BEGIN seg0125_a noise_mid
print inoise_spectrum
echo LM_END seg0125_a noise_mid
ac dec 100 1000000000.0 100000000000.0
echo LM_BEGIN seg0125_a fwd_wide
print real(v(p1)) imag(v(p1)) real(v(p2)) imag(v(p2))
echo LM_END seg0125_a fwd_wide
destroy all
alterparam mag1 = 0
alterparam mag2 = 1
reset
ac lin 71 17700000000.0 21200000000.0
echo LM_BEGIN seg0125_a rev_dense
print real(v(p1)) imag(v(p1)) real(v(p2)) imag(v(p2))
echo LM_END seg0125_a rev_dense
ac lin 70 17725000000.0 21175000000.0
echo LM_BEGIN seg0125_a rev_mid
print real(v(p1)) imag(v(p1)) real(v(p2)) imag(v(p2))
echo LM_END seg0125_a rev_mid
ac dec 100 1000000000.0 100000000000.0
echo LM_BEGIN seg0125_a rev_wide
print real(v(p1)) imag(v(p1)) real(v(p2)) imag(v(p2))
echo LM_END seg0125_a rev_wide
destroy all
alterparam c_sh1 = 2.958e-14
alterparam l_in = 1.295e-09
alterparam c_sh2 = 0.0
alterparam mag1 = 1
alterparam mag2 = 0
reset
ac lin 71 17700000000.0 21200000000.0
echo LM_BEGIN seg0250_a fwd_dense
print real(v(p1)) imag(v(p1)) real(v(p2)) imag(v(p2))
echo LM_END seg0250_a fwd_dense
noise v(p2) vs1 lin 71 17700000000.0 21200000000.0
setplot previous
echo LM_BEGIN seg0250_a noise_dense
print inoise_spectrum
echo LM_END seg0250_a noise_dense
ac lin 70 17725000000.0 21175000000.0
echo LM_BEGIN seg0250_a fwd_mid
print real(v(p1)) imag(v(p1)) real(v(p2)) imag(v(p2))
echo LM_END seg0250_a fwd_mid
noise v(p2) vs1 lin 70 17725000000.0 21175000000.0
setplot previous
echo LM_BEGIN seg0250_a noise_mid
print inoise_spectrum
echo LM_END seg0250_a noise_mid
ac dec 100 1000000000.0 100000000000.0
echo LM_BEGIN seg0250_a fwd_wide
print real(v(p1)) imag(v(p1)) real(v(p2)) imag(v(p2))
echo LM_END seg0250_a fwd_wide
destroy all
alterparam mag1 = 0
alterparam mag2 = 1
reset
ac lin 71 17700000000.0 21200000000.0
echo LM_BEGIN seg0250_a rev_dense
print real(v(p1)) imag(v(p1)) real(v(p2)) imag(v(p2))
echo LM_END seg0250_a rev_dense
ac lin 70 17725000000.0 21175000000.0
echo LM_BEGIN seg0250_a rev_mid
print real(v(p1)) imag(v(p1)) real(v(p2)) imag(v(p2))
echo LM_END seg0250_a rev_mid
ac dec 100 1000000000.0 100000000000.0
echo LM_BEGIN seg0250_a rev_wide
print real(v(p1)) imag(v(p1)) real(v(p2)) imag(v(p2))
echo LM_END seg0250_a rev_wide
destroy all
alterparam c_sh1 = 0.0
alterparam l_in = 1.101e-09
alterparam c_sh2 = 7.128e-15
alterparam mag1 = 1
alterparam mag2 = 0
reset
ac lin 71 17700000000.0 21200000000.0
echo LM_BEGIN seg0375_b fwd_dense
print real(v(p1)) imag(v(p1)) real(v(p2)) imag(v(p2))
echo LM_END seg0375_b fwd_dense
noise v(p2) vs1 lin 71 17700000000.0 21200000000.0
setplot previous
echo LM_BEGIN seg0375_b noise_dense
print inoise_spectrum
echo LM_END seg0375_b noise_dense
ac lin 70 17725000000.0 21175000000.0
echo LM_BEGIN seg0375_b fwd_mid
print real(v(p1)) imag(v(p1)) real(v(p2)) imag(v(p2))
echo LM_END seg0375_b fwd_mid
noise v(p2) vs1 lin 70 17725000000.0 21175000000.0
setplot previous
echo LM_BEGIN seg0375_b noise_mid
print inoise_spectrum
echo LM_END seg0375_b noise_mid
ac dec 100 1000000000.0 100000000000.0
echo LM_BEGIN seg0375_b fwd_wide
print real(v(p1)) imag(v(p1)) real(v(p2)) imag(v(p2))
echo LM_END seg0375_b fwd_wide
destroy all
alterparam mag1 = 0
alterparam mag2 = 1
reset
ac lin 71 17700000000.0 21200000000.0
echo LM_BEGIN seg0375_b rev_dense
print real(v(p1)) imag(v(p1)) real(v(p2)) imag(v(p2))
echo LM_END seg0375_b rev_dense
ac lin 70 17725000000.0 21175000000.0
echo LM_BEGIN seg0375_b rev_mid
print real(v(p1)) imag(v(p1)) real(v(p2)) imag(v(p2))
echo LM_END seg0375_b rev_mid
ac dec 100 1000000000.0 100000000000.0
echo LM_BEGIN seg0375_b rev_wide
print real(v(p1)) imag(v(p1)) real(v(p2)) imag(v(p2))
echo LM_END seg0375_b rev_wide
destroy all
alterparam c_sh1 = 0.0
alterparam l_in = 9.948e-10
alterparam c_sh2 = 1.472e-14
alterparam mag1 = 1
alterparam mag2 = 0
reset
ac lin 71 17700000000.0 21200000000.0
echo LM_BEGIN seg0500_b fwd_dense
print real(v(p1)) imag(v(p1)) real(v(p2)) imag(v(p2))
echo LM_END seg0500_b fwd_dense
noise v(p2) vs1 lin 71 17700000000.0 21200000000.0
setplot previous
echo LM_BEGIN seg0500_b noise_dense
print inoise_spectrum
echo LM_END seg0500_b noise_dense
ac lin 70 17725000000.0 21175000000.0
echo LM_BEGIN seg0500_b fwd_mid
print real(v(p1)) imag(v(p1)) real(v(p2)) imag(v(p2))
echo LM_END seg0500_b fwd_mid
noise v(p2) vs1 lin 70 17725000000.0 21175000000.0
setplot previous
echo LM_BEGIN seg0500_b noise_mid
print inoise_spectrum
echo LM_END seg0500_b noise_mid
ac dec 100 1000000000.0 100000000000.0
echo LM_BEGIN seg0500_b fwd_wide
print real(v(p1)) imag(v(p1)) real(v(p2)) imag(v(p2))
echo LM_END seg0500_b fwd_wide
destroy all
alterparam mag1 = 0
alterparam mag2 = 1
reset
ac lin 71 17700000000.0 21200000000.0
echo LM_BEGIN seg0500_b rev_dense
print real(v(p1)) imag(v(p1)) real(v(p2)) imag(v(p2))
echo LM_END seg0500_b rev_dense
ac lin 70 17725000000.0 21175000000.0
echo LM_BEGIN seg0500_b rev_mid
print real(v(p1)) imag(v(p1)) real(v(p2)) imag(v(p2))
echo LM_END seg0500_b rev_mid
ac dec 100 1000000000.0 100000000000.0
echo LM_BEGIN seg0500_b rev_wide
print real(v(p1)) imag(v(p1)) real(v(p2)) imag(v(p2))
echo LM_END seg0500_b rev_wide
destroy all
alterparam c_sh1 = 0.0
alterparam l_in = 9.118e-10
alterparam c_sh2 = 2.203e-14
alterparam mag1 = 1
alterparam mag2 = 0
reset
ac lin 71 17700000000.0 21200000000.0
echo LM_BEGIN seg0625_b fwd_dense
print real(v(p1)) imag(v(p1)) real(v(p2)) imag(v(p2))
echo LM_END seg0625_b fwd_dense
noise v(p2) vs1 lin 71 17700000000.0 21200000000.0
setplot previous
echo LM_BEGIN seg0625_b noise_dense
print inoise_spectrum
echo LM_END seg0625_b noise_dense
ac lin 70 17725000000.0 21175000000.0
echo LM_BEGIN seg0625_b fwd_mid
print real(v(p1)) imag(v(p1)) real(v(p2)) imag(v(p2))
echo LM_END seg0625_b fwd_mid
noise v(p2) vs1 lin 70 17725000000.0 21175000000.0
setplot previous
echo LM_BEGIN seg0625_b noise_mid
print inoise_spectrum
echo LM_END seg0625_b noise_mid
ac dec 100 1000000000.0 100000000000.0
echo LM_BEGIN seg0625_b fwd_wide
print real(v(p1)) imag(v(p1)) real(v(p2)) imag(v(p2))
echo LM_END seg0625_b fwd_wide
destroy all
alterparam mag1 = 0
alterparam mag2 = 1
reset
ac lin 71 17700000000.0 21200000000.0
echo LM_BEGIN seg0625_b rev_dense
print real(v(p1)) imag(v(p1)) real(v(p2)) imag(v(p2))
echo LM_END seg0625_b rev_dense
ac lin 70 17725000000.0 21175000000.0
echo LM_BEGIN seg0625_b rev_mid
print real(v(p1)) imag(v(p1)) real(v(p2)) imag(v(p2))
echo LM_END seg0625_b rev_mid
ac dec 100 1000000000.0 100000000000.0
echo LM_BEGIN seg0625_b rev_wide
print real(v(p1)) imag(v(p1)) real(v(p2)) imag(v(p2))
echo LM_END seg0625_b rev_wide
destroy all
alterparam c_sh1 = 0.0
alterparam l_in = 8.445e-10
alterparam c_sh2 = 2.916e-14
alterparam mag1 = 1
alterparam mag2 = 0
reset
ac lin 71 17700000000.0 21200000000.0
echo LM_BEGIN seg0750_b fwd_dense
print real(v(p1)) imag(v(p1)) real(v(p2)) imag(v(p2))
echo LM_END seg0750_b fwd_dense
noise v(p2) vs1 lin 71 17700000000.0 21200000000.0
setplot previous
echo LM_BEGIN seg0750_b noise_dense
print inoise_spectrum
echo LM_END seg0750_b noise_dense
ac lin 70 17725000000.0 21175000000.0
echo LM_BEGIN seg0750_b fwd_mid
print real(v(p1)) imag(v(p1)) real(v(p2)) imag(v(p2))
echo LM_END seg0750_b fwd_mid
noise v(p2) vs1 lin 70 17725000000.0 21175000000.0
setplot previous
echo LM_BEGIN seg0750_b noise_mid
print inoise_spectrum
echo LM_END seg0750_b noise_mid
ac dec 100 1000000000.0 100000000000.0
echo LM_BEGIN seg0750_b fwd_wide
print real(v(p1)) imag(v(p1)) real(v(p2)) imag(v(p2))
echo LM_END seg0750_b fwd_wide
destroy all
alterparam mag1 = 0
alterparam mag2 = 1
reset
ac lin 71 17700000000.0 21200000000.0
echo LM_BEGIN seg0750_b rev_dense
print real(v(p1)) imag(v(p1)) real(v(p2)) imag(v(p2))
echo LM_END seg0750_b rev_dense
ac lin 70 17725000000.0 21175000000.0
echo LM_BEGIN seg0750_b rev_mid
print real(v(p1)) imag(v(p1)) real(v(p2)) imag(v(p2))
echo LM_END seg0750_b rev_mid
ac dec 100 1000000000.0 100000000000.0
echo LM_BEGIN seg0750_b rev_wide
print real(v(p1)) imag(v(p1)) real(v(p2)) imag(v(p2))
echo LM_END seg0750_b rev_wide
destroy all
alterparam c_sh1 = 0.0
alterparam l_in = 7.888e-10
alterparam c_sh2 = 3.617e-14
alterparam mag1 = 1
alterparam mag2 = 0
reset
ac lin 71 17700000000.0 21200000000.0
echo LM_BEGIN seg0875_b fwd_dense
print real(v(p1)) imag(v(p1)) real(v(p2)) imag(v(p2))
echo LM_END seg0875_b fwd_dense
noise v(p2) vs1 lin 71 17700000000.0 21200000000.0
setplot previous
echo LM_BEGIN seg0875_b noise_dense
print inoise_spectrum
echo LM_END seg0875_b noise_dense
ac lin 70 17725000000.0 21175000000.0
echo LM_BEGIN seg0875_b fwd_mid
print real(v(p1)) imag(v(p1)) real(v(p2)) imag(v(p2))
echo LM_END seg0875_b fwd_mid
noise v(p2) vs1 lin 70 17725000000.0 21175000000.0
setplot previous
echo LM_BEGIN seg0875_b noise_mid
print inoise_spectrum
echo LM_END seg0875_b noise_mid
ac dec 100 1000000000.0 100000000000.0
echo LM_BEGIN seg0875_b fwd_wide
print real(v(p1)) imag(v(p1)) real(v(p2)) imag(v(p2))
echo LM_END seg0875_b fwd_wide
destroy all
alterparam mag1 = 0
alterparam mag2 = 1
reset
ac lin 71 17700000000.0 21200000000.0
echo LM_BEGIN seg0875_b rev_dense
print real(v(p1)) imag(v(p1)) real(v(p2)) imag(v(p2))
echo LM_END seg0875_b rev_dense
ac lin 70 17725000000.0 21175000000.0
echo LM_BEGIN seg0875_b rev_mid
print real(v(p1)) imag(v(p1)) real(v(p2)) imag(v(p2))
echo LM_END seg0875_b rev_mid
ac dec 100 1000000000.0 100000000000.0
echo LM_BEGIN seg0875_b rev_wide
print real(v(p1)) imag(v(p1)) real(v(p2)) imag(v(p2))
echo LM_END seg0875_b rev_wide
destroy all
alterparam c_sh1 = 0.0
alterparam l_in = 7.42e-10
alterparam c_sh2 = 4.311e-14
alterparam mag1 = 1
alterparam mag2 = 0
reset
ac lin 71 17700000000.0 21200000000.0
echo LM_BEGIN seg1000_b fwd_dense
print real(v(p1)) imag(v(p1)) real(v(p2)) imag(v(p2))
echo LM_END seg1000_b fwd_dense
noise v(p2) vs1 lin 71 17700000000.0 21200000000.0
setplot previous
echo LM_BEGIN seg1000_b noise_dense
print inoise_spectrum
echo LM_END seg1000_b noise_dense
ac lin 70 17725000000.0 21175000000.0
echo LM_BEGIN seg1000_b fwd_mid
print real(v(p1)) imag(v(p1)) real(v(p2)) imag(v(p2))
echo LM_END seg1000_b fwd_mid
noise v(p2) vs1 lin 70 17725000000.0 21175000000.0
setplot previous
echo LM_BEGIN seg1000_b noise_mid
print inoise_spectrum
echo LM_END seg1000_b noise_mid
ac dec 100 1000000000.0 100000000000.0
echo LM_BEGIN seg1000_b fwd_wide
print real(v(p1)) imag(v(p1)) real(v(p2)) imag(v(p2))
echo LM_END seg1000_b fwd_wide
destroy all
alterparam mag1 = 0
alterparam mag2 = 1
reset
ac lin 71 17700000000.0 21200000000.0
echo LM_BEGIN seg1000_b rev_dense
print real(v(p1)) imag(v(p1)) real(v(p2)) imag(v(p2))
echo LM_END seg1000_b rev_dense
ac lin 70 17725000000.0 21175000000.0
echo LM_BEGIN seg1000_b rev_mid
print real(v(p1)) imag(v(p1)) real(v(p2)) imag(v(p2))
echo LM_END seg1000_b rev_mid
ac dec 100 1000000000.0 100000000000.0
echo LM_BEGIN seg1000_b rev_wide
print real(v(p1)) imag(v(p1)) real(v(p2)) imag(v(p2))
echo LM_END seg1000_b rev_wide
destroy all
alterparam c_sh1 = 0.0
alterparam l_in = 9.285e-10
alterparam c_sh2 = 3.725e-14
alterparam mag1 = 1
alterparam mag2 = 0
reset
ac lin 71 17700000000.0 21200000000.0
echo LM_BEGIN optr10a000_b fwd_dense
print real(v(p1)) imag(v(p1)) real(v(p2)) imag(v(p2))
echo LM_END optr10a000_b fwd_dense
noise v(p2) vs1 lin 71 17700000000.0 21200000000.0
setplot previous
echo LM_BEGIN optr10a000_b noise_dense
print inoise_spectrum
echo LM_END optr10a000_b noise_dense
ac lin 70 17725000000.0 21175000000.0
echo LM_BEGIN optr10a000_b fwd_mid
print real(v(p1)) imag(v(p1)) real(v(p2)) imag(v(p2))
echo LM_END optr10a000_b fwd_mid
noise v(p2) vs1 lin 70 17725000000.0 21175000000.0
setplot previous
echo LM_BEGIN optr10a000_b noise_mid
print inoise_spectrum
echo LM_END optr10a000_b noise_mid
ac dec 100 1000000000.0 100000000000.0
echo LM_BEGIN optr10a000_b fwd_wide
print real(v(p1)) imag(v(p1)) real(v(p2)) imag(v(p2))
echo LM_END optr10a000_b fwd_wide
destroy all
alterparam mag1 = 0
alterparam mag2 = 1
reset
ac lin 71 17700000000.0 21200000000.0
echo LM_BEGIN optr10a000_b rev_dense
print real(v(p1)) imag(v(p1)) real(v(p2)) imag(v(p2))
echo LM_END optr10a000_b rev_dense
ac lin 70 17725000000.0 21175000000.0
echo LM_BEGIN optr10a000_b rev_mid
print real(v(p1)) imag(v(p1)) real(v(p2)) imag(v(p2))
echo LM_END optr10a000_b rev_mid
ac dec 100 1000000000.0 100000000000.0
echo LM_BEGIN optr10a000_b rev_wide
print real(v(p1)) imag(v(p1)) real(v(p2)) imag(v(p2))
echo LM_END optr10a000_b rev_wide
destroy all
alterparam c_sh1 = 0.0
alterparam l_in = 9.096e-10
alterparam c_sh2 = 2.944e-14
alterparam mag1 = 1
alterparam mag2 = 0
reset
ac lin 71 17700000000.0 21200000000.0
echo LM_BEGIN optr10a045_b fwd_dense
print real(v(p1)) imag(v(p1)) real(v(p2)) imag(v(p2))
echo LM_END optr10a045_b fwd_dense
noise v(p2) vs1 lin 71 17700000000.0 21200000000.0
setplot previous
echo LM_BEGIN optr10a045_b noise_dense
print inoise_spectrum
echo LM_END optr10a045_b noise_dense
ac lin 70 17725000000.0 21175000000.0
echo LM_BEGIN optr10a045_b fwd_mid
print real(v(p1)) imag(v(p1)) real(v(p2)) imag(v(p2))
echo LM_END optr10a045_b fwd_mid
noise v(p2) vs1 lin 70 17725000000.0 21175000000.0
setplot previous
echo LM_BEGIN optr10a045_b noise_mid
print inoise_spectrum
echo LM_END optr10a045_b noise_mid
ac dec 100 1000000000.0 100000000000.0
echo LM_BEGIN optr10a045_b fwd_wide
print real(v(p1)) imag(v(p1)) real(v(p2)) imag(v(p2))
echo LM_END optr10a045_b fwd_wide
destroy all
alterparam mag1 = 0
alterparam mag2 = 1
reset
ac lin 71 17700000000.0 21200000000.0
echo LM_BEGIN optr10a045_b rev_dense
print real(v(p1)) imag(v(p1)) real(v(p2)) imag(v(p2))
echo LM_END optr10a045_b rev_dense
ac lin 70 17725000000.0 21175000000.0
echo LM_BEGIN optr10a045_b rev_mid
print real(v(p1)) imag(v(p1)) real(v(p2)) imag(v(p2))
echo LM_END optr10a045_b rev_mid
ac dec 100 1000000000.0 100000000000.0
echo LM_BEGIN optr10a045_b rev_wide
print real(v(p1)) imag(v(p1)) real(v(p2)) imag(v(p2))
echo LM_END optr10a045_b rev_wide
destroy all
alterparam c_sh1 = 0.0
alterparam l_in = 7.954e-10
alterparam c_sh2 = 2.858e-14
alterparam mag1 = 1
alterparam mag2 = 0
reset
ac lin 71 17700000000.0 21200000000.0
echo LM_BEGIN optr10a090_b fwd_dense
print real(v(p1)) imag(v(p1)) real(v(p2)) imag(v(p2))
echo LM_END optr10a090_b fwd_dense
noise v(p2) vs1 lin 71 17700000000.0 21200000000.0
setplot previous
echo LM_BEGIN optr10a090_b noise_dense
print inoise_spectrum
echo LM_END optr10a090_b noise_dense
ac lin 70 17725000000.0 21175000000.0
echo LM_BEGIN optr10a090_b fwd_mid
print real(v(p1)) imag(v(p1)) real(v(p2)) imag(v(p2))
echo LM_END optr10a090_b fwd_mid
noise v(p2) vs1 lin 70 17725000000.0 21175000000.0
setplot previous
echo LM_BEGIN optr10a090_b noise_mid
print inoise_spectrum
echo LM_END optr10a090_b noise_mid
ac dec 100 1000000000.0 100000000000.0
echo LM_BEGIN optr10a090_b fwd_wide
print real(v(p1)) imag(v(p1)) real(v(p2)) imag(v(p2))
echo LM_END optr10a090_b fwd_wide
destroy all
alterparam mag1 = 0
alterparam mag2 = 1
reset
ac lin 71 17700000000.0 21200000000.0
echo LM_BEGIN optr10a090_b rev_dense
print real(v(p1)) imag(v(p1)) real(v(p2)) imag(v(p2))
echo LM_END optr10a090_b rev_dense
ac lin 70 17725000000.0 21175000000.0
echo LM_BEGIN optr10a090_b rev_mid
print real(v(p1)) imag(v(p1)) real(v(p2)) imag(v(p2))
echo LM_END optr10a090_b rev_mid
ac dec 100 1000000000.0 100000000000.0
echo LM_BEGIN optr10a090_b rev_wide
print real(v(p1)) imag(v(p1)) real(v(p2)) imag(v(p2))
echo LM_END optr10a090_b rev_wide
destroy all
alterparam c_sh1 = 0.0
alterparam l_in = 6.727e-10
alterparam c_sh2 = 3.49e-14
alterparam mag1 = 1
alterparam mag2 = 0
reset
ac lin 71 17700000000.0 21200000000.0
echo LM_BEGIN optr10a135_b fwd_dense
print real(v(p1)) imag(v(p1)) real(v(p2)) imag(v(p2))
echo LM_END optr10a135_b fwd_dense
noise v(p2) vs1 lin 71 17700000000.0 21200000000.0
setplot previous
echo LM_BEGIN optr10a135_b noise_dense
print inoise_spectrum
echo LM_END optr10a135_b noise_dense
ac lin 70 17725000000.0 21175000000.0
echo LM_BEGIN optr10a135_b fwd_mid
print real(v(p1)) imag(v(p1)) real(v(p2)) imag(v(p2))
echo LM_END optr10a135_b fwd_mid
noise v(p2) vs1 lin 70 17725000000.0 21175000000.0
setplot previous
echo LM_BEGIN optr10a135_b noise_mid
print inoise_spectrum
echo LM_END optr10a135_b noise_mid
ac dec 100 1000000000.0 100000000000.0
echo LM_BEGIN optr10a135_b fwd_wide
print real(v(p1)) imag(v(p1)) real(v(p2)) imag(v(p2))
echo LM_END optr10a135_b fwd_wide
destroy all
alterparam mag1 = 0
alterparam mag2 = 1
reset
ac lin 71 17700000000.0 21200000000.0
echo LM_BEGIN optr10a135_b rev_dense
print real(v(p1)) imag(v(p1)) real(v(p2)) imag(v(p2))
echo LM_END optr10a135_b rev_dense
ac lin 70 17725000000.0 21175000000.0
echo LM_BEGIN optr10a135_b rev_mid
print real(v(p1)) imag(v(p1)) real(v(p2)) imag(v(p2))
echo LM_END optr10a135_b rev_mid
ac dec 100 1000000000.0 100000000000.0
echo LM_BEGIN optr10a135_b rev_wide
print real(v(p1)) imag(v(p1)) real(v(p2)) imag(v(p2))
echo LM_END optr10a135_b rev_wide
destroy all
alterparam c_sh1 = 0.0
alterparam l_in = 6.066e-10
alterparam c_sh2 = 4.624e-14
alterparam mag1 = 1
alterparam mag2 = 0
reset
ac lin 71 17700000000.0 21200000000.0
echo LM_BEGIN optr10a180_b fwd_dense
print real(v(p1)) imag(v(p1)) real(v(p2)) imag(v(p2))
echo LM_END optr10a180_b fwd_dense
noise v(p2) vs1 lin 71 17700000000.0 21200000000.0
setplot previous
echo LM_BEGIN optr10a180_b noise_dense
print inoise_spectrum
echo LM_END optr10a180_b noise_dense
ac lin 70 17725000000.0 21175000000.0
echo LM_BEGIN optr10a180_b fwd_mid
print real(v(p1)) imag(v(p1)) real(v(p2)) imag(v(p2))
echo LM_END optr10a180_b fwd_mid
noise v(p2) vs1 lin 70 17725000000.0 21175000000.0
setplot previous
echo LM_BEGIN optr10a180_b noise_mid
print inoise_spectrum
echo LM_END optr10a180_b noise_mid
ac dec 100 1000000000.0 100000000000.0
echo LM_BEGIN optr10a180_b fwd_wide
print real(v(p1)) imag(v(p1)) real(v(p2)) imag(v(p2))
echo LM_END optr10a180_b fwd_wide
destroy all
alterparam mag1 = 0
alterparam mag2 = 1
reset
ac lin 71 17700000000.0 21200000000.0
echo LM_BEGIN optr10a180_b rev_dense
print real(v(p1)) imag(v(p1)) real(v(p2)) imag(v(p2))
echo LM_END optr10a180_b rev_dense
ac lin 70 17725000000.0 21175000000.0
echo LM_BEGIN optr10a180_b rev_mid
print real(v(p1)) imag(v(p1)) real(v(p2)) imag(v(p2))
echo LM_END optr10a180_b rev_mid
ac dec 100 1000000000.0 100000000000.0
echo LM_BEGIN optr10a180_b rev_wide
print real(v(p1)) imag(v(p1)) real(v(p2)) imag(v(p2))
echo LM_END optr10a180_b rev_wide
destroy all
alterparam c_sh1 = 0.0
alterparam l_in = 6.225e-10
alterparam c_sh2 = 5.618e-14
alterparam mag1 = 1
alterparam mag2 = 0
reset
ac lin 71 17700000000.0 21200000000.0
echo LM_BEGIN optr10a225_b fwd_dense
print real(v(p1)) imag(v(p1)) real(v(p2)) imag(v(p2))
echo LM_END optr10a225_b fwd_dense
noise v(p2) vs1 lin 71 17700000000.0 21200000000.0
setplot previous
echo LM_BEGIN optr10a225_b noise_dense
print inoise_spectrum
echo LM_END optr10a225_b noise_dense
ac lin 70 17725000000.0 21175000000.0
echo LM_BEGIN optr10a225_b fwd_mid
print real(v(p1)) imag(v(p1)) real(v(p2)) imag(v(p2))
echo LM_END optr10a225_b fwd_mid
noise v(p2) vs1 lin 70 17725000000.0 21175000000.0
setplot previous
echo LM_BEGIN optr10a225_b noise_mid
print inoise_spectrum
echo LM_END optr10a225_b noise_mid
ac dec 100 1000000000.0 100000000000.0
echo LM_BEGIN optr10a225_b fwd_wide
print real(v(p1)) imag(v(p1)) real(v(p2)) imag(v(p2))
echo LM_END optr10a225_b fwd_wide
destroy all
alterparam mag1 = 0
alterparam mag2 = 1
reset
ac lin 71 17700000000.0 21200000000.0
echo LM_BEGIN optr10a225_b rev_dense
print real(v(p1)) imag(v(p1)) real(v(p2)) imag(v(p2))
echo LM_END optr10a225_b rev_dense
ac lin 70 17725000000.0 21175000000.0
echo LM_BEGIN optr10a225_b rev_mid
print real(v(p1)) imag(v(p1)) real(v(p2)) imag(v(p2))
echo LM_END optr10a225_b rev_mid
ac dec 100 1000000000.0 100000000000.0
echo LM_BEGIN optr10a225_b rev_wide
print real(v(p1)) imag(v(p1)) real(v(p2)) imag(v(p2))
echo LM_END optr10a225_b rev_wide
destroy all
alterparam c_sh1 = 0.0
alterparam l_in = 7.12e-10
alterparam c_sh2 = 5.71e-14
alterparam mag1 = 1
alterparam mag2 = 0
reset
ac lin 71 17700000000.0 21200000000.0
echo LM_BEGIN optr10a270_b fwd_dense
print real(v(p1)) imag(v(p1)) real(v(p2)) imag(v(p2))
echo LM_END optr10a270_b fwd_dense
noise v(p2) vs1 lin 71 17700000000.0 21200000000.0
setplot previous
echo LM_BEGIN optr10a270_b noise_dense
print inoise_spectrum
echo LM_END optr10a270_b noise_dense
ac lin 70 17725000000.0 21175000000.0
echo LM_BEGIN optr10a270_b fwd_mid
print real(v(p1)) imag(v(p1)) real(v(p2)) imag(v(p2))
echo LM_END optr10a270_b fwd_mid
noise v(p2) vs1 lin 70 17725000000.0 21175000000.0
setplot previous
echo LM_BEGIN optr10a270_b noise_mid
print inoise_spectrum
echo LM_END optr10a270_b noise_mid
ac dec 100 1000000000.0 100000000000.0
echo LM_BEGIN optr10a270_b fwd_wide
print real(v(p1)) imag(v(p1)) real(v(p2)) imag(v(p2))
echo LM_END optr10a270_b fwd_wide
destroy all
alterparam mag1 = 0
alterparam mag2 = 1
reset
ac lin 71 17700000000.0 21200000000.0
echo LM_BEGIN optr10a270_b rev_dense
print real(v(p1)) imag(v(p1)) real(v(p2)) imag(v(p2))
echo LM_END optr10a270_b rev_dense
ac lin 70 17725000000.0 21175000000.0
echo LM_BEGIN optr10a270_b rev_mid
print real(v(p1)) imag(v(p1)) real(v(p2)) imag(v(p2))
echo LM_END optr10a270_b rev_mid
ac dec 100 1000000000.0 100000000000.0
echo LM_BEGIN optr10a270_b rev_wide
print real(v(p1)) imag(v(p1)) real(v(p2)) imag(v(p2))
echo LM_END optr10a270_b rev_wide
destroy all
alterparam c_sh1 = 0.0
alterparam l_in = 8.375e-10
alterparam c_sh2 = 4.867e-14
alterparam mag1 = 1
alterparam mag2 = 0
reset
ac lin 71 17700000000.0 21200000000.0
echo LM_BEGIN optr10a315_b fwd_dense
print real(v(p1)) imag(v(p1)) real(v(p2)) imag(v(p2))
echo LM_END optr10a315_b fwd_dense
noise v(p2) vs1 lin 71 17700000000.0 21200000000.0
setplot previous
echo LM_BEGIN optr10a315_b noise_dense
print inoise_spectrum
echo LM_END optr10a315_b noise_dense
ac lin 70 17725000000.0 21175000000.0
echo LM_BEGIN optr10a315_b fwd_mid
print real(v(p1)) imag(v(p1)) real(v(p2)) imag(v(p2))
echo LM_END optr10a315_b fwd_mid
noise v(p2) vs1 lin 70 17725000000.0 21175000000.0
setplot previous
echo LM_BEGIN optr10a315_b noise_mid
print inoise_spectrum
echo LM_END optr10a315_b noise_mid
ac dec 100 1000000000.0 100000000000.0
echo LM_BEGIN optr10a315_b fwd_wide
print real(v(p1)) imag(v(p1)) real(v(p2)) imag(v(p2))
echo LM_END optr10a315_b fwd_wide
destroy all
alterparam mag1 = 0
alterparam mag2 = 1
reset
ac lin 71 17700000000.0 21200000000.0
echo LM_BEGIN optr10a315_b rev_dense
print real(v(p1)) imag(v(p1)) real(v(p2)) imag(v(p2))
echo LM_END optr10a315_b rev_dense
ac lin 70 17725000000.0 21175000000.0
echo LM_BEGIN optr10a315_b rev_mid
print real(v(p1)) imag(v(p1)) real(v(p2)) imag(v(p2))
echo LM_END optr10a315_b rev_mid
ac dec 100 1000000000.0 100000000000.0
echo LM_BEGIN optr10a315_b rev_wide
print real(v(p1)) imag(v(p1)) real(v(p2)) imag(v(p2))
echo LM_END optr10a315_b rev_wide
destroy all
alterparam c_sh1 = 0.0
alterparam l_in = 1.23e-09
alterparam c_sh2 = 2.833e-14
alterparam mag1 = 1
alterparam mag2 = 0
reset
ac lin 71 17700000000.0 21200000000.0
echo LM_BEGIN optr20a000_b fwd_dense
print real(v(p1)) imag(v(p1)) real(v(p2)) imag(v(p2))
echo LM_END optr20a000_b fwd_dense
noise v(p2) vs1 lin 71 17700000000.0 21200000000.0
setplot previous
echo LM_BEGIN optr20a000_b noise_dense
print inoise_spectrum
echo LM_END optr20a000_b noise_dense
ac lin 70 17725000000.0 21175000000.0
echo LM_BEGIN optr20a000_b fwd_mid
print real(v(p1)) imag(v(p1)) real(v(p2)) imag(v(p2))
echo LM_END optr20a000_b fwd_mid
noise v(p2) vs1 lin 70 17725000000.0 21175000000.0
setplot previous
echo LM_BEGIN optr20a000_b noise_mid
print inoise_spectrum
echo LM_END optr20a000_b noise_mid
ac dec 100 1000000000.0 100000000000.0
echo LM_BEGIN optr20a000_b fwd_wide
print real(v(p1)) imag(v(p1)) real(v(p2)) imag(v(p2))
echo LM_END optr20a000_b fwd_wide
destroy all
alterparam mag1 = 0
alterparam mag2 = 1
reset
ac lin 71 17700000000.0 21200000000.0
echo LM_BEGIN optr20a000_b rev_dense
print real(v(p1)) imag(v(p1)) real(v(p2)) imag(v(p2))
echo LM_END optr20a000_b rev_dense
ac lin 70 17725000000.0 21175000000.0
echo LM_BEGIN optr20a000_b rev_mid
print real(v(p1)) imag(v(p1)) real(v(p2)) imag(v(p2))
echo LM_END optr20a000_b rev_mid
ac dec 100 1000000000.0 100000000000.0
echo LM_BEGIN optr20a000_b rev_wide
print real(v(p1)) imag(v(p1)) real(v(p2)) imag(v(p2))
echo LM_END optr20a000_b rev_wide
destroy all
alterparam c_sh1 = 0.0
alterparam l_in = 1.18e-09
alterparam c_sh2 = 1.438e-14
alterparam mag1 = 1
alterparam mag2 = 0
reset
ac lin 71 17700000000.0 21200000000.0
echo LM_BEGIN optr20a045_b fwd_dense
print real(v(p1)) imag(v(p1)) real(v(p2)) imag(v(p2))
echo LM_END optr20a045_b fwd_dense
noise v(p2) vs1 lin 71 17700000000.0 21200000000.0
setplot previous
echo LM_BEGIN optr20a045_b noise_dense
print inoise_spectrum
echo LM_END optr20a045_b noise_dense
ac lin 70 17725000000.0 21175000000.0
echo LM_BEGIN optr20a045_b fwd_mid
print real(v(p1)) imag(v(p1)) real(v(p2)) imag(v(p2))
echo LM_END optr20a045_b fwd_mid
noise v(p2) vs1 lin 70 17725000000.0 21175000000.0
setplot previous
echo LM_BEGIN optr20a045_b noise_mid
print inoise_spectrum
echo LM_END optr20a045_b noise_mid
ac dec 100 1000000000.0 100000000000.0
echo LM_BEGIN optr20a045_b fwd_wide
print real(v(p1)) imag(v(p1)) real(v(p2)) imag(v(p2))
echo LM_END optr20a045_b fwd_wide
destroy all
alterparam mag1 = 0
alterparam mag2 = 1
reset
ac lin 71 17700000000.0 21200000000.0
echo LM_BEGIN optr20a045_b rev_dense
print real(v(p1)) imag(v(p1)) real(v(p2)) imag(v(p2))
echo LM_END optr20a045_b rev_dense
ac lin 70 17725000000.0 21175000000.0
echo LM_BEGIN optr20a045_b rev_mid
print real(v(p1)) imag(v(p1)) real(v(p2)) imag(v(p2))
echo LM_END optr20a045_b rev_mid
ac dec 100 1000000000.0 100000000000.0
echo LM_BEGIN optr20a045_b rev_wide
print real(v(p1)) imag(v(p1)) real(v(p2)) imag(v(p2))
echo LM_END optr20a045_b rev_wide
destroy all
alterparam c_sh1 = 0.0
alterparam l_in = 8.81e-10
alterparam c_sh2 = 1.345e-14
alterparam mag1 = 1
alterparam mag2 = 0
reset
ac lin 71 17700000000.0 21200000000.0
echo LM_BEGIN optr20a090_b fwd_dense
print real(v(p1)) imag(v(p1)) real(v(p2)) imag(v(p2))
echo LM_END optr20a090_b fwd_dense
noise v(p2) vs1 lin 71 17700000000.0 21200000000.0
setplot previous
echo LM_BEGIN optr20a090_b noise_dense
print inoise_spectrum
echo LM_END optr20a090_b noise_dense
ac lin 70 17725000000.0 21175000000.0
echo LM_BEGIN optr20a090_b fwd_mid
print real(v(p1)) imag(v(p1)) real(v(p2)) imag(v(p2))
echo LM_END optr20a090_b fwd_mid
noise v(p2) vs1 lin 70 17725000000.0 21175000000.0
setplot previous
echo LM_BEGIN optr20a090_b noise_mid
print inoise_spectrum
echo LM_END optr20a090_b noise_mid
ac dec 100 1000000000.0 100000000000.0
echo LM_BEGIN optr20a090_b fwd_wide
print real(v(p1)) imag(v(p1)) real(v(p2)) imag(v(p2))
echo LM_END optr20a090_b fwd_wide
destroy all
alterparam mag1 = 0
alterparam mag2 = 1
reset
ac lin 71 17700000000.0 21200000000.0
echo LM_BEGIN optr20a090_b rev_dense
print real(v(p1)) imag(v(p1)) real(v(p2)) imag(v(p2))
echo LM_END optr20a090_b rev_dense
ac lin 70 17725000000.0 21175000000.0
echo LM_BEGIN optr20a090_b rev_mid
print real(v(p1)) imag(v(p1)) real(v(p2)) imag(v(p2))
echo LM_END optr20a090_b rev_mid
ac dec 100 1000000000.0 100000000000.0
echo LM_BEGIN optr20a090_b rev_wide
print real(v(p1)) imag(v(p1)) real(v(p2)) imag(v(p2))
echo LM_END optr20a090_b rev_wide
destroy all
alterparam c_sh1 = 0.0
alterparam l_in = 6.23e-10
alterparam c_sh2 = 2.417e-14
alterparam mag1 = 1
alterparam mag2 = 0
reset
ac lin 71 17700000000.0 21200000000.0
echo LM_BEGIN optr20a135_b fwd_dense
print real(v(p1)) imag(v(p1)) real(v(p2)) imag(v(p2))
echo LM_END optr20a135_b fwd_dense
noise v(p2) vs1 lin 71 17700000000.0 21200000000.0
setplot previous
echo LM_BEGIN optr20a135_b noise_dense
print inoise_spectrum
echo LM_END optr20a135_b noise_dense
ac lin 70 17725000000.0 21175000000.0
echo LM_BEGIN optr20a135_b fwd_mid
print real(v(p1)) imag(v(p1)) real(v(p2)) imag(v(p2))
echo LM_END optr20a135_b fwd_mid
noise v(p2) vs1 lin 70 17725000000.0 21175000000.0
setplot previous
echo LM_BEGIN optr20a135_b noise_mid
print inoise_spectrum
echo LM_END optr20a135_b noise_mid
ac dec 100 1000000000.0 100000000000.0
echo LM_BEGIN optr20a135_b fwd_wide
print real(v(p1)) imag(v(p1)) real(v(p2)) imag(v(p2))
echo LM_END optr20a135_b fwd_wide
destroy all
alterparam mag1 = 0
alterparam mag2 = 1
reset
ac lin 71 17700000000.0 21200000000.0
echo LM_BEGIN optr20a135_b rev_dense
print real(v(p1)) imag(v(p1)) real(v(p2)) imag(v(p2))
echo LM_END optr20a135_b rev_dense
ac lin 70 17725000000.0 21175000000.0
echo LM_BEGIN optr20a135_b rev_mid
print real(v(p1)) imag(v(p1)) real(v(p2)) imag(v(p2))
echo LM_END optr20a135_b rev_mid
ac dec 100 1000000000.0 100000000000.0
echo LM_BEGIN optr20a135_b rev_wide
print real(v(p1)) imag(v(p1)) real(v(p2)) imag(v(p2))
echo LM_END optr20a135_b rev_wide
destroy all
alterparam c_sh1 = 0.0
alterparam l_in = 4.981e-10
alterparam c_sh2 = 4.634e-14
alterparam mag1 = 1
alterparam mag2 = 0
reset
ac lin 71 17700000000.0 21200000000.0
echo LM_BEGIN optr20a180_b fwd_dense
print real(v(p1)) imag(v(p1)) real(v(p2)) imag(v(p2))
echo LM_END optr20a180_b fwd_dense
noise v(p2) vs1 lin 71 17700000000.0 21200000000.0
setplot previous
echo LM_BEGIN optr20a180_b noise_dense
print inoise_spectrum
echo LM_END optr20a180_b noise_dense
ac lin 70 17725000000.0 21175000000.0
echo LM_BEGIN optr20a180_b fwd_mid
print real(v(p1)) imag(v(p1)) real(v(p2)) imag(v(p2))
echo LM_END optr20a180_b fwd_mid
noise v(p2) vs1 lin 70 17725000000.0 21175000000.0
setplot previous
echo LM_BEGIN optr20a180_b noise_mid
print inoise_spectrum
echo LM_END optr20a180_b noise_mid
ac dec 100 1000000000.0 100000000000.0
echo LM_BEGIN optr20a180_b fwd_wide
print real(v(p1)) imag(v(p1)) real(v(p2)) imag(v(p2))
echo LM_END optr20a180_b fwd_wide
destroy all
alterparam mag1 = 0
alterparam mag2 = 1
reset
ac lin 71 17700000000.0 21200000000.0
echo LM_BEGIN optr20a180_b rev_dense
print real(v(p1)) imag(v(p1)) real(v(p2)) imag(v(p2))
echo LM_END optr20a180_b rev_dense
ac lin 70 17725000000.0 21175000000.0
echo LM_BEGIN optr20a180_b rev_mid
print real(v(p1)) imag(v(p1)) real(v(p2)) imag(v(p2))
echo LM_END optr20a180_b rev_mid
ac dec 100 1000000000.0 100000000000.0
echo LM_BEGIN optr20a180_b rev_wide
print real(v(p1)) imag(v(p1)) real(v(p2)) imag(v(p2))
echo LM_END optr20a180_b rev_wide
destroy all
alterparam c_sh1 = 0.0
alterparam l_in = 5.305e-10
alterparam c_sh2 = 6.913e-14
alterparam mag1 = 1
alterparam mag2 = 0
reset
ac lin 71 17700000000.0 21200000000.0
echo LM_BEGIN optr20a225_b fwd_dense
print real(v(p1)) imag(v(p1)) real(v(p2)) imag(v(p2))
echo LM_END optr20a225_b fwd_dense
noise v(p2) vs1 lin 71 17700000000.0 21200000000.0
setplot previous
echo LM_BEGIN optr20a225_b noise_dense
print inoise_spectrum
echo LM_END optr20a225_b noise_dense
ac lin 70 17725000000.0 21175000000.0
echo LM_BEGIN optr20a225_b fwd_mid
print real(v(p1)) imag(v(p1)) real(v(p2)) imag(v(p2))
echo LM_END optr20a225_b fwd_mid
noise v(p2) vs1 lin 70 17725000000.0 21175000000.0
setplot previous
echo LM_BEGIN optr20a225_b noise_mid
print inoise_spectrum
echo LM_END optr20a225_b noise_mid
ac dec 100 1000000000.0 100000000000.0
echo LM_BEGIN optr20a225_b fwd_wide
print real(v(p1)) imag(v(p1)) real(v(p2)) imag(v(p2))
echo LM_END optr20a225_b fwd_wide
destroy all
alterparam mag1 = 0
alterparam mag2 = 1
reset
ac lin 71 17700000000.0 21200000000.0
echo LM_BEGIN optr20a225_b rev_dense
print real(v(p1)) imag(v(p1)) real(v(p2)) imag(v(p2))
echo LM_END optr20a225_b rev_dense
ac lin 70 17725000000.0 21175000000.0
echo LM_BEGIN optr20a225_b rev_mid
print real(v(p1)) imag(v(p1)) real(v(p2)) imag(v(p2))
echo LM_END optr20a225_b rev_mid
ac dec 100 1000000000.0 100000000000.0
echo LM_BEGIN optr20a225_b rev_wide
print real(v(p1)) imag(v(p1)) real(v(p2)) imag(v(p2))
echo LM_END optr20a225_b rev_wide
destroy all
alterparam c_sh1 = 0.0
alterparam l_in = 7.016e-10
alterparam c_sh2 = 7.042e-14
alterparam mag1 = 1
alterparam mag2 = 0
reset
ac lin 71 17700000000.0 21200000000.0
echo LM_BEGIN optr20a270_b fwd_dense
print real(v(p1)) imag(v(p1)) real(v(p2)) imag(v(p2))
echo LM_END optr20a270_b fwd_dense
noise v(p2) vs1 lin 71 17700000000.0 21200000000.0
setplot previous
echo LM_BEGIN optr20a270_b noise_dense
print inoise_spectrum
echo LM_END optr20a270_b noise_dense
ac lin 70 17725000000.0 21175000000.0
echo LM_BEGIN optr20a270_b fwd_mid
print real(v(p1)) imag(v(p1)) real(v(p2)) imag(v(p2))
echo LM_END optr20a270_b fwd_mid
noise v(p2) vs1 lin 70 17725000000.0 21175000000.0
setplot previous
echo LM_BEGIN optr20a270_b noise_mid
print inoise_spectrum
echo LM_END optr20a270_b noise_mid
ac dec 100 1000000000.0 100000000000.0
echo LM_BEGIN optr20a270_b fwd_wide
print real(v(p1)) imag(v(p1)) real(v(p2)) imag(v(p2))
echo LM_END optr20a270_b fwd_wide
destroy all
alterparam mag1 = 0
alterparam mag2 = 1
reset
ac lin 71 17700000000.0 21200000000.0
echo LM_BEGIN optr20a270_b rev_dense
print real(v(p1)) imag(v(p1)) real(v(p2)) imag(v(p2))
echo LM_END optr20a270_b rev_dense
ac lin 70 17725000000.0 21175000000.0
echo LM_BEGIN optr20a270_b rev_mid
print real(v(p1)) imag(v(p1)) real(v(p2)) imag(v(p2))
echo LM_END optr20a270_b rev_mid
ac dec 100 1000000000.0 100000000000.0
echo LM_BEGIN optr20a270_b rev_wide
print real(v(p1)) imag(v(p1)) real(v(p2)) imag(v(p2))
echo LM_END optr20a270_b rev_wide
destroy all
alterparam c_sh1 = 0.0
alterparam l_in = 9.737e-10
alterparam c_sh2 = 5.143e-14
alterparam mag1 = 1
alterparam mag2 = 0
reset
ac lin 71 17700000000.0 21200000000.0
echo LM_BEGIN optr20a315_b fwd_dense
print real(v(p1)) imag(v(p1)) real(v(p2)) imag(v(p2))
echo LM_END optr20a315_b fwd_dense
noise v(p2) vs1 lin 71 17700000000.0 21200000000.0
setplot previous
echo LM_BEGIN optr20a315_b noise_dense
print inoise_spectrum
echo LM_END optr20a315_b noise_dense
ac lin 70 17725000000.0 21175000000.0
echo LM_BEGIN optr20a315_b fwd_mid
print real(v(p1)) imag(v(p1)) real(v(p2)) imag(v(p2))
echo LM_END optr20a315_b fwd_mid
noise v(p2) vs1 lin 70 17725000000.0 21175000000.0
setplot previous
echo LM_BEGIN optr20a315_b noise_mid
print inoise_spectrum
echo LM_END optr20a315_b noise_mid
ac dec 100 1000000000.0 100000000000.0
echo LM_BEGIN optr20a315_b fwd_wide
print real(v(p1)) imag(v(p1)) real(v(p2)) imag(v(p2))
echo LM_END optr20a315_b fwd_wide
destroy all
alterparam mag1 = 0
alterparam mag2 = 1
reset
ac lin 71 17700000000.0 21200000000.0
echo LM_BEGIN optr20a315_b rev_dense
print real(v(p1)) imag(v(p1)) real(v(p2)) imag(v(p2))
echo LM_END optr20a315_b rev_dense
ac lin 70 17725000000.0 21175000000.0
echo LM_BEGIN optr20a315_b rev_mid
print real(v(p1)) imag(v(p1)) real(v(p2)) imag(v(p2))
echo LM_END optr20a315_b rev_mid
ac dec 100 1000000000.0 100000000000.0
echo LM_BEGIN optr20a315_b rev_wide
print real(v(p1)) imag(v(p1)) real(v(p2)) imag(v(p2))
echo LM_END optr20a315_b rev_wide
destroy all
alterparam c_sh1 = 2.301e-13
alterparam l_in = 1.43e-09
alterparam c_sh2 = 0.0
alterparam mag1 = 1
alterparam mag2 = 0
reset
ac lin 71 17700000000.0 21200000000.0
echo LM_BEGIN pmr03a000_a fwd_dense
print real(v(p1)) imag(v(p1)) real(v(p2)) imag(v(p2))
echo LM_END pmr03a000_a fwd_dense
noise v(p2) vs1 lin 71 17700000000.0 21200000000.0
setplot previous
echo LM_BEGIN pmr03a000_a noise_dense
print inoise_spectrum
echo LM_END pmr03a000_a noise_dense
ac lin 70 17725000000.0 21175000000.0
echo LM_BEGIN pmr03a000_a fwd_mid
print real(v(p1)) imag(v(p1)) real(v(p2)) imag(v(p2))
echo LM_END pmr03a000_a fwd_mid
noise v(p2) vs1 lin 70 17725000000.0 21175000000.0
setplot previous
echo LM_BEGIN pmr03a000_a noise_mid
print inoise_spectrum
echo LM_END pmr03a000_a noise_mid
ac dec 100 1000000000.0 100000000000.0
echo LM_BEGIN pmr03a000_a fwd_wide
print real(v(p1)) imag(v(p1)) real(v(p2)) imag(v(p2))
echo LM_END pmr03a000_a fwd_wide
destroy all
alterparam mag1 = 0
alterparam mag2 = 1
reset
ac lin 71 17700000000.0 21200000000.0
echo LM_BEGIN pmr03a000_a rev_dense
print real(v(p1)) imag(v(p1)) real(v(p2)) imag(v(p2))
echo LM_END pmr03a000_a rev_dense
ac lin 70 17725000000.0 21175000000.0
echo LM_BEGIN pmr03a000_a rev_mid
print real(v(p1)) imag(v(p1)) real(v(p2)) imag(v(p2))
echo LM_END pmr03a000_a rev_mid
ac dec 100 1000000000.0 100000000000.0
echo LM_BEGIN pmr03a000_a rev_wide
print real(v(p1)) imag(v(p1)) real(v(p2)) imag(v(p2))
echo LM_END pmr03a000_a rev_wide
destroy all
alterparam c_sh1 = 2.595e-13
alterparam l_in = 1.377e-09
alterparam c_sh2 = 0.0
alterparam mag1 = 1
alterparam mag2 = 0
reset
ac lin 71 17700000000.0 21200000000.0
echo LM_BEGIN pmr03a045_a fwd_dense
print real(v(p1)) imag(v(p1)) real(v(p2)) imag(v(p2))
echo LM_END pmr03a045_a fwd_dense
noise v(p2) vs1 lin 71 17700000000.0 21200000000.0
setplot previous
echo LM_BEGIN pmr03a045_a noise_dense
print inoise_spectrum
echo LM_END pmr03a045_a noise_dense
ac lin 70 17725000000.0 21175000000.0
echo LM_BEGIN pmr03a045_a fwd_mid
print real(v(p1)) imag(v(p1)) real(v(p2)) imag(v(p2))
echo LM_END pmr03a045_a fwd_mid
noise v(p2) vs1 lin 70 17725000000.0 21175000000.0
setplot previous
echo LM_BEGIN pmr03a045_a noise_mid
print inoise_spectrum
echo LM_END pmr03a045_a noise_mid
ac dec 100 1000000000.0 100000000000.0
echo LM_BEGIN pmr03a045_a fwd_wide
print real(v(p1)) imag(v(p1)) real(v(p2)) imag(v(p2))
echo LM_END pmr03a045_a fwd_wide
destroy all
alterparam mag1 = 0
alterparam mag2 = 1
reset
ac lin 71 17700000000.0 21200000000.0
echo LM_BEGIN pmr03a045_a rev_dense
print real(v(p1)) imag(v(p1)) real(v(p2)) imag(v(p2))
echo LM_END pmr03a045_a rev_dense
ac lin 70 17725000000.0 21175000000.0
echo LM_BEGIN pmr03a045_a rev_mid
print real(v(p1)) imag(v(p1)) real(v(p2)) imag(v(p2))
echo LM_END pmr03a045_a rev_mid
ac dec 100 1000000000.0 100000000000.0
echo LM_BEGIN pmr03a045_a rev_wide
print real(v(p1)) imag(v(p1)) real(v(p2)) imag(v(p2))
echo LM_END pmr03a045_a rev_wide
destroy all
alterparam c_sh1 = 2.382e-13
alterparam l_in = 1.339e-09
alterparam c_sh2 = 0.0
alterparam mag1 = 1
alterparam mag2 = 0
reset
ac lin 71 17700000000.0 21200000000.0
echo LM_BEGIN pmr03a090_a fwd_dense
print real(v(p1)) imag(v(p1)) real(v(p2)) imag(v(p2))
echo LM_END pmr03a090_a fwd_dense
noise v(p2) vs1 lin 71 17700000000.0 21200000000.0
setplot previous
echo LM_BEGIN pmr03a090_a noise_dense
print inoise_spectrum
echo LM_END pmr03a090_a noise_dense
ac lin 70 17725000000.0 21175000000.0
echo LM_BEGIN pmr03a090_a fwd_mid
print real(v(p1)) imag(v(p1)) real(v(p2)) imag(v(p2))
echo LM_END pmr03a090_a fwd_mid
noise v(p2) vs1 lin 70 17725000000.0 21175000000.0
setplot previous
echo LM_BEGIN pmr03a090_a noise_mid
print inoise_spectrum
echo LM_END pmr03a090_a noise_mid
ac dec 100 1000000000.0 100000000000.0
echo LM_BEGIN pmr03a090_a fwd_wide
print real(v(p1)) imag(v(p1)) real(v(p2)) imag(v(p2))
echo LM_END pmr03a090_a fwd_wide
destroy all
alterparam mag1 = 0
alterparam mag2 = 1
reset
ac lin 71 17700000000.0 21200000000.0
echo LM_BEGIN pmr03a090_a rev_dense
print real(v(p1)) imag(v(p1)) real(v(p2)) imag(v(p2))
echo LM_END pmr03a090_a rev_dense
ac lin 70 17725000000.0 21175000000.0
echo LM_BEGIN pmr03a090_a rev_mid
print real(v(p1)) imag(v(p1)) real(v(p2)) imag(v(p2))
echo LM_END pmr03a090_a rev_mid
ac dec 100 1000000000.0 100000000000.0
echo LM_BEGIN pmr03a090_a rev_wide
print real(v(p1)) imag(v(p1)) real(v(p2)) imag(v(p2))
echo LM_END pmr03a090_a rev_wide
destroy all
alterparam c_sh1 = 1.938e-13
alterparam l_in = 1.328e-09
alterparam c_sh2 = 0.0
alterparam mag1 = 1
alterparam mag2 = 0
reset
ac lin 71 17700000000.0 21200000000.0
echo LM_BEGIN pmr03a135_a fwd_dense
print real(v(p1)) imag(v(p1)) real(v(p2)) imag(v(p2))
echo LM_END pmr03a135_a fwd_dense
noise v(p2) vs1 lin 71 17700000000.0 21200000000.0
setplot previous
echo LM_BEGIN pmr03a135_a noise_dense
print inoise_spectrum
echo LM_END pmr03a135_a noise_dense
ac lin 70 17725000000.0 21175000000.0
echo LM_BEGIN pmr03a135_a fwd_mid
print real(v(p1)) imag(v(p1)) real(v(p2)) imag(v(p2))
echo LM_END pmr03a135_a fwd_mid
noise v(p2) vs1 lin 70 17725000000.0 21175000000.0
setplot previous
echo LM_BEGIN pmr03a135_a noise_mid
print inoise_spectrum
echo LM_END pmr03a135_a noise_mid
ac dec 100 1000000000.0 100000000000.0
echo LM_BEGIN pmr03a135_a fwd_wide
print real(v(p1)) imag(v(p1)) real(v(p2)) imag(v(p2))
echo LM_END pmr03a135_a fwd_wide
destroy all
alterparam mag1 = 0
alterparam mag2 = 1
reset
ac lin 71 17700000000.0 21200000000.0
echo LM_BEGIN pmr03a135_a rev_dense
print real(v(p1)) imag(v(p1)) real(v(p2)) imag(v(p2))
echo LM_END pmr03a135_a rev_dense
ac lin 70 17725000000.0 21175000000.0
echo LM_BEGIN pmr03a135_a rev_mid
print real(v(p1)) imag(v(p1)) real(v(p2)) imag(v(p2))
echo LM_END pmr03a135_a rev_mid
ac dec 100 1000000000.0 100000000000.0
echo LM_BEGIN pmr03a135_a rev_wide
print real(v(p1)) imag(v(p1)) real(v(p2)) imag(v(p2))
echo LM_END pmr03a135_a rev_wide
destroy all
alterparam c_sh1 = 1.552e-13
alterparam l_in = 1.339e-09
alterparam c_sh2 = 0.0
alterparam mag1 = 1
alterparam mag2 = 0
reset
ac lin 71 17700000000.0 21200000000.0
echo LM_BEGIN pmr03a180_a fwd_dense
print real(v(p1)) imag(v(p1)) real(v(p2)) imag(v(p2))
echo LM_END pmr03a180_a fwd_dense
noise v(p2) vs1 lin 71 17700000000.0 21200000000.0
setplot previous
echo LM_BEGIN pmr03a180_a noise_dense
print inoise_spectrum
echo LM_END pmr03a180_a noise_dense
ac lin 70 17725000000.0 21175000000.0
echo LM_BEGIN pmr03a180_a fwd_mid
print real(v(p1)) imag(v(p1)) real(v(p2)) imag(v(p2))
echo LM_END pmr03a180_a fwd_mid
noise v(p2) vs1 lin 70 17725000000.0 21175000000.0
setplot previous
echo LM_BEGIN pmr03a180_a noise_mid
print inoise_spectrum
echo LM_END pmr03a180_a noise_mid
ac dec 100 1000000000.0 100000000000.0
echo LM_BEGIN pmr03a180_a fwd_wide
print real(v(p1)) imag(v(p1)) real(v(p2)) imag(v(p2))
echo LM_END pmr03a180_a fwd_wide
destroy all
alterparam mag1 = 0
alterparam mag2 = 1
reset
ac lin 71 17700000000.0 21200000000.0
echo LM_BEGIN pmr03a180_a rev_dense
print real(v(p1)) imag(v(p1)) real(v(p2)) imag(v(p2))
echo LM_END pmr03a180_a rev_dense
ac lin 70 17725000000.0 21175000000.0
echo LM_BEGIN pmr03a180_a rev_mid
print real(v(p1)) imag(v(p1)) real(v(p2)) imag(v(p2))
echo LM_END pmr03a180_a rev_mid
ac dec 100 1000000000.0 100000000000.0
echo LM_BEGIN pmr03a180_a rev_wide
print real(v(p1)) imag(v(p1)) real(v(p2)) imag(v(p2))
echo LM_END pmr03a180_a rev_wide
destroy all
alterparam c_sh1 = 1.349e-13
alterparam l_in = 1.376e-09
alterparam c_sh2 = 0.0
alterparam mag1 = 1
alterparam mag2 = 0
reset
ac lin 71 17700000000.0 21200000000.0
echo LM_BEGIN pmr03a225_a fwd_dense
print real(v(p1)) imag(v(p1)) real(v(p2)) imag(v(p2))
echo LM_END pmr03a225_a fwd_dense
noise v(p2) vs1 lin 71 17700000000.0 21200000000.0
setplot previous
echo LM_BEGIN pmr03a225_a noise_dense
print inoise_spectrum
echo LM_END pmr03a225_a noise_dense
ac lin 70 17725000000.0 21175000000.0
echo LM_BEGIN pmr03a225_a fwd_mid
print real(v(p1)) imag(v(p1)) real(v(p2)) imag(v(p2))
echo LM_END pmr03a225_a fwd_mid
noise v(p2) vs1 lin 70 17725000000.0 21175000000.0
setplot previous
echo LM_BEGIN pmr03a225_a noise_mid
print inoise_spectrum
echo LM_END pmr03a225_a noise_mid
ac dec 100 1000000000.0 100000000000.0
echo LM_BEGIN pmr03a225_a fwd_wide
print real(v(p1)) imag(v(p1)) real(v(p2)) imag(v(p2))
echo LM_END pmr03a225_a fwd_wide
destroy all
alterparam mag1 = 0
alterparam mag2 = 1
reset
ac lin 71 17700000000.0 21200000000.0
echo LM_BEGIN pmr03a225_a rev_dense
print real(v(p1)) imag(v(p1)) real(v(p2)) imag(v(p2))
echo LM_END pmr03a225_a rev_dense
ac lin 70 17725000000.0 21175000000.0
echo LM_BEGIN pmr03a225_a rev_mid
print real(v(p1)) imag(v(p1)) real(v(p2)) imag(v(p2))
echo LM_END pmr03a225_a rev_mid
ac dec 100 1000000000.0 100000000000.0
echo LM_BEGIN pmr03a225_a rev_wide
print real(v(p1)) imag(v(p1)) real(v(p2)) imag(v(p2))
echo LM_END pmr03a225_a rev_wide
destroy all
alterparam c_sh1 = 1.416e-13
alterparam l_in = 1.429e-09
alterparam c_sh2 = 0.0
alterparam mag1 = 1
alterparam mag2 = 0
reset
ac lin 71 17700000000.0 21200000000.0
echo LM_BEGIN pmr03a270_a fwd_dense
print real(v(p1)) imag(v(p1)) real(v(p2)) imag(v(p2))
echo LM_END pmr03a270_a fwd_dense
noise v(p2) vs1 lin 71 17700000000.0 21200000000.0
setplot previous
echo LM_BEGIN pmr03a270_a noise_dense
print inoise_spectrum
echo LM_END pmr03a270_a noise_dense
ac lin 70 17725000000.0 21175000000.0
echo LM_BEGIN pmr03a270_a fwd_mid
print real(v(p1)) imag(v(p1)) real(v(p2)) imag(v(p2))
echo LM_END pmr03a270_a fwd_mid
noise v(p2) vs1 lin 70 17725000000.0 21175000000.0
setplot previous
echo LM_BEGIN pmr03a270_a noise_mid
print inoise_spectrum
echo LM_END pmr03a270_a noise_mid
ac dec 100 1000000000.0 100000000000.0
echo LM_BEGIN pmr03a270_a fwd_wide
print real(v(p1)) imag(v(p1)) real(v(p2)) imag(v(p2))
echo LM_END pmr03a270_a fwd_wide
destroy all
alterparam mag1 = 0
alterparam mag2 = 1
reset
ac lin 71 17700000000.0 21200000000.0
echo LM_BEGIN pmr03a270_a rev_dense
print real(v(p1)) imag(v(p1)) real(v(p2)) imag(v(p2))
echo LM_END pmr03a270_a rev_dense
ac lin 70 17725000000.0 21175000000.0
echo LM_BEGIN pmr03a270_a rev_mid
print real(v(p1)) imag(v(p1)) real(v(p2)) imag(v(p2))
echo LM_END pmr03a270_a rev_mid
ac dec 100 1000000000.0 100000000000.0
echo LM_BEGIN pmr03a270_a rev_wide
print real(v(p1)) imag(v(p1)) real(v(p2)) imag(v(p2))
echo LM_END pmr03a270_a rev_wide
destroy all
alterparam c_sh1 = 1.779e-13
alterparam l_in = 1.457e-09
alterparam c_sh2 = 0.0
alterparam mag1 = 1
alterparam mag2 = 0
reset
ac lin 71 17700000000.0 21200000000.0
echo LM_BEGIN pmr03a315_a fwd_dense
print real(v(p1)) imag(v(p1)) real(v(p2)) imag(v(p2))
echo LM_END pmr03a315_a fwd_dense
noise v(p2) vs1 lin 71 17700000000.0 21200000000.0
setplot previous
echo LM_BEGIN pmr03a315_a noise_dense
print inoise_spectrum
echo LM_END pmr03a315_a noise_dense
ac lin 70 17725000000.0 21175000000.0
echo LM_BEGIN pmr03a315_a fwd_mid
print real(v(p1)) imag(v(p1)) real(v(p2)) imag(v(p2))
echo LM_END pmr03a315_a fwd_mid
noise v(p2) vs1 lin 70 17725000000.0 21175000000.0
setplot previous
echo LM_BEGIN pmr03a315_a noise_mid
print inoise_spectrum
echo LM_END pmr03a315_a noise_mid
ac dec 100 1000000000.0 100000000000.0
echo LM_BEGIN pmr03a315_a fwd_wide
print real(v(p1)) imag(v(p1)) real(v(p2)) imag(v(p2))
echo LM_END pmr03a315_a fwd_wide
destroy all
alterparam mag1 = 0
alterparam mag2 = 1
reset
ac lin 71 17700000000.0 21200000000.0
echo LM_BEGIN pmr03a315_a rev_dense
print real(v(p1)) imag(v(p1)) real(v(p2)) imag(v(p2))
echo LM_END pmr03a315_a rev_dense
ac lin 70 17725000000.0 21175000000.0
echo LM_BEGIN pmr03a315_a rev_mid
print real(v(p1)) imag(v(p1)) real(v(p2)) imag(v(p2))
echo LM_END pmr03a315_a rev_mid
ac dec 100 1000000000.0 100000000000.0
echo LM_BEGIN pmr03a315_a rev_wide
print real(v(p1)) imag(v(p1)) real(v(p2)) imag(v(p2))
echo LM_END pmr03a315_a rev_wide
destroy all
alterparam c_sh1 = 3.101e-13
alterparam l_in = 1.454e-09
alterparam c_sh2 = 0.0
alterparam mag1 = 1
alterparam mag2 = 0
reset
ac lin 71 17700000000.0 21200000000.0
echo LM_BEGIN pmr06a000_a fwd_dense
print real(v(p1)) imag(v(p1)) real(v(p2)) imag(v(p2))
echo LM_END pmr06a000_a fwd_dense
noise v(p2) vs1 lin 71 17700000000.0 21200000000.0
setplot previous
echo LM_BEGIN pmr06a000_a noise_dense
print inoise_spectrum
echo LM_END pmr06a000_a noise_dense
ac lin 70 17725000000.0 21175000000.0
echo LM_BEGIN pmr06a000_a fwd_mid
print real(v(p1)) imag(v(p1)) real(v(p2)) imag(v(p2))
echo LM_END pmr06a000_a fwd_mid
noise v(p2) vs1 lin 70 17725000000.0 21175000000.0
setplot previous
echo LM_BEGIN pmr06a000_a noise_mid
print inoise_spectrum
echo LM_END pmr06a000_a noise_mid
ac dec 100 1000000000.0 100000000000.0
echo LM_BEGIN pmr06a000_a fwd_wide
print real(v(p1)) imag(v(p1)) real(v(p2)) imag(v(p2))
echo LM_END pmr06a000_a fwd_wide
destroy all
alterparam mag1 = 0
alterparam mag2 = 1
reset
ac lin 71 17700000000.0 21200000000.0
echo LM_BEGIN pmr06a000_a rev_dense
print real(v(p1)) imag(v(p1)) real(v(p2)) imag(v(p2))
echo LM_END pmr06a000_a rev_dense
ac lin 70 17725000000.0 21175000000.0
echo LM_BEGIN pmr06a000_a rev_mid
print real(v(p1)) imag(v(p1)) real(v(p2)) imag(v(p2))
echo LM_END pmr06a000_a rev_mid
ac dec 100 1000000000.0 100000000000.0
echo LM_BEGIN pmr06a000_a rev_wide
print real(v(p1)) imag(v(p1)) real(v(p2)) imag(v(p2))
echo LM_END pmr06a000_a rev_wide
destroy all
alterparam c_sh1 = 4.139e-13
alterparam l_in = 1.332e-09
alterparam c_sh2 = 0.0
alterparam mag1 = 1
alterparam mag2 = 0
reset
ac lin 71 17700000000.0 21200000000.0
echo LM_BEGIN pmr06a045_a fwd_dense
print real(v(p1)) imag(v(p1)) real(v(p2)) imag(v(p2))
echo LM_END pmr06a045_a fwd_dense
noise v(p2) vs1 lin 71 17700000000.0 21200000000.0
setplot previous
echo LM_BEGIN pmr06a045_a noise_dense
print inoise_spectrum
echo LM_END pmr06a045_a noise_dense
ac lin 70 17725000000.0 21175000000.0
echo LM_BEGIN pmr06a045_a fwd_mid
print real(v(p1)) imag(v(p1)) real(v(p2)) imag(v(p2))
echo LM_END pmr06a045_a fwd_mid
noise v(p2) vs1 lin 70 17725000000.0 21175000000.0
setplot previous
echo LM_BEGIN pmr06a045_a noise_mid
print inoise_spectrum
echo LM_END pmr06a045_a noise_mid
ac dec 100 1000000000.0 100000000000.0
echo LM_BEGIN pmr06a045_a fwd_wide
print real(v(p1)) imag(v(p1)) real(v(p2)) imag(v(p2))
echo LM_END pmr06a045_a fwd_wide
destroy all
alterparam mag1 = 0
alterparam mag2 = 1
reset
ac lin 71 17700000000.0 21200000000.0
echo LM_BEGIN pmr06a045_a rev_dense
print real(v(p1)) imag(v(p1)) real(v(p2)) imag(v(p2))
echo LM_END pmr06a045_a rev_dense
ac lin 70 17725000000.0 21175000000.0
echo LM_BEGIN pmr06a045_a rev_mid
print real(v(p1)) imag(v(p1)) real(v(p2)) imag(v(p2))
echo LM_END pmr06a045_a rev_mid
ac dec 100 1000000000.0 100000000000.0
echo LM_BEGIN pmr06a045_a rev_wide
print real(v(p1)) imag(v(p1)) real(v(p2)) imag(v(p2))
echo LM_END pmr06a045_a rev_wide
destroy all
alterparam c_sh1 = 3.121e-13
alterparam l_in = 1.28e-09
alterparam c_sh2 = 0.0
alterparam mag1 = 1
alterparam mag2 = 0
reset
ac lin 71 17700000000.0 21200000000.0
echo LM_BEGIN pmr06a090_a fwd_dense
print real(v(p1)) imag(v(p1)) real(v(p2)) imag(v(p2))
echo LM_END pmr06a090_a fwd_dense
noise v(p2) vs1 lin 71 17700000000.0 21200000000.0
setplot previous
echo LM_BEGIN pmr06a090_a noise_dense
print inoise_spectrum
echo LM_END pmr06a090_a noise_dense
ac lin 70 17725000000.0 21175000000.0
echo LM_BEGIN pmr06a090_a fwd_mid
print real(v(p1)) imag(v(p1)) real(v(p2)) imag(v(p2))
echo LM_END pmr06a090_a fwd_mid
noise v(p2) vs1 lin 70 17725000000.0 21175000000.0
setplot previous
echo LM_BEGIN pmr06a090_a noise_mid
print inoise_spectrum
echo LM_END pmr06a090_a noise_mid
ac dec 100 1000000000.0 100000000000.0
echo LM_BEGIN pmr06a090_a fwd_wide
print real(v(p1)) imag(v(p1)) real(v(p2)) imag(v(p2))
echo LM_END pmr06a090_a fwd_wide
destroy all
alterparam mag1 = 0
alterparam mag2 = 1
reset
ac lin 71 17700000000.0 21200000000.0
echo LM_BEGIN pmr06a090_a rev_dense
print real(v(p1)) imag(v(p1)) real(v(p2)) imag(v(p2))
echo LM_END pmr06a090_a rev_dense
ac lin 70 17725000000.0 21175000000.0
echo LM_BEGIN pmr06a090_a rev_mid
print real(v(p1)) imag(v(p1)) real(v(p2)) imag(v(p2))
echo LM_END pmr06a090_a rev_mid
ac dec 100 1000000000.0 100000000000.0
echo LM_BEGIN pmr06a090_a rev_wide
print real(v(p1)) imag(v(p1)) real(v(p2)) imag(v(p2))
echo LM_END pmr06a090_a rev_wide
destroy all
alterparam c_sh1 = 2.039e-13
alterparam l_in = 1.27e-09
alterparam c_sh2 = 0.0
alterparam mag1 = 1
alterparam mag2 = 0
reset
ac lin 71 17700000000.0 21200000000.0
echo LM_BEGIN pmr06a135_a fwd_dense
print real(v(p1)) imag(v(p1)) real(v(p2)) imag(v(p2))
echo LM_END pmr06a135_a fwd_dense
noise v(p2) vs1 lin 71 17700000000.0 21200000000.0
setplot previous
echo LM_BEGIN pmr06a135_a noise_dense
print inoise_spectrum
echo LM_END pmr06a135_a noise_dense
ac lin 70 17725000000.0 21175000000.0
echo LM_BEGIN pmr06a135_a fwd_mid
print real(v(p1)) imag(v(p1)) real(v(p2)) imag(v(p2))
echo LM_END pmr06a135_a fwd_mid
noise v(p2) vs1 lin 70 17725000000.0 21175000000.0
setplot previous
echo LM_BEGIN pmr06a135_a noise_mid
print inoise_spectrum
echo LM_END pmr06a135_a noise_mid
ac dec 100 1000000000.0 100000000000.0
echo LM_BEGIN pmr06a135_a fwd_wide
print real(v(p1)) imag(v(p1)) real(v(p2)) imag(v(p2))
echo LM_END pmr06a135_a fwd_wide
destroy all
alterparam mag1 = 0
alterparam mag2 = 1
reset
ac lin 71 17700000000.0 21200000000.0
echo LM_BEGIN pmr06a135_a rev_dense
print real(v(p1)) imag(v(p1)) real(v(p2)) imag(v(p2))
echo LM_END pmr06a135_a rev_dense
ac lin 70 17725000000.0 21175000000.0
echo LM_BEGIN pmr06a135_a rev_mid
print real(v(p1)) imag(v(p1)) real(v(p2)) imag(v(p2))
echo LM_END pmr06a135_a rev_mid
ac dec 100 1000000000.0 100000000000.0
echo LM_BEGIN pmr06a135_a rev_wide
print real(v(p1)) imag(v(p1)) real(v(p2)) imag(v(p2))
echo LM_END pmr06a135_a rev_wide
destroy all
alterparam c_sh1 = 1.336e-13
alterparam l_in = 1.283e-09
alterparam c_sh2 = 0.0
alterparam mag1 = 1
alterparam mag2 = 0
reset
ac lin 71 17700000000.0 21200000000.0
echo LM_BEGIN pmr06a180_a fwd_dense
print real(v(p1)) imag(v(p1)) real(v(p2)) imag(v(p2))
echo LM_END pmr06a180_a fwd_dense
noise v(p2) vs1 lin 71 17700000000.0 21200000000.0
setplot previous
echo LM_BEGIN pmr06a180_a noise_dense
print inoise_spectrum
echo LM_END pmr06a180_a noise_dense
ac lin 70 17725000000.0 21175000000.0
echo LM_BEGIN pmr06a180_a fwd_mid
print real(v(p1)) imag(v(p1)) real(v(p2)) imag(v(p2))
echo LM_END pmr06a180_a fwd_mid
noise v(p2) vs1 lin 70 17725000000.0 21175000000.0
setplot previous
echo LM_BEGIN pmr06a180_a noise_mid
print inoise_spectrum
echo LM_END pmr06a180_a noise_mid
ac dec 100 1000000000.0 100000000000.0
echo LM_BEGIN pmr06a180_a fwd_wide
print real(v(p1)) imag(v(p1)) real(v(p2)) imag(v(p2))
echo LM_END pmr06a180_a fwd_wide
destroy all
alterparam mag1 = 0
alterparam mag2 = 1
reset
ac lin 71 17700000000.0 21200000000.0
echo LM_BEGIN pmr06a180_a rev_dense
print real(v(p1)) imag(v(p1)) real(v(p2)) imag(v(p2))
echo LM_END pmr06a180_a rev_dense
ac lin 70 17725000000.0 21175000000.0
echo LM_BEGIN pmr06a180_a rev_mid
print real(v(p1)) imag(v(p1)) real(v(p2)) imag(v(p2))
echo LM_END pmr06a180_a rev_mid
ac dec 100 1000000000.0 100000000000.0
echo LM_BEGIN pmr06a180_a rev_wide
print real(v(p1)) imag(v(p1)) real(v(p2)) imag(v(p2))
echo LM_END pmr06a180_a rev_wide
destroy all
alterparam c_sh1 = 9.368e-14
alterparam l_in = 1.333e-09
alterparam c_sh2 = 0.0
alterparam mag1 = 1
alterparam mag2 = 0
reset
ac lin 71 17700000000.0 21200000000.0
echo LM_BEGIN pmr06a225_a fwd_dense
print real(v(p1)) imag(v(p1)) real(v(p2)) imag(v(p2))
echo LM_END pmr06a225_a fwd_dense
noise v(p2) vs1 lin 71 17700000000.0 21200000000.0
setplot previous
echo LM_BEGIN pmr06a225_a noise_dense
print inoise_spectrum
echo LM_END pmr06a225_a noise_dense
ac lin 70 17725000000.0 21175000000.0
echo LM_BEGIN pmr06a225_a fwd_mid
print real(v(p1)) imag(v(p1)) real(v(p2)) imag(v(p2))
echo LM_END pmr06a225_a fwd_mid
noise v(p2) vs1 lin 70 17725000000.0 21175000000.0
setplot previous
echo LM_BEGIN pmr06a225_a noise_mid
print inoise_spectrum
echo LM_END pmr06a225_a noise_mid
ac dec 100 1000000000.0 100000000000.0
echo LM_BEGIN pmr06a225_a fwd_wide
print real(v(p1)) imag(v(p1)) real(v(p2)) imag(v(p2))
echo LM_END pmr06a225_a fwd_wide
destroy all
alterparam mag1 = 0
alterparam mag2 = 1
reset
ac lin 71 17700000000.0 21200000000.0
echo LM_BEGIN pmr06a225_a rev_dense
print real(v(p1)) imag(v(p1)) real(v(p2)) imag(v(p2))
echo LM_END pmr06a225_a rev_dense
ac lin 70 17725000000.0 21175000000.0
echo LM_BEGIN pmr06a225_a rev_mid
print real(v(p1)) imag(v(p1)) real(v(p2)) imag(v(p2))
echo LM_END pmr06a225_a rev_mid
ac dec 100 1000000000.0 100000000000.0
echo LM_BEGIN pmr06a225_a rev_wide
print real(v(p1)) imag(v(p1)) real(v(p2)) imag(v(p2))
echo LM_END pmr06a225_a rev_wide
destroy all
alterparam c_sh1 = 1.015e-13
alterparam l_in = 1.45e-09
alterparam c_sh2 = 0.0
alterparam mag1 = 1
alterparam mag2 = 0
reset
ac lin 71 17700000000.0 21200000000.0
echo LM_BEGIN pmr06a270_a fwd_dense
print real(v(p1)) imag(v(p1)) real(v(p2)) imag(v(p2))
echo LM_END pmr06a270_a fwd_dense
noise v(p2) vs1 lin 71 17700000000.0 21200000000.0
setplot previous
echo LM_BEGIN pmr06a270_a noise_dense
print inoise_spectrum
echo LM_END pmr06a270_a noise_dense
ac lin 70 17725000000.0 21175000000.0
echo LM_BEGIN pmr06a270_a fwd_mid
print real(v(p1)) imag(v(p1)) real(v(p2)) imag(v(p2))
echo LM_END pmr06a270_a fwd_mid
noise v(p2) vs1 lin 70 17725000000.0 21175000000.0
setplot previous
echo LM_BEGIN pmr06a270_a noise_mid
print inoise_spectrum
echo LM_END pmr06a270_a noise_mid
ac dec 100 1000000000.0 100000000000.0
echo LM_BEGIN pmr06a270_a fwd_wide
print real(v(p1)) imag(v(p1)) real(v(p2)) imag(v(p2))
echo LM_END pmr06a270_a fwd_wide
destroy all
alterparam mag1 = 0
alterparam mag2 = 1
reset
ac lin 71 17700000000.0 21200000000.0
echo LM_BEGIN pmr06a270_a rev_dense
print real(v(p1)) imag(v(p1)) real(v(p2)) imag(v(p2))
echo LM_END pmr06a270_a rev_dense
ac lin 70 17725000000.0 21175000000.0
echo LM_BEGIN pmr06a270_a rev_mid
print real(v(p1)) imag(v(p1)) real(v(p2)) imag(v(p2))
echo LM_END pmr06a270_a rev_mid
ac dec 100 1000000000.0 100000000000.0
echo LM_BEGIN pmr06a270_a rev_wide
print real(v(p1)) imag(v(p1)) real(v(p2)) imag(v(p2))
echo LM_END pmr06a270_a rev_wide
destroy all
alterparam c_sh1 = 1.725e-13
alterparam l_in = 1.532e-09
alterparam c_sh2 = 0.0
alterparam mag1 = 1
alterparam mag2 = 0
reset
ac lin 71 17700000000.0 21200000000.0
echo LM_BEGIN pmr06a315_a fwd_dense
print real(v(p1)) imag(v(p1)) real(v(p2)) imag(v(p2))
echo LM_END pmr06a315_a fwd_dense
noise v(p2) vs1 lin 71 17700000000.0 21200000000.0
setplot previous
echo LM_BEGIN pmr06a315_a noise_dense
print inoise_spectrum
echo LM_END pmr06a315_a noise_dense
ac lin 70 17725000000.0 21175000000.0
echo LM_BEGIN pmr06a315_a fwd_mid
print real(v(p1)) imag(v(p1)) real(v(p2)) imag(v(p2))
echo LM_END pmr06a315_a fwd_mid
noise v(p2) vs1 lin 70 17725000000.0 21175000000.0
setplot previous
echo LM_BEGIN pmr06a315_a noise_mid
print inoise_spectrum
echo LM_END pmr06a315_a noise_mid
ac dec 100 1000000000.0 100000000000.0
echo LM_BEGIN pmr06a315_a fwd_wide
print real(v(p1)) imag(v(p1)) real(v(p2)) imag(v(p2))
echo LM_END pmr06a315_a fwd_wide
destroy all
alterparam mag1 = 0
alterparam mag2 = 1
reset
ac lin 71 17700000000.0 21200000000.0
echo LM_BEGIN pmr06a315_a rev_dense
print real(v(p1)) imag(v(p1)) real(v(p2)) imag(v(p2))
echo LM_END pmr06a315_a rev_dense
ac lin 70 17725000000.0 21175000000.0
echo LM_BEGIN pmr06a315_a rev_mid
print real(v(p1)) imag(v(p1)) real(v(p2)) imag(v(p2))
echo LM_END pmr06a315_a rev_mid
ac dec 100 1000000000.0 100000000000.0
echo LM_BEGIN pmr06a315_a rev_wide
print real(v(p1)) imag(v(p1)) real(v(p2)) imag(v(p2))
echo LM_END pmr06a315_a rev_wide
destroy all
alterparam c_sh1 = 0.0
alterparam l_in = 1e-18
alterparam c_sh2 = 0.0
alterparam mag1 = 1
alterparam mag2 = 0
reset
ac lin 71 17700000000.0 21200000000.0
echo LM_BEGIN probe_thru fwd_dense
print real(v(p1)) imag(v(p1)) real(v(p2)) imag(v(p2))
echo LM_END probe_thru fwd_dense
noise v(p2) vs1 lin 71 17700000000.0 21200000000.0
setplot previous
echo LM_BEGIN probe_thru noise_dense
print inoise_spectrum
echo LM_END probe_thru noise_dense
destroy all
alterparam mag1 = 0
alterparam mag2 = 1
reset
ac lin 71 17700000000.0 21200000000.0
echo LM_BEGIN probe_thru rev_dense
print real(v(p1)) imag(v(p1)) real(v(p2)) imag(v(p2))
echo LM_END probe_thru rev_dense
destroy all
alterparam c_sh1 = 0.0
alterparam l_in = 5.786e-10
alterparam c_sh2 = 7.715e-14
alterparam mag1 = 1
alterparam mag2 = 0
reset
ac lin 71 17700000000.0 21200000000.0
echo LM_BEGIN probe_r50a000_b fwd_dense
print real(v(p1)) imag(v(p1)) real(v(p2)) imag(v(p2))
echo LM_END probe_r50a000_b fwd_dense
noise v(p2) vs1 lin 71 17700000000.0 21200000000.0
setplot previous
echo LM_BEGIN probe_r50a000_b noise_dense
print inoise_spectrum
echo LM_END probe_r50a000_b noise_dense
destroy all
alterparam mag1 = 0
alterparam mag2 = 1
reset
ac lin 71 17700000000.0 21200000000.0
echo LM_BEGIN probe_r50a000_b rev_dense
print real(v(p1)) imag(v(p1)) real(v(p2)) imag(v(p2))
echo LM_END probe_r50a000_b rev_dense
destroy all
alterparam c_sh1 = 0.0
alterparam l_in = 5.191e-10
alterparam c_sh2 = 2.044e-14
alterparam mag1 = 1
alterparam mag2 = 0
reset
ac lin 71 17700000000.0 21200000000.0
echo LM_BEGIN probe_r50a045_b fwd_dense
print real(v(p1)) imag(v(p1)) real(v(p2)) imag(v(p2))
echo LM_END probe_r50a045_b fwd_dense
noise v(p2) vs1 lin 71 17700000000.0 21200000000.0
setplot previous
echo LM_BEGIN probe_r50a045_b noise_dense
print inoise_spectrum
echo LM_END probe_r50a045_b noise_dense
destroy all
alterparam mag1 = 0
alterparam mag2 = 1
reset
ac lin 71 17700000000.0 21200000000.0
echo LM_BEGIN probe_r50a045_b rev_dense
print real(v(p1)) imag(v(p1)) real(v(p2)) imag(v(p2))
echo LM_END probe_r50a045_b rev_dense
destroy all
alterparam c_sh1 = 1.336e-13
alterparam l_in = 5.277e-10
alterparam c_sh2 = 0.0
alterparam mag1 = 1
alterparam mag2 = 0
reset
ac lin 71 17700000000.0 21200000000.0
echo LM_BEGIN probe_r50a090_a fwd_dense
print real(v(p1)) imag(v(p1)) real(v(p2)) imag(v(p2))
echo LM_END probe_r50a090_a fwd_dense
noise v(p2) vs1 lin 71 17700000000.0 21200000000.0
setplot previous
echo LM_BEGIN probe_r50a090_a noise_dense
print inoise_spectrum
echo LM_END probe_r50a090_a noise_dense
destroy all
alterparam mag1 = 0
alterparam mag2 = 1
reset
ac lin 71 17700000000.0 21200000000.0
echo LM_BEGIN probe_r50a090_a rev_dense
print real(v(p1)) imag(v(p1)) real(v(p2)) imag(v(p2))
echo LM_END probe_r50a090_a rev_dense
destroy all
alterparam c_sh1 = 2.076e-13
alterparam l_in = 3.467e-10
alterparam c_sh2 = 0.0
alterparam mag1 = 1
alterparam mag2 = 0
reset
ac lin 71 17700000000.0 21200000000.0
echo LM_BEGIN probe_r50a135_a fwd_dense
print real(v(p1)) imag(v(p1)) real(v(p2)) imag(v(p2))
echo LM_END probe_r50a135_a fwd_dense
noise v(p2) vs1 lin 71 17700000000.0 21200000000.0
setplot previous
echo LM_BEGIN probe_r50a135_a noise_dense
print inoise_spectrum
echo LM_END probe_r50a135_a noise_dense
destroy all
alterparam mag1 = 0
alterparam mag2 = 1
reset
ac lin 71 17700000000.0 21200000000.0
echo LM_BEGIN probe_r50a135_a rev_dense
print real(v(p1)) imag(v(p1)) real(v(p2)) imag(v(p2))
echo LM_END probe_r50a135_a rev_dense
destroy all
alterparam c_sh1 = 2.314e-13
alterparam l_in = 1.929e-10
alterparam c_sh2 = 0.0
alterparam mag1 = 1
alterparam mag2 = 0
reset
ac lin 71 17700000000.0 21200000000.0
echo LM_BEGIN probe_r50a180_a fwd_dense
print real(v(p1)) imag(v(p1)) real(v(p2)) imag(v(p2))
echo LM_END probe_r50a180_a fwd_dense
noise v(p2) vs1 lin 71 17700000000.0 21200000000.0
setplot previous
echo LM_BEGIN probe_r50a180_a noise_dense
print inoise_spectrum
echo LM_END probe_r50a180_a noise_dense
destroy all
alterparam mag1 = 0
alterparam mag2 = 1
reset
ac lin 71 17700000000.0 21200000000.0
echo LM_BEGIN probe_r50a180_a rev_dense
print real(v(p1)) imag(v(p1)) real(v(p2)) imag(v(p2))
echo LM_END probe_r50a180_a rev_dense
destroy all
alterparam c_sh1 = 2.076e-13
alterparam l_in = 5.109e-11
alterparam c_sh2 = 0.0
alterparam mag1 = 1
alterparam mag2 = 0
reset
ac lin 71 17700000000.0 21200000000.0
echo LM_BEGIN probe_r50a225_a fwd_dense
print real(v(p1)) imag(v(p1)) real(v(p2)) imag(v(p2))
echo LM_END probe_r50a225_a fwd_dense
noise v(p2) vs1 lin 71 17700000000.0 21200000000.0
setplot previous
echo LM_BEGIN probe_r50a225_a noise_dense
print inoise_spectrum
echo LM_END probe_r50a225_a noise_dense
destroy all
alterparam mag1 = 0
alterparam mag2 = 1
reset
ac lin 71 17700000000.0 21200000000.0
echo LM_BEGIN probe_r50a225_a rev_dense
print real(v(p1)) imag(v(p1)) real(v(p2)) imag(v(p2))
echo LM_END probe_r50a225_a rev_dense
destroy all
alterparam c_sh1 = 0.0
alterparam l_in = 3.341e-10
alterparam c_sh2 = 2.111e-13
alterparam mag1 = 1
alterparam mag2 = 0
reset
ac lin 71 17700000000.0 21200000000.0
echo LM_BEGIN probe_r50a270_b fwd_dense
print real(v(p1)) imag(v(p1)) real(v(p2)) imag(v(p2))
echo LM_END probe_r50a270_b fwd_dense
noise v(p2) vs1 lin 71 17700000000.0 21200000000.0
setplot previous
echo LM_BEGIN probe_r50a270_b noise_dense
print inoise_spectrum
echo LM_END probe_r50a270_b noise_dense
destroy all
alterparam mag1 = 0
alterparam mag2 = 1
reset
ac lin 71 17700000000.0 21200000000.0
echo LM_BEGIN probe_r50a270_b rev_dense
print real(v(p1)) imag(v(p1)) real(v(p2)) imag(v(p2))
echo LM_END probe_r50a270_b rev_dense
destroy all
alterparam c_sh1 = 0.0
alterparam l_in = 5.191e-10
alterparam c_sh2 = 1.387e-13
alterparam mag1 = 1
alterparam mag2 = 0
reset
ac lin 71 17700000000.0 21200000000.0
echo LM_BEGIN probe_r50a315_b fwd_dense
print real(v(p1)) imag(v(p1)) real(v(p2)) imag(v(p2))
echo LM_END probe_r50a315_b fwd_dense
noise v(p2) vs1 lin 71 17700000000.0 21200000000.0
setplot previous
echo LM_BEGIN probe_r50a315_b noise_dense
print inoise_spectrum
echo LM_END probe_r50a315_b noise_dense
destroy all
alterparam mag1 = 0
alterparam mag2 = 1
reset
ac lin 71 17700000000.0 21200000000.0
echo LM_BEGIN probe_r50a315_b rev_dense
print real(v(p1)) imag(v(p1)) real(v(p2)) imag(v(p2))
echo LM_END probe_r50a315_b rev_dense
destroy all
echo LM_DONE
.endc
