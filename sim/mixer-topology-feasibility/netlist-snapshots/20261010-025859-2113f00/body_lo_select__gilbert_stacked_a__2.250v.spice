* mixer-topology-feasibility: klt sim body, gilbert_stacked_a, supply 2.250 V -- GENERATED by collect.py, do not edit
.param vdd_val=2.25
.param f1=17700000000.0
.param f2=17700000000.0
.param flo=16700000000.0
.param vrf1=0.0
.param vrf2=0.0
.param vlo=0.0
.param rf_dc=0.0
.param lo_dc=1.88
.options reltol=1e-5

* Mixer-topology feasibility bench (issue #35): COMMON PORT DEFINITIONS.
*
* DEVICE-LEVEL TOPOLOGY STUDY, NOT A DESIGN. This file is prepended by
* ../mixfeas.py (compose_fragment) to EVERY candidate fragment in this
* directory, so all candidates see bit-identical port, power and supply
* conventions. Only the candidate fragment differs. Harness fragment rules
* apply (sim/harness/testbench.py): no .lib/.temp/.include/.control/.end.
*
* Parameters set by the driver (generated .param lines, then alterparam in
* the control block), never by a candidate:
*   vdd_val  supply rail for this PVT point (sim/harness)
*   f1, f2   RF tone frequencies [Hz] (single-tone runs: vrf2 = 0)
*   flo      LO frequency [Hz] (low-side: RF - 1 GHz, see tb.json "study")
*   vrf1/2   open-circuit PEAK voltage of each RF tone [V]
*   vlo      open-circuit PEAK DIFFERENTIAL LO voltage [V]
*   rf_dc    DC level of the RF source leg (an ideal bias tee; 0 if the
*            candidate biases its RF input itself)
*   lo_dc    DC level of BOTH LO source legs (ideal bias tee)
*
* ---- Ports -------------------------------------------------------------------
* RF:  single-ended 50 ohm Thevenin port. Reference plane = node rf_port.
*      Available power per tone  P_av = vrf^2 / (8 * z0).
*      With the RF source at 0 (RF off) Rrf is the RF port's 50 ohm
*      termination; LO-to-RF leakage = |V(rf_port) at flo|^2 / (2 * z0),
*      i.e. power DELIVERED into that termination.
* LO:  differential 100 ohm reference port: two 50 ohm legs driven in
*      antiphase (+vlo/2, -vlo/2 peak). Reference plane = nodes lo_p/lo_n.
*      Thevenin differential open-circuit peak = vlo, R_diff = 2 * z0, so
*      the TOTAL available LO power is P_av = vlo^2 / (8 * R_diff)
*      (issue #35 formula), quoted as one number, not per leg. The loaded
*      differential voltage is V(lo_p) - V(lo_n) at flo.
* IF:  physical 50 ohm termination Rif at node if_out. Every candidate
*      transforms its output to if_out with an ideal transformer stated in
*      its own fragment header; IF power = |V(if_out) at f_if|^2 / (2 * z0),
*      power DELIVERED into Rif. LO-to-IF leakage is the same quantity at flo
*      with the RF source off.
* Rail: Vdd, node vdd. Mixer-only DC rail power = vdd_val * (-I(Vdd)),
*      averaged over the retained window (and at the DC operating point).
*      Ideal bias sources (rf_dc, lo_dc, candidate bias sources) are NOT
*      rail power; they are ideal bias elements, stated as such.
*
* No inductor of any kind appears here or in any candidate. The two ideal
* transformer subcircuits below are lossless, frequency-independent,
* DC-coupled controlled-source models (E/F sources); they are ideal baluns,
* not a passive model of anything on this PDK.

.param z0=50

* ---- supply ---------------------------------------------------------------
Vdd vdd 0 DC {vdd_val}

* ---- RF port: two series tones behind one 50 ohm source resistance ------
Vrf1 rfa 0 DC {rf_dc} SIN({rf_dc} {vrf1} {f1})
Vrf2 rfs rfa DC 0 SIN(0 {vrf2} {f2})
Rrf rfs rf_port {z0}

* ---- LO port: two antiphase 50 ohm legs (ideal bias tee = lo_dc) ---------
Vlop lops 0 DC {lo_dc} SIN({lo_dc} {vlo/2} {flo})
Vlon lons 0 DC {lo_dc} SIN({lo_dc} {-vlo/2} {flo})
Rlop lops lo_p {z0}
Rlon lons lo_n {z0}

* ---- IF termination -----------------------------------------------------------
Rif if_out 0 {z0}

* ---- ideal transformers -------------------------------------------------------
* mf_balun: single-ended winding se (to ground) <-> centre-tapped
* differential winding pos/neg around ct.
*   V(pos) - V(neg) = n * V(se)       (each half n/2, antiphase about ct)
*   I into se        = n * I_diff      (power conserving)
* so Z_diff = n^2 * Z_se. Bidirectional: either side may be the source.
.subckt mf_balun se pos neg ct n=1
Ep pi ct se 0 {n/2}
Vsp pi pos 0
En ni ct se 0 {-n/2}
Vsn ni neg 0
Fp se 0 Vsp {n/2}
Fn se 0 Vsn {-n/2}
.ends mf_balun

* mf_xfmr: single-ended to single-ended ideal transformer (both windings to
* ground), V(sec) = n * V(pri), I into pri = n * I out of sec, so
* Z_pri = Z_sec / n^2.
.subckt mf_xfmr pri sec n=1
Es si 0 pri 0 {n}
Vss si sec 0
Fs pri 0 Vss {n}
.ends mf_xfmr

* Candidate "gilbert_stacked": classic double-balanced Gilbert cell, stacked.
*
* SIZING FOLLOW-UP #61 -- sizing A (3 mA tail). Declared in tb.json BEFORE collection and not
* tuned afterwards. Reason (from the first record, 20261010-010744-a10c193): the
* LO quad's retained V_BE fell below the card's 0.65 V floor from -9 dBm while
* the gain was still rising. A switching device's V_BE trough is roughly
* (V_BE,on - differential swing), so the lever kept inside the declared sweep and
* limits is the on-state current density, which raises V_BE,on. Here: tail 3 mA
* (was 2 mA), i.e. 1.5 mA per RF-pair device and <= 1.5 mA peak per quad device
* (card limit 3 mA); load RL = 270 ohm keeps the ~0.4 V average drop of the
* original (1.5 mA x 270 = 0.405 V); LO quad bias lo_dc = 1.88 V (was 1.85 V) keeps the quad
* emitters near the original ~1 V. Hand estimates, NOT results. The RF pair bias,
* IF network and ports are unchanged. Only the .param line below differs from
* cand_gilbert_stacked.spice.
*
* DEVICE-LEVEL TOPOLOGY STUDY, NOT A DESIGN (issue #35). One fixed,
* documented sizing/bias choice; no optimizer. Ideal baluns, ideal R/C and
* ideal bias sources only; no inductor. Prepended by ports_common.spice.
*
* Stack (ground up): ideal tail current sink -> RF differential pair Q1/Q2
* -> LO switching quad Q3..Q6 -> collector load resistors to vdd. Three
* levels (sink, RF pair, quad) plus the load share the rail: this is the
* headroom question row 17 asks.
*
* Sizing (all devices npn13G2 Nx=1, card limit Ic < 3 mA):
*   I_tail = 2 mA ideal sink         1 mA per RF device, 0.5-1 mA per quad device
*   RF pair bases: ideal balun CT = 1.10 V  -> tail node ~0.18-0.30 V over T
*   LO quad bases: lo_dc = 1.85 V (ideal bias tee in the LO legs)
*                                    -> quad emitters (x1/x2) ~0.95-1.07 V
*   RL = 400 ohm per output node, 1 mA average each -> collectors vdd-0.4 V
*   Cout = 0.5 pF per output node to ground (IF filter; 16 ohm at 20 GHz,
*          318 ohm at 1 GHz) -- the same IF network every candidate uses.
* Hand estimate of V_CE at the DC point (Vbe ~0.78/0.86/0.90 V at
* 125/27/-40 C for ~0.5-1 mA): RF pair ~0.77 V, quad ~0.55-1.08 V across
* 2.025-2.475 V. These are design intents, NOT results; the bench measures
* every device's V_CE/V_BE/Ic.
*
* Ports (see ports_common.spice):
*   RF: rf_port -> ideal balun mf_balun n=1 (50 ohm SE <-> 50 ohm diff),
*       centre tap = ideal 1.10 V bias source; RF pair bases DC-coupled.
*       rf_dc = 0 (the candidate biases via the centre tap).
*   LO: lo_p/lo_n drive the quad bases directly; lo_dc = 1.85 V.
*   IF: ideal balun n=2 directly across out_p/out_n (200 ohm diff <->
*       50 ohm SE) -> if_out (Rif = 50 ohm). Its centre tap gs_ifct is left
*       FLOATING, so the output common mode is unconstrained and no DC block
*       (and no DC-block settling) is needed. A DC DIFFERENTIAL collector
*       voltage (mismatch only) does drive DC into Rif through the ideal
*       balun; a real transformer winding would instead short it. Either way
*       it lands in the DC bin, not in any measured bin.
*
* Every HBT collector is fed through a 0 V sense source vic_<dev> so the
* driver can read Ic; c/b/e nodes are explicit (c_<dev>, ...). The device
* list (name, nodes, Nx) is declared in tb.json "study.candidates" and must
* match this file (mixfeas.check_fragment_devices enforces it).

.param gs_itail=3m gs_vbrf=1.10 gs_rl=270 gs_cout=0.5p

* ---- RF input balun, centre tap at the RF-pair bias -------------------------
Vgs_brf gs_brf 0 DC {gs_vbrf}
Xgs_rfbal rf_port b_q1 b_q2 gs_brf mf_balun n=1

* ---- RF transconductor pair --------------------------------------------------
vic_q1 x1 c_q1 0
Xq1 c_q1 b_q1 e_q1 0 npn13G2 Nx=1
vic_q2 x2 c_q2 0
Xq2 c_q2 b_q2 e_q2 0 npn13G2 Nx=1
Vgs_e1 e_q1 tail 0
Vgs_e2 e_q2 tail 0
Igs_tail tail 0 DC {gs_itail}

* ---- LO switching quad ---------------------------------------------------------
vic_q3 out_p c_q3 0
Xq3 c_q3 lo_p x1 0 npn13G2 Nx=1
vic_q4 out_n c_q4 0
Xq4 c_q4 lo_n x1 0 npn13G2 Nx=1
vic_q5 out_n c_q5 0
Xq5 c_q5 lo_p x2 0 npn13G2 Nx=1
vic_q6 out_p c_q6 0
Xq6 c_q6 lo_n x2 0 npn13G2 Nx=1

* ---- loads, IF filter, output balun -----------------------------------------
Rgs_lp vdd out_p {gs_rl}
Rgs_ln vdd out_n {gs_rl}
Cgs_op out_p 0 {gs_cout}
Cgs_on out_n 0 {gs_cout}
Xgs_ifbal if_out out_p out_n gs_ifct mf_balun n=2

.control
set numdgt=10
set noaskquit
echo "MF_DECK_BEGIN"
echo "MFRUN ls_f17p70_m30_rf60"
alterparam f1 = 17700000000.0
alterparam f2 = 17700000000.0
alterparam flo = 16700000000.0
alterparam vrf1 = 0.0006324555320336759
alterparam vrf2 = 0.0
alterparam vlo = 0.0282842712474619
reset
op
let mf_dcirail = 0 - i(vdd)
let mf_dc_vce_q1 = v(c_q1)-v(e_q1)
let mf_dc_vbe_q1 = v(b_q1)-v(e_q1)
let mf_dc_ic_q1 = i(vic_q1)
let mf_dc_vce_q2 = v(c_q2)-v(e_q2)
let mf_dc_vbe_q2 = v(b_q2)-v(e_q2)
let mf_dc_ic_q2 = i(vic_q2)
let mf_dc_vce_q3 = v(c_q3)-v(x1)
let mf_dc_vbe_q3 = v(lo_p)-v(x1)
let mf_dc_ic_q3 = i(vic_q3)
let mf_dc_vce_q4 = v(c_q4)-v(x1)
let mf_dc_vbe_q4 = v(lo_n)-v(x1)
let mf_dc_ic_q4 = i(vic_q4)
let mf_dc_vce_q5 = v(c_q5)-v(x2)
let mf_dc_vbe_q5 = v(lo_p)-v(x2)
let mf_dc_ic_q5 = i(vic_q5)
let mf_dc_vce_q6 = v(c_q6)-v(x2)
let mf_dc_vbe_q6 = v(lo_n)-v(x2)
let mf_dc_ic_q6 = i(vic_q6)
let mf_dc_sink_tail = v(tail)
print mf_dcirail
print mf_dc_vce_q1
print mf_dc_vbe_q1
print mf_dc_ic_q1
print mf_dc_vce_q2
print mf_dc_vbe_q2
print mf_dc_ic_q2
print mf_dc_vce_q3
print mf_dc_vbe_q3
print mf_dc_ic_q3
print mf_dc_vce_q4
print mf_dc_vbe_q4
print mf_dc_ic_q4
print mf_dc_vce_q5
print mf_dc_vbe_q5
print mf_dc_ic_q5
print mf_dc_vce_q6
print mf_dc_vbe_q6
print mf_dc_ic_q6
print mf_dc_sink_tail
tran 1e-12 4e-08 0 1e-12
let mfq_vce_q1 = v(c_q1)-v(e_q1)
meas tran mf_su_vcemax_q1 MAX mfq_vce_q1 from=0.0 to=2e-08
meas tran mf_su_vcemin_q1 MIN mfq_vce_q1 from=0.0 to=2e-08
meas tran mf_ss_vcemax_q1 MAX mfq_vce_q1 from=2e-08 to=4e-08
meas tran mf_ss_vcemin_q1 MIN mfq_vce_q1 from=2e-08 to=4e-08
let mfq_vbe_q1 = v(b_q1)-v(e_q1)
meas tran mf_su_vbemax_q1 MAX mfq_vbe_q1 from=0.0 to=2e-08
meas tran mf_su_vbemin_q1 MIN mfq_vbe_q1 from=0.0 to=2e-08
meas tran mf_ss_vbemax_q1 MAX mfq_vbe_q1 from=2e-08 to=4e-08
meas tran mf_ss_vbemin_q1 MIN mfq_vbe_q1 from=2e-08 to=4e-08
let mfq_ic_q1 = i(vic_q1)
meas tran mf_su_icmax_q1 MAX mfq_ic_q1 from=0.0 to=2e-08
meas tran mf_su_icmin_q1 MIN mfq_ic_q1 from=0.0 to=2e-08
meas tran mf_ss_icmax_q1 MAX mfq_ic_q1 from=2e-08 to=4e-08
meas tran mf_ss_icmin_q1 MIN mfq_ic_q1 from=2e-08 to=4e-08
let mfq_vce_q2 = v(c_q2)-v(e_q2)
meas tran mf_su_vcemax_q2 MAX mfq_vce_q2 from=0.0 to=2e-08
meas tran mf_su_vcemin_q2 MIN mfq_vce_q2 from=0.0 to=2e-08
meas tran mf_ss_vcemax_q2 MAX mfq_vce_q2 from=2e-08 to=4e-08
meas tran mf_ss_vcemin_q2 MIN mfq_vce_q2 from=2e-08 to=4e-08
let mfq_vbe_q2 = v(b_q2)-v(e_q2)
meas tran mf_su_vbemax_q2 MAX mfq_vbe_q2 from=0.0 to=2e-08
meas tran mf_su_vbemin_q2 MIN mfq_vbe_q2 from=0.0 to=2e-08
meas tran mf_ss_vbemax_q2 MAX mfq_vbe_q2 from=2e-08 to=4e-08
meas tran mf_ss_vbemin_q2 MIN mfq_vbe_q2 from=2e-08 to=4e-08
let mfq_ic_q2 = i(vic_q2)
meas tran mf_su_icmax_q2 MAX mfq_ic_q2 from=0.0 to=2e-08
meas tran mf_su_icmin_q2 MIN mfq_ic_q2 from=0.0 to=2e-08
meas tran mf_ss_icmax_q2 MAX mfq_ic_q2 from=2e-08 to=4e-08
meas tran mf_ss_icmin_q2 MIN mfq_ic_q2 from=2e-08 to=4e-08
let mfq_vce_q3 = v(c_q3)-v(x1)
meas tran mf_su_vcemax_q3 MAX mfq_vce_q3 from=0.0 to=2e-08
meas tran mf_su_vcemin_q3 MIN mfq_vce_q3 from=0.0 to=2e-08
meas tran mf_ss_vcemax_q3 MAX mfq_vce_q3 from=2e-08 to=4e-08
meas tran mf_ss_vcemin_q3 MIN mfq_vce_q3 from=2e-08 to=4e-08
let mfq_vbe_q3 = v(lo_p)-v(x1)
meas tran mf_su_vbemax_q3 MAX mfq_vbe_q3 from=0.0 to=2e-08
meas tran mf_su_vbemin_q3 MIN mfq_vbe_q3 from=0.0 to=2e-08
meas tran mf_ss_vbemax_q3 MAX mfq_vbe_q3 from=2e-08 to=4e-08
meas tran mf_ss_vbemin_q3 MIN mfq_vbe_q3 from=2e-08 to=4e-08
let mfq_ic_q3 = i(vic_q3)
meas tran mf_su_icmax_q3 MAX mfq_ic_q3 from=0.0 to=2e-08
meas tran mf_su_icmin_q3 MIN mfq_ic_q3 from=0.0 to=2e-08
meas tran mf_ss_icmax_q3 MAX mfq_ic_q3 from=2e-08 to=4e-08
meas tran mf_ss_icmin_q3 MIN mfq_ic_q3 from=2e-08 to=4e-08
let mfq_vce_q4 = v(c_q4)-v(x1)
meas tran mf_su_vcemax_q4 MAX mfq_vce_q4 from=0.0 to=2e-08
meas tran mf_su_vcemin_q4 MIN mfq_vce_q4 from=0.0 to=2e-08
meas tran mf_ss_vcemax_q4 MAX mfq_vce_q4 from=2e-08 to=4e-08
meas tran mf_ss_vcemin_q4 MIN mfq_vce_q4 from=2e-08 to=4e-08
let mfq_vbe_q4 = v(lo_n)-v(x1)
meas tran mf_su_vbemax_q4 MAX mfq_vbe_q4 from=0.0 to=2e-08
meas tran mf_su_vbemin_q4 MIN mfq_vbe_q4 from=0.0 to=2e-08
meas tran mf_ss_vbemax_q4 MAX mfq_vbe_q4 from=2e-08 to=4e-08
meas tran mf_ss_vbemin_q4 MIN mfq_vbe_q4 from=2e-08 to=4e-08
let mfq_ic_q4 = i(vic_q4)
meas tran mf_su_icmax_q4 MAX mfq_ic_q4 from=0.0 to=2e-08
meas tran mf_su_icmin_q4 MIN mfq_ic_q4 from=0.0 to=2e-08
meas tran mf_ss_icmax_q4 MAX mfq_ic_q4 from=2e-08 to=4e-08
meas tran mf_ss_icmin_q4 MIN mfq_ic_q4 from=2e-08 to=4e-08
let mfq_vce_q5 = v(c_q5)-v(x2)
meas tran mf_su_vcemax_q5 MAX mfq_vce_q5 from=0.0 to=2e-08
meas tran mf_su_vcemin_q5 MIN mfq_vce_q5 from=0.0 to=2e-08
meas tran mf_ss_vcemax_q5 MAX mfq_vce_q5 from=2e-08 to=4e-08
meas tran mf_ss_vcemin_q5 MIN mfq_vce_q5 from=2e-08 to=4e-08
let mfq_vbe_q5 = v(lo_p)-v(x2)
meas tran mf_su_vbemax_q5 MAX mfq_vbe_q5 from=0.0 to=2e-08
meas tran mf_su_vbemin_q5 MIN mfq_vbe_q5 from=0.0 to=2e-08
meas tran mf_ss_vbemax_q5 MAX mfq_vbe_q5 from=2e-08 to=4e-08
meas tran mf_ss_vbemin_q5 MIN mfq_vbe_q5 from=2e-08 to=4e-08
let mfq_ic_q5 = i(vic_q5)
meas tran mf_su_icmax_q5 MAX mfq_ic_q5 from=0.0 to=2e-08
meas tran mf_su_icmin_q5 MIN mfq_ic_q5 from=0.0 to=2e-08
meas tran mf_ss_icmax_q5 MAX mfq_ic_q5 from=2e-08 to=4e-08
meas tran mf_ss_icmin_q5 MIN mfq_ic_q5 from=2e-08 to=4e-08
let mfq_vce_q6 = v(c_q6)-v(x2)
meas tran mf_su_vcemax_q6 MAX mfq_vce_q6 from=0.0 to=2e-08
meas tran mf_su_vcemin_q6 MIN mfq_vce_q6 from=0.0 to=2e-08
meas tran mf_ss_vcemax_q6 MAX mfq_vce_q6 from=2e-08 to=4e-08
meas tran mf_ss_vcemin_q6 MIN mfq_vce_q6 from=2e-08 to=4e-08
let mfq_vbe_q6 = v(lo_n)-v(x2)
meas tran mf_su_vbemax_q6 MAX mfq_vbe_q6 from=0.0 to=2e-08
meas tran mf_su_vbemin_q6 MIN mfq_vbe_q6 from=0.0 to=2e-08
meas tran mf_ss_vbemax_q6 MAX mfq_vbe_q6 from=2e-08 to=4e-08
meas tran mf_ss_vbemin_q6 MIN mfq_vbe_q6 from=2e-08 to=4e-08
let mfq_ic_q6 = i(vic_q6)
meas tran mf_su_icmax_q6 MAX mfq_ic_q6 from=0.0 to=2e-08
meas tran mf_su_icmin_q6 MIN mfq_ic_q6 from=0.0 to=2e-08
meas tran mf_ss_icmax_q6 MAX mfq_ic_q6 from=2e-08 to=4e-08
meas tran mf_ss_icmin_q6 MIN mfq_ic_q6 from=2e-08 to=4e-08
meas tran mf_su_sinkmin_tail MIN v(tail) from=0.0 to=2e-08
meas tran mf_ss_sinkmin_tail MIN v(tail) from=2e-08 to=4e-08
print mf_su_vcemax_q1
print mf_su_vcemin_q1
print mf_ss_vcemax_q1
print mf_ss_vcemin_q1
print mf_su_vbemax_q1
print mf_su_vbemin_q1
print mf_ss_vbemax_q1
print mf_ss_vbemin_q1
print mf_su_icmax_q1
print mf_su_icmin_q1
print mf_ss_icmax_q1
print mf_ss_icmin_q1
print mf_su_vcemax_q2
print mf_su_vcemin_q2
print mf_ss_vcemax_q2
print mf_ss_vcemin_q2
print mf_su_vbemax_q2
print mf_su_vbemin_q2
print mf_ss_vbemax_q2
print mf_ss_vbemin_q2
print mf_su_icmax_q2
print mf_su_icmin_q2
print mf_ss_icmax_q2
print mf_ss_icmin_q2
print mf_su_vcemax_q3
print mf_su_vcemin_q3
print mf_ss_vcemax_q3
print mf_ss_vcemin_q3
print mf_su_vbemax_q3
print mf_su_vbemin_q3
print mf_ss_vbemax_q3
print mf_ss_vbemin_q3
print mf_su_icmax_q3
print mf_su_icmin_q3
print mf_ss_icmax_q3
print mf_ss_icmin_q3
print mf_su_vcemax_q4
print mf_su_vcemin_q4
print mf_ss_vcemax_q4
print mf_ss_vcemin_q4
print mf_su_vbemax_q4
print mf_su_vbemin_q4
print mf_ss_vbemax_q4
print mf_ss_vbemin_q4
print mf_su_icmax_q4
print mf_su_icmin_q4
print mf_ss_icmax_q4
print mf_ss_icmin_q4
print mf_su_vcemax_q5
print mf_su_vcemin_q5
print mf_ss_vcemax_q5
print mf_ss_vcemin_q5
print mf_su_vbemax_q5
print mf_su_vbemin_q5
print mf_ss_vbemax_q5
print mf_ss_vbemin_q5
print mf_su_icmax_q5
print mf_su_icmin_q5
print mf_ss_icmax_q5
print mf_ss_icmin_q5
print mf_su_vcemax_q6
print mf_su_vcemin_q6
print mf_ss_vcemax_q6
print mf_ss_vcemin_q6
print mf_su_vbemax_q6
print mf_su_vbemin_q6
print mf_ss_vbemax_q6
print mf_ss_vbemin_q6
print mf_su_icmax_q6
print mf_su_icmin_q6
print mf_ss_icmax_q6
print mf_ss_icmin_q6
print mf_su_sinkmin_tail
print mf_ss_sinkmin_tail
linearize
let mf_l = length(time)
let mfw = (time ge 1.99995e-08) * (time lt 3.99995e-08)
let mf_n = mean(mfw) * mf_l
let mfs = mf_l / mf_n
let mf_prail = mean(v(vdd) * (0 - i(vdd)) * mfw) * mfs
let mfph = 2 * pi * 16700000000.0 * (time - 2e-08)
let mf_lodiff_re = 2 * mean((v(lo_p)-v(lo_n)) * mfw * cos(mfph)) * mfs
let mf_lodiff_im = 2 * mean((v(lo_p)-v(lo_n)) * mfw * sin(mfph)) * mfs
let mfph = 2 * pi * 1000000000.0 * (time - 2e-08)
let mf_if_re = 2 * mean((v(if_out)) * mfw * cos(mfph)) * mfs
let mf_if_im = 2 * mean((v(if_out)) * mfw * sin(mfph)) * mfs
let mfph = 2 * pi * 16700000000.0 * (time - 2e-08)
let mf_loif_re = 2 * mean((v(if_out)) * mfw * cos(mfph)) * mfs
let mf_loif_im = 2 * mean((v(if_out)) * mfw * sin(mfph)) * mfs
let mfph = 2 * pi * 16700000000.0 * (time - 2e-08)
let mf_lorf_re = 2 * mean((v(rf_port)) * mfw * cos(mfph)) * mfs
let mf_lorf_im = 2 * mean((v(rf_port)) * mfw * sin(mfph)) * mfs
let mfph = 2 * pi * 950000000.0 * (time - 2e-08)
let mf_flifa_re = 2 * mean((v(if_out)) * mfw * cos(mfph)) * mfs
let mf_flifa_im = 2 * mean((v(if_out)) * mfw * sin(mfph)) * mfs
let mfph = 2 * pi * 1050000000.0 * (time - 2e-08)
let mf_flifb_re = 2 * mean((v(if_out)) * mfw * cos(mfph)) * mfs
let mf_flifb_im = 2 * mean((v(if_out)) * mfw * sin(mfph)) * mfs
let mfph = 2 * pi * 16750000000.0 * (time - 2e-08)
let mf_fllorf_re = 2 * mean((v(rf_port)) * mfw * cos(mfph)) * mfs
let mf_fllorf_im = 2 * mean((v(rf_port)) * mfw * sin(mfph)) * mfs
let mfph = 2 * pi * 16750000000.0 * (time - 2e-08)
let mf_flloif_re = 2 * mean((v(if_out)) * mfw * cos(mfph)) * mfs
let mf_flloif_im = 2 * mean((v(if_out)) * mfw * sin(mfph)) * mfs
print mf_l
print mf_n
print mf_prail
print mf_lodiff_re
print mf_lodiff_im
print mf_if_re
print mf_if_im
print mf_loif_re
print mf_loif_im
print mf_lorf_re
print mf_lorf_im
print mf_flifa_re
print mf_flifa_im
print mf_flifb_re
print mf_flifb_im
print mf_fllorf_re
print mf_fllorf_im
print mf_flloif_re
print mf_flloif_im
destroy all
echo "MFEND ls_f17p70_m30_rf60"
echo "MFRUN ls_f17p70_m30_rf66"
alterparam f1 = 17700000000.0
alterparam f2 = 17700000000.0
alterparam flo = 16700000000.0
alterparam vrf1 = 0.00031697863849222284
alterparam vrf2 = 0.0
alterparam vlo = 0.0282842712474619
reset
op
let mf_dcirail = 0 - i(vdd)
let mf_dc_vce_q1 = v(c_q1)-v(e_q1)
let mf_dc_vbe_q1 = v(b_q1)-v(e_q1)
let mf_dc_ic_q1 = i(vic_q1)
let mf_dc_vce_q2 = v(c_q2)-v(e_q2)
let mf_dc_vbe_q2 = v(b_q2)-v(e_q2)
let mf_dc_ic_q2 = i(vic_q2)
let mf_dc_vce_q3 = v(c_q3)-v(x1)
let mf_dc_vbe_q3 = v(lo_p)-v(x1)
let mf_dc_ic_q3 = i(vic_q3)
let mf_dc_vce_q4 = v(c_q4)-v(x1)
let mf_dc_vbe_q4 = v(lo_n)-v(x1)
let mf_dc_ic_q4 = i(vic_q4)
let mf_dc_vce_q5 = v(c_q5)-v(x2)
let mf_dc_vbe_q5 = v(lo_p)-v(x2)
let mf_dc_ic_q5 = i(vic_q5)
let mf_dc_vce_q6 = v(c_q6)-v(x2)
let mf_dc_vbe_q6 = v(lo_n)-v(x2)
let mf_dc_ic_q6 = i(vic_q6)
let mf_dc_sink_tail = v(tail)
print mf_dcirail
print mf_dc_vce_q1
print mf_dc_vbe_q1
print mf_dc_ic_q1
print mf_dc_vce_q2
print mf_dc_vbe_q2
print mf_dc_ic_q2
print mf_dc_vce_q3
print mf_dc_vbe_q3
print mf_dc_ic_q3
print mf_dc_vce_q4
print mf_dc_vbe_q4
print mf_dc_ic_q4
print mf_dc_vce_q5
print mf_dc_vbe_q5
print mf_dc_ic_q5
print mf_dc_vce_q6
print mf_dc_vbe_q6
print mf_dc_ic_q6
print mf_dc_sink_tail
tran 1e-12 4e-08 0 1e-12
let mfq_vce_q1 = v(c_q1)-v(e_q1)
meas tran mf_su_vcemax_q1 MAX mfq_vce_q1 from=0.0 to=2e-08
meas tran mf_su_vcemin_q1 MIN mfq_vce_q1 from=0.0 to=2e-08
meas tran mf_ss_vcemax_q1 MAX mfq_vce_q1 from=2e-08 to=4e-08
meas tran mf_ss_vcemin_q1 MIN mfq_vce_q1 from=2e-08 to=4e-08
let mfq_vbe_q1 = v(b_q1)-v(e_q1)
meas tran mf_su_vbemax_q1 MAX mfq_vbe_q1 from=0.0 to=2e-08
meas tran mf_su_vbemin_q1 MIN mfq_vbe_q1 from=0.0 to=2e-08
meas tran mf_ss_vbemax_q1 MAX mfq_vbe_q1 from=2e-08 to=4e-08
meas tran mf_ss_vbemin_q1 MIN mfq_vbe_q1 from=2e-08 to=4e-08
let mfq_ic_q1 = i(vic_q1)
meas tran mf_su_icmax_q1 MAX mfq_ic_q1 from=0.0 to=2e-08
meas tran mf_su_icmin_q1 MIN mfq_ic_q1 from=0.0 to=2e-08
meas tran mf_ss_icmax_q1 MAX mfq_ic_q1 from=2e-08 to=4e-08
meas tran mf_ss_icmin_q1 MIN mfq_ic_q1 from=2e-08 to=4e-08
let mfq_vce_q2 = v(c_q2)-v(e_q2)
meas tran mf_su_vcemax_q2 MAX mfq_vce_q2 from=0.0 to=2e-08
meas tran mf_su_vcemin_q2 MIN mfq_vce_q2 from=0.0 to=2e-08
meas tran mf_ss_vcemax_q2 MAX mfq_vce_q2 from=2e-08 to=4e-08
meas tran mf_ss_vcemin_q2 MIN mfq_vce_q2 from=2e-08 to=4e-08
let mfq_vbe_q2 = v(b_q2)-v(e_q2)
meas tran mf_su_vbemax_q2 MAX mfq_vbe_q2 from=0.0 to=2e-08
meas tran mf_su_vbemin_q2 MIN mfq_vbe_q2 from=0.0 to=2e-08
meas tran mf_ss_vbemax_q2 MAX mfq_vbe_q2 from=2e-08 to=4e-08
meas tran mf_ss_vbemin_q2 MIN mfq_vbe_q2 from=2e-08 to=4e-08
let mfq_ic_q2 = i(vic_q2)
meas tran mf_su_icmax_q2 MAX mfq_ic_q2 from=0.0 to=2e-08
meas tran mf_su_icmin_q2 MIN mfq_ic_q2 from=0.0 to=2e-08
meas tran mf_ss_icmax_q2 MAX mfq_ic_q2 from=2e-08 to=4e-08
meas tran mf_ss_icmin_q2 MIN mfq_ic_q2 from=2e-08 to=4e-08
let mfq_vce_q3 = v(c_q3)-v(x1)
meas tran mf_su_vcemax_q3 MAX mfq_vce_q3 from=0.0 to=2e-08
meas tran mf_su_vcemin_q3 MIN mfq_vce_q3 from=0.0 to=2e-08
meas tran mf_ss_vcemax_q3 MAX mfq_vce_q3 from=2e-08 to=4e-08
meas tran mf_ss_vcemin_q3 MIN mfq_vce_q3 from=2e-08 to=4e-08
let mfq_vbe_q3 = v(lo_p)-v(x1)
meas tran mf_su_vbemax_q3 MAX mfq_vbe_q3 from=0.0 to=2e-08
meas tran mf_su_vbemin_q3 MIN mfq_vbe_q3 from=0.0 to=2e-08
meas tran mf_ss_vbemax_q3 MAX mfq_vbe_q3 from=2e-08 to=4e-08
meas tran mf_ss_vbemin_q3 MIN mfq_vbe_q3 from=2e-08 to=4e-08
let mfq_ic_q3 = i(vic_q3)
meas tran mf_su_icmax_q3 MAX mfq_ic_q3 from=0.0 to=2e-08
meas tran mf_su_icmin_q3 MIN mfq_ic_q3 from=0.0 to=2e-08
meas tran mf_ss_icmax_q3 MAX mfq_ic_q3 from=2e-08 to=4e-08
meas tran mf_ss_icmin_q3 MIN mfq_ic_q3 from=2e-08 to=4e-08
let mfq_vce_q4 = v(c_q4)-v(x1)
meas tran mf_su_vcemax_q4 MAX mfq_vce_q4 from=0.0 to=2e-08
meas tran mf_su_vcemin_q4 MIN mfq_vce_q4 from=0.0 to=2e-08
meas tran mf_ss_vcemax_q4 MAX mfq_vce_q4 from=2e-08 to=4e-08
meas tran mf_ss_vcemin_q4 MIN mfq_vce_q4 from=2e-08 to=4e-08
let mfq_vbe_q4 = v(lo_n)-v(x1)
meas tran mf_su_vbemax_q4 MAX mfq_vbe_q4 from=0.0 to=2e-08
meas tran mf_su_vbemin_q4 MIN mfq_vbe_q4 from=0.0 to=2e-08
meas tran mf_ss_vbemax_q4 MAX mfq_vbe_q4 from=2e-08 to=4e-08
meas tran mf_ss_vbemin_q4 MIN mfq_vbe_q4 from=2e-08 to=4e-08
let mfq_ic_q4 = i(vic_q4)
meas tran mf_su_icmax_q4 MAX mfq_ic_q4 from=0.0 to=2e-08
meas tran mf_su_icmin_q4 MIN mfq_ic_q4 from=0.0 to=2e-08
meas tran mf_ss_icmax_q4 MAX mfq_ic_q4 from=2e-08 to=4e-08
meas tran mf_ss_icmin_q4 MIN mfq_ic_q4 from=2e-08 to=4e-08
let mfq_vce_q5 = v(c_q5)-v(x2)
meas tran mf_su_vcemax_q5 MAX mfq_vce_q5 from=0.0 to=2e-08
meas tran mf_su_vcemin_q5 MIN mfq_vce_q5 from=0.0 to=2e-08
meas tran mf_ss_vcemax_q5 MAX mfq_vce_q5 from=2e-08 to=4e-08
meas tran mf_ss_vcemin_q5 MIN mfq_vce_q5 from=2e-08 to=4e-08
let mfq_vbe_q5 = v(lo_p)-v(x2)
meas tran mf_su_vbemax_q5 MAX mfq_vbe_q5 from=0.0 to=2e-08
meas tran mf_su_vbemin_q5 MIN mfq_vbe_q5 from=0.0 to=2e-08
meas tran mf_ss_vbemax_q5 MAX mfq_vbe_q5 from=2e-08 to=4e-08
meas tran mf_ss_vbemin_q5 MIN mfq_vbe_q5 from=2e-08 to=4e-08
let mfq_ic_q5 = i(vic_q5)
meas tran mf_su_icmax_q5 MAX mfq_ic_q5 from=0.0 to=2e-08
meas tran mf_su_icmin_q5 MIN mfq_ic_q5 from=0.0 to=2e-08
meas tran mf_ss_icmax_q5 MAX mfq_ic_q5 from=2e-08 to=4e-08
meas tran mf_ss_icmin_q5 MIN mfq_ic_q5 from=2e-08 to=4e-08
let mfq_vce_q6 = v(c_q6)-v(x2)
meas tran mf_su_vcemax_q6 MAX mfq_vce_q6 from=0.0 to=2e-08
meas tran mf_su_vcemin_q6 MIN mfq_vce_q6 from=0.0 to=2e-08
meas tran mf_ss_vcemax_q6 MAX mfq_vce_q6 from=2e-08 to=4e-08
meas tran mf_ss_vcemin_q6 MIN mfq_vce_q6 from=2e-08 to=4e-08
let mfq_vbe_q6 = v(lo_n)-v(x2)
meas tran mf_su_vbemax_q6 MAX mfq_vbe_q6 from=0.0 to=2e-08
meas tran mf_su_vbemin_q6 MIN mfq_vbe_q6 from=0.0 to=2e-08
meas tran mf_ss_vbemax_q6 MAX mfq_vbe_q6 from=2e-08 to=4e-08
meas tran mf_ss_vbemin_q6 MIN mfq_vbe_q6 from=2e-08 to=4e-08
let mfq_ic_q6 = i(vic_q6)
meas tran mf_su_icmax_q6 MAX mfq_ic_q6 from=0.0 to=2e-08
meas tran mf_su_icmin_q6 MIN mfq_ic_q6 from=0.0 to=2e-08
meas tran mf_ss_icmax_q6 MAX mfq_ic_q6 from=2e-08 to=4e-08
meas tran mf_ss_icmin_q6 MIN mfq_ic_q6 from=2e-08 to=4e-08
meas tran mf_su_sinkmin_tail MIN v(tail) from=0.0 to=2e-08
meas tran mf_ss_sinkmin_tail MIN v(tail) from=2e-08 to=4e-08
print mf_su_vcemax_q1
print mf_su_vcemin_q1
print mf_ss_vcemax_q1
print mf_ss_vcemin_q1
print mf_su_vbemax_q1
print mf_su_vbemin_q1
print mf_ss_vbemax_q1
print mf_ss_vbemin_q1
print mf_su_icmax_q1
print mf_su_icmin_q1
print mf_ss_icmax_q1
print mf_ss_icmin_q1
print mf_su_vcemax_q2
print mf_su_vcemin_q2
print mf_ss_vcemax_q2
print mf_ss_vcemin_q2
print mf_su_vbemax_q2
print mf_su_vbemin_q2
print mf_ss_vbemax_q2
print mf_ss_vbemin_q2
print mf_su_icmax_q2
print mf_su_icmin_q2
print mf_ss_icmax_q2
print mf_ss_icmin_q2
print mf_su_vcemax_q3
print mf_su_vcemin_q3
print mf_ss_vcemax_q3
print mf_ss_vcemin_q3
print mf_su_vbemax_q3
print mf_su_vbemin_q3
print mf_ss_vbemax_q3
print mf_ss_vbemin_q3
print mf_su_icmax_q3
print mf_su_icmin_q3
print mf_ss_icmax_q3
print mf_ss_icmin_q3
print mf_su_vcemax_q4
print mf_su_vcemin_q4
print mf_ss_vcemax_q4
print mf_ss_vcemin_q4
print mf_su_vbemax_q4
print mf_su_vbemin_q4
print mf_ss_vbemax_q4
print mf_ss_vbemin_q4
print mf_su_icmax_q4
print mf_su_icmin_q4
print mf_ss_icmax_q4
print mf_ss_icmin_q4
print mf_su_vcemax_q5
print mf_su_vcemin_q5
print mf_ss_vcemax_q5
print mf_ss_vcemin_q5
print mf_su_vbemax_q5
print mf_su_vbemin_q5
print mf_ss_vbemax_q5
print mf_ss_vbemin_q5
print mf_su_icmax_q5
print mf_su_icmin_q5
print mf_ss_icmax_q5
print mf_ss_icmin_q5
print mf_su_vcemax_q6
print mf_su_vcemin_q6
print mf_ss_vcemax_q6
print mf_ss_vcemin_q6
print mf_su_vbemax_q6
print mf_su_vbemin_q6
print mf_ss_vbemax_q6
print mf_ss_vbemin_q6
print mf_su_icmax_q6
print mf_su_icmin_q6
print mf_ss_icmax_q6
print mf_ss_icmin_q6
print mf_su_sinkmin_tail
print mf_ss_sinkmin_tail
linearize
let mf_l = length(time)
let mfw = (time ge 1.99995e-08) * (time lt 3.99995e-08)
let mf_n = mean(mfw) * mf_l
let mfs = mf_l / mf_n
let mf_prail = mean(v(vdd) * (0 - i(vdd)) * mfw) * mfs
let mfph = 2 * pi * 16700000000.0 * (time - 2e-08)
let mf_lodiff_re = 2 * mean((v(lo_p)-v(lo_n)) * mfw * cos(mfph)) * mfs
let mf_lodiff_im = 2 * mean((v(lo_p)-v(lo_n)) * mfw * sin(mfph)) * mfs
let mfph = 2 * pi * 1000000000.0 * (time - 2e-08)
let mf_if_re = 2 * mean((v(if_out)) * mfw * cos(mfph)) * mfs
let mf_if_im = 2 * mean((v(if_out)) * mfw * sin(mfph)) * mfs
let mfph = 2 * pi * 16700000000.0 * (time - 2e-08)
let mf_loif_re = 2 * mean((v(if_out)) * mfw * cos(mfph)) * mfs
let mf_loif_im = 2 * mean((v(if_out)) * mfw * sin(mfph)) * mfs
let mfph = 2 * pi * 16700000000.0 * (time - 2e-08)
let mf_lorf_re = 2 * mean((v(rf_port)) * mfw * cos(mfph)) * mfs
let mf_lorf_im = 2 * mean((v(rf_port)) * mfw * sin(mfph)) * mfs
let mfph = 2 * pi * 950000000.0 * (time - 2e-08)
let mf_flifa_re = 2 * mean((v(if_out)) * mfw * cos(mfph)) * mfs
let mf_flifa_im = 2 * mean((v(if_out)) * mfw * sin(mfph)) * mfs
let mfph = 2 * pi * 1050000000.0 * (time - 2e-08)
let mf_flifb_re = 2 * mean((v(if_out)) * mfw * cos(mfph)) * mfs
let mf_flifb_im = 2 * mean((v(if_out)) * mfw * sin(mfph)) * mfs
let mfph = 2 * pi * 16750000000.0 * (time - 2e-08)
let mf_fllorf_re = 2 * mean((v(rf_port)) * mfw * cos(mfph)) * mfs
let mf_fllorf_im = 2 * mean((v(rf_port)) * mfw * sin(mfph)) * mfs
let mfph = 2 * pi * 16750000000.0 * (time - 2e-08)
let mf_flloif_re = 2 * mean((v(if_out)) * mfw * cos(mfph)) * mfs
let mf_flloif_im = 2 * mean((v(if_out)) * mfw * sin(mfph)) * mfs
print mf_l
print mf_n
print mf_prail
print mf_lodiff_re
print mf_lodiff_im
print mf_if_re
print mf_if_im
print mf_loif_re
print mf_loif_im
print mf_lorf_re
print mf_lorf_im
print mf_flifa_re
print mf_flifa_im
print mf_flifb_re
print mf_flifb_im
print mf_fllorf_re
print mf_fllorf_im
print mf_flloif_re
print mf_flloif_im
destroy all
echo "MFEND ls_f17p70_m30_rf66"
echo "MFRUN ls_f17p70_m27_rf60"
alterparam f1 = 17700000000.0
alterparam f2 = 17700000000.0
alterparam flo = 16700000000.0
alterparam vrf1 = 0.0006324555320336759
alterparam vrf2 = 0.0
alterparam vlo = 0.039952595059333795
reset
op
let mf_dcirail = 0 - i(vdd)
let mf_dc_vce_q1 = v(c_q1)-v(e_q1)
let mf_dc_vbe_q1 = v(b_q1)-v(e_q1)
let mf_dc_ic_q1 = i(vic_q1)
let mf_dc_vce_q2 = v(c_q2)-v(e_q2)
let mf_dc_vbe_q2 = v(b_q2)-v(e_q2)
let mf_dc_ic_q2 = i(vic_q2)
let mf_dc_vce_q3 = v(c_q3)-v(x1)
let mf_dc_vbe_q3 = v(lo_p)-v(x1)
let mf_dc_ic_q3 = i(vic_q3)
let mf_dc_vce_q4 = v(c_q4)-v(x1)
let mf_dc_vbe_q4 = v(lo_n)-v(x1)
let mf_dc_ic_q4 = i(vic_q4)
let mf_dc_vce_q5 = v(c_q5)-v(x2)
let mf_dc_vbe_q5 = v(lo_p)-v(x2)
let mf_dc_ic_q5 = i(vic_q5)
let mf_dc_vce_q6 = v(c_q6)-v(x2)
let mf_dc_vbe_q6 = v(lo_n)-v(x2)
let mf_dc_ic_q6 = i(vic_q6)
let mf_dc_sink_tail = v(tail)
print mf_dcirail
print mf_dc_vce_q1
print mf_dc_vbe_q1
print mf_dc_ic_q1
print mf_dc_vce_q2
print mf_dc_vbe_q2
print mf_dc_ic_q2
print mf_dc_vce_q3
print mf_dc_vbe_q3
print mf_dc_ic_q3
print mf_dc_vce_q4
print mf_dc_vbe_q4
print mf_dc_ic_q4
print mf_dc_vce_q5
print mf_dc_vbe_q5
print mf_dc_ic_q5
print mf_dc_vce_q6
print mf_dc_vbe_q6
print mf_dc_ic_q6
print mf_dc_sink_tail
tran 1e-12 4e-08 0 1e-12
let mfq_vce_q1 = v(c_q1)-v(e_q1)
meas tran mf_su_vcemax_q1 MAX mfq_vce_q1 from=0.0 to=2e-08
meas tran mf_su_vcemin_q1 MIN mfq_vce_q1 from=0.0 to=2e-08
meas tran mf_ss_vcemax_q1 MAX mfq_vce_q1 from=2e-08 to=4e-08
meas tran mf_ss_vcemin_q1 MIN mfq_vce_q1 from=2e-08 to=4e-08
let mfq_vbe_q1 = v(b_q1)-v(e_q1)
meas tran mf_su_vbemax_q1 MAX mfq_vbe_q1 from=0.0 to=2e-08
meas tran mf_su_vbemin_q1 MIN mfq_vbe_q1 from=0.0 to=2e-08
meas tran mf_ss_vbemax_q1 MAX mfq_vbe_q1 from=2e-08 to=4e-08
meas tran mf_ss_vbemin_q1 MIN mfq_vbe_q1 from=2e-08 to=4e-08
let mfq_ic_q1 = i(vic_q1)
meas tran mf_su_icmax_q1 MAX mfq_ic_q1 from=0.0 to=2e-08
meas tran mf_su_icmin_q1 MIN mfq_ic_q1 from=0.0 to=2e-08
meas tran mf_ss_icmax_q1 MAX mfq_ic_q1 from=2e-08 to=4e-08
meas tran mf_ss_icmin_q1 MIN mfq_ic_q1 from=2e-08 to=4e-08
let mfq_vce_q2 = v(c_q2)-v(e_q2)
meas tran mf_su_vcemax_q2 MAX mfq_vce_q2 from=0.0 to=2e-08
meas tran mf_su_vcemin_q2 MIN mfq_vce_q2 from=0.0 to=2e-08
meas tran mf_ss_vcemax_q2 MAX mfq_vce_q2 from=2e-08 to=4e-08
meas tran mf_ss_vcemin_q2 MIN mfq_vce_q2 from=2e-08 to=4e-08
let mfq_vbe_q2 = v(b_q2)-v(e_q2)
meas tran mf_su_vbemax_q2 MAX mfq_vbe_q2 from=0.0 to=2e-08
meas tran mf_su_vbemin_q2 MIN mfq_vbe_q2 from=0.0 to=2e-08
meas tran mf_ss_vbemax_q2 MAX mfq_vbe_q2 from=2e-08 to=4e-08
meas tran mf_ss_vbemin_q2 MIN mfq_vbe_q2 from=2e-08 to=4e-08
let mfq_ic_q2 = i(vic_q2)
meas tran mf_su_icmax_q2 MAX mfq_ic_q2 from=0.0 to=2e-08
meas tran mf_su_icmin_q2 MIN mfq_ic_q2 from=0.0 to=2e-08
meas tran mf_ss_icmax_q2 MAX mfq_ic_q2 from=2e-08 to=4e-08
meas tran mf_ss_icmin_q2 MIN mfq_ic_q2 from=2e-08 to=4e-08
let mfq_vce_q3 = v(c_q3)-v(x1)
meas tran mf_su_vcemax_q3 MAX mfq_vce_q3 from=0.0 to=2e-08
meas tran mf_su_vcemin_q3 MIN mfq_vce_q3 from=0.0 to=2e-08
meas tran mf_ss_vcemax_q3 MAX mfq_vce_q3 from=2e-08 to=4e-08
meas tran mf_ss_vcemin_q3 MIN mfq_vce_q3 from=2e-08 to=4e-08
let mfq_vbe_q3 = v(lo_p)-v(x1)
meas tran mf_su_vbemax_q3 MAX mfq_vbe_q3 from=0.0 to=2e-08
meas tran mf_su_vbemin_q3 MIN mfq_vbe_q3 from=0.0 to=2e-08
meas tran mf_ss_vbemax_q3 MAX mfq_vbe_q3 from=2e-08 to=4e-08
meas tran mf_ss_vbemin_q3 MIN mfq_vbe_q3 from=2e-08 to=4e-08
let mfq_ic_q3 = i(vic_q3)
meas tran mf_su_icmax_q3 MAX mfq_ic_q3 from=0.0 to=2e-08
meas tran mf_su_icmin_q3 MIN mfq_ic_q3 from=0.0 to=2e-08
meas tran mf_ss_icmax_q3 MAX mfq_ic_q3 from=2e-08 to=4e-08
meas tran mf_ss_icmin_q3 MIN mfq_ic_q3 from=2e-08 to=4e-08
let mfq_vce_q4 = v(c_q4)-v(x1)
meas tran mf_su_vcemax_q4 MAX mfq_vce_q4 from=0.0 to=2e-08
meas tran mf_su_vcemin_q4 MIN mfq_vce_q4 from=0.0 to=2e-08
meas tran mf_ss_vcemax_q4 MAX mfq_vce_q4 from=2e-08 to=4e-08
meas tran mf_ss_vcemin_q4 MIN mfq_vce_q4 from=2e-08 to=4e-08
let mfq_vbe_q4 = v(lo_n)-v(x1)
meas tran mf_su_vbemax_q4 MAX mfq_vbe_q4 from=0.0 to=2e-08
meas tran mf_su_vbemin_q4 MIN mfq_vbe_q4 from=0.0 to=2e-08
meas tran mf_ss_vbemax_q4 MAX mfq_vbe_q4 from=2e-08 to=4e-08
meas tran mf_ss_vbemin_q4 MIN mfq_vbe_q4 from=2e-08 to=4e-08
let mfq_ic_q4 = i(vic_q4)
meas tran mf_su_icmax_q4 MAX mfq_ic_q4 from=0.0 to=2e-08
meas tran mf_su_icmin_q4 MIN mfq_ic_q4 from=0.0 to=2e-08
meas tran mf_ss_icmax_q4 MAX mfq_ic_q4 from=2e-08 to=4e-08
meas tran mf_ss_icmin_q4 MIN mfq_ic_q4 from=2e-08 to=4e-08
let mfq_vce_q5 = v(c_q5)-v(x2)
meas tran mf_su_vcemax_q5 MAX mfq_vce_q5 from=0.0 to=2e-08
meas tran mf_su_vcemin_q5 MIN mfq_vce_q5 from=0.0 to=2e-08
meas tran mf_ss_vcemax_q5 MAX mfq_vce_q5 from=2e-08 to=4e-08
meas tran mf_ss_vcemin_q5 MIN mfq_vce_q5 from=2e-08 to=4e-08
let mfq_vbe_q5 = v(lo_p)-v(x2)
meas tran mf_su_vbemax_q5 MAX mfq_vbe_q5 from=0.0 to=2e-08
meas tran mf_su_vbemin_q5 MIN mfq_vbe_q5 from=0.0 to=2e-08
meas tran mf_ss_vbemax_q5 MAX mfq_vbe_q5 from=2e-08 to=4e-08
meas tran mf_ss_vbemin_q5 MIN mfq_vbe_q5 from=2e-08 to=4e-08
let mfq_ic_q5 = i(vic_q5)
meas tran mf_su_icmax_q5 MAX mfq_ic_q5 from=0.0 to=2e-08
meas tran mf_su_icmin_q5 MIN mfq_ic_q5 from=0.0 to=2e-08
meas tran mf_ss_icmax_q5 MAX mfq_ic_q5 from=2e-08 to=4e-08
meas tran mf_ss_icmin_q5 MIN mfq_ic_q5 from=2e-08 to=4e-08
let mfq_vce_q6 = v(c_q6)-v(x2)
meas tran mf_su_vcemax_q6 MAX mfq_vce_q6 from=0.0 to=2e-08
meas tran mf_su_vcemin_q6 MIN mfq_vce_q6 from=0.0 to=2e-08
meas tran mf_ss_vcemax_q6 MAX mfq_vce_q6 from=2e-08 to=4e-08
meas tran mf_ss_vcemin_q6 MIN mfq_vce_q6 from=2e-08 to=4e-08
let mfq_vbe_q6 = v(lo_n)-v(x2)
meas tran mf_su_vbemax_q6 MAX mfq_vbe_q6 from=0.0 to=2e-08
meas tran mf_su_vbemin_q6 MIN mfq_vbe_q6 from=0.0 to=2e-08
meas tran mf_ss_vbemax_q6 MAX mfq_vbe_q6 from=2e-08 to=4e-08
meas tran mf_ss_vbemin_q6 MIN mfq_vbe_q6 from=2e-08 to=4e-08
let mfq_ic_q6 = i(vic_q6)
meas tran mf_su_icmax_q6 MAX mfq_ic_q6 from=0.0 to=2e-08
meas tran mf_su_icmin_q6 MIN mfq_ic_q6 from=0.0 to=2e-08
meas tran mf_ss_icmax_q6 MAX mfq_ic_q6 from=2e-08 to=4e-08
meas tran mf_ss_icmin_q6 MIN mfq_ic_q6 from=2e-08 to=4e-08
meas tran mf_su_sinkmin_tail MIN v(tail) from=0.0 to=2e-08
meas tran mf_ss_sinkmin_tail MIN v(tail) from=2e-08 to=4e-08
print mf_su_vcemax_q1
print mf_su_vcemin_q1
print mf_ss_vcemax_q1
print mf_ss_vcemin_q1
print mf_su_vbemax_q1
print mf_su_vbemin_q1
print mf_ss_vbemax_q1
print mf_ss_vbemin_q1
print mf_su_icmax_q1
print mf_su_icmin_q1
print mf_ss_icmax_q1
print mf_ss_icmin_q1
print mf_su_vcemax_q2
print mf_su_vcemin_q2
print mf_ss_vcemax_q2
print mf_ss_vcemin_q2
print mf_su_vbemax_q2
print mf_su_vbemin_q2
print mf_ss_vbemax_q2
print mf_ss_vbemin_q2
print mf_su_icmax_q2
print mf_su_icmin_q2
print mf_ss_icmax_q2
print mf_ss_icmin_q2
print mf_su_vcemax_q3
print mf_su_vcemin_q3
print mf_ss_vcemax_q3
print mf_ss_vcemin_q3
print mf_su_vbemax_q3
print mf_su_vbemin_q3
print mf_ss_vbemax_q3
print mf_ss_vbemin_q3
print mf_su_icmax_q3
print mf_su_icmin_q3
print mf_ss_icmax_q3
print mf_ss_icmin_q3
print mf_su_vcemax_q4
print mf_su_vcemin_q4
print mf_ss_vcemax_q4
print mf_ss_vcemin_q4
print mf_su_vbemax_q4
print mf_su_vbemin_q4
print mf_ss_vbemax_q4
print mf_ss_vbemin_q4
print mf_su_icmax_q4
print mf_su_icmin_q4
print mf_ss_icmax_q4
print mf_ss_icmin_q4
print mf_su_vcemax_q5
print mf_su_vcemin_q5
print mf_ss_vcemax_q5
print mf_ss_vcemin_q5
print mf_su_vbemax_q5
print mf_su_vbemin_q5
print mf_ss_vbemax_q5
print mf_ss_vbemin_q5
print mf_su_icmax_q5
print mf_su_icmin_q5
print mf_ss_icmax_q5
print mf_ss_icmin_q5
print mf_su_vcemax_q6
print mf_su_vcemin_q6
print mf_ss_vcemax_q6
print mf_ss_vcemin_q6
print mf_su_vbemax_q6
print mf_su_vbemin_q6
print mf_ss_vbemax_q6
print mf_ss_vbemin_q6
print mf_su_icmax_q6
print mf_su_icmin_q6
print mf_ss_icmax_q6
print mf_ss_icmin_q6
print mf_su_sinkmin_tail
print mf_ss_sinkmin_tail
linearize
let mf_l = length(time)
let mfw = (time ge 1.99995e-08) * (time lt 3.99995e-08)
let mf_n = mean(mfw) * mf_l
let mfs = mf_l / mf_n
let mf_prail = mean(v(vdd) * (0 - i(vdd)) * mfw) * mfs
let mfph = 2 * pi * 16700000000.0 * (time - 2e-08)
let mf_lodiff_re = 2 * mean((v(lo_p)-v(lo_n)) * mfw * cos(mfph)) * mfs
let mf_lodiff_im = 2 * mean((v(lo_p)-v(lo_n)) * mfw * sin(mfph)) * mfs
let mfph = 2 * pi * 1000000000.0 * (time - 2e-08)
let mf_if_re = 2 * mean((v(if_out)) * mfw * cos(mfph)) * mfs
let mf_if_im = 2 * mean((v(if_out)) * mfw * sin(mfph)) * mfs
let mfph = 2 * pi * 16700000000.0 * (time - 2e-08)
let mf_loif_re = 2 * mean((v(if_out)) * mfw * cos(mfph)) * mfs
let mf_loif_im = 2 * mean((v(if_out)) * mfw * sin(mfph)) * mfs
let mfph = 2 * pi * 16700000000.0 * (time - 2e-08)
let mf_lorf_re = 2 * mean((v(rf_port)) * mfw * cos(mfph)) * mfs
let mf_lorf_im = 2 * mean((v(rf_port)) * mfw * sin(mfph)) * mfs
let mfph = 2 * pi * 950000000.0 * (time - 2e-08)
let mf_flifa_re = 2 * mean((v(if_out)) * mfw * cos(mfph)) * mfs
let mf_flifa_im = 2 * mean((v(if_out)) * mfw * sin(mfph)) * mfs
let mfph = 2 * pi * 1050000000.0 * (time - 2e-08)
let mf_flifb_re = 2 * mean((v(if_out)) * mfw * cos(mfph)) * mfs
let mf_flifb_im = 2 * mean((v(if_out)) * mfw * sin(mfph)) * mfs
let mfph = 2 * pi * 16750000000.0 * (time - 2e-08)
let mf_fllorf_re = 2 * mean((v(rf_port)) * mfw * cos(mfph)) * mfs
let mf_fllorf_im = 2 * mean((v(rf_port)) * mfw * sin(mfph)) * mfs
let mfph = 2 * pi * 16750000000.0 * (time - 2e-08)
let mf_flloif_re = 2 * mean((v(if_out)) * mfw * cos(mfph)) * mfs
let mf_flloif_im = 2 * mean((v(if_out)) * mfw * sin(mfph)) * mfs
print mf_l
print mf_n
print mf_prail
print mf_lodiff_re
print mf_lodiff_im
print mf_if_re
print mf_if_im
print mf_loif_re
print mf_loif_im
print mf_lorf_re
print mf_lorf_im
print mf_flifa_re
print mf_flifa_im
print mf_flifb_re
print mf_flifb_im
print mf_fllorf_re
print mf_fllorf_im
print mf_flloif_re
print mf_flloif_im
destroy all
echo "MFEND ls_f17p70_m27_rf60"
echo "MFRUN ls_f17p70_m27_rf66"
alterparam f1 = 17700000000.0
alterparam f2 = 17700000000.0
alterparam flo = 16700000000.0
alterparam vrf1 = 0.00031697863849222284
alterparam vrf2 = 0.0
alterparam vlo = 0.039952595059333795
reset
op
let mf_dcirail = 0 - i(vdd)
let mf_dc_vce_q1 = v(c_q1)-v(e_q1)
let mf_dc_vbe_q1 = v(b_q1)-v(e_q1)
let mf_dc_ic_q1 = i(vic_q1)
let mf_dc_vce_q2 = v(c_q2)-v(e_q2)
let mf_dc_vbe_q2 = v(b_q2)-v(e_q2)
let mf_dc_ic_q2 = i(vic_q2)
let mf_dc_vce_q3 = v(c_q3)-v(x1)
let mf_dc_vbe_q3 = v(lo_p)-v(x1)
let mf_dc_ic_q3 = i(vic_q3)
let mf_dc_vce_q4 = v(c_q4)-v(x1)
let mf_dc_vbe_q4 = v(lo_n)-v(x1)
let mf_dc_ic_q4 = i(vic_q4)
let mf_dc_vce_q5 = v(c_q5)-v(x2)
let mf_dc_vbe_q5 = v(lo_p)-v(x2)
let mf_dc_ic_q5 = i(vic_q5)
let mf_dc_vce_q6 = v(c_q6)-v(x2)
let mf_dc_vbe_q6 = v(lo_n)-v(x2)
let mf_dc_ic_q6 = i(vic_q6)
let mf_dc_sink_tail = v(tail)
print mf_dcirail
print mf_dc_vce_q1
print mf_dc_vbe_q1
print mf_dc_ic_q1
print mf_dc_vce_q2
print mf_dc_vbe_q2
print mf_dc_ic_q2
print mf_dc_vce_q3
print mf_dc_vbe_q3
print mf_dc_ic_q3
print mf_dc_vce_q4
print mf_dc_vbe_q4
print mf_dc_ic_q4
print mf_dc_vce_q5
print mf_dc_vbe_q5
print mf_dc_ic_q5
print mf_dc_vce_q6
print mf_dc_vbe_q6
print mf_dc_ic_q6
print mf_dc_sink_tail
tran 1e-12 4e-08 0 1e-12
let mfq_vce_q1 = v(c_q1)-v(e_q1)
meas tran mf_su_vcemax_q1 MAX mfq_vce_q1 from=0.0 to=2e-08
meas tran mf_su_vcemin_q1 MIN mfq_vce_q1 from=0.0 to=2e-08
meas tran mf_ss_vcemax_q1 MAX mfq_vce_q1 from=2e-08 to=4e-08
meas tran mf_ss_vcemin_q1 MIN mfq_vce_q1 from=2e-08 to=4e-08
let mfq_vbe_q1 = v(b_q1)-v(e_q1)
meas tran mf_su_vbemax_q1 MAX mfq_vbe_q1 from=0.0 to=2e-08
meas tran mf_su_vbemin_q1 MIN mfq_vbe_q1 from=0.0 to=2e-08
meas tran mf_ss_vbemax_q1 MAX mfq_vbe_q1 from=2e-08 to=4e-08
meas tran mf_ss_vbemin_q1 MIN mfq_vbe_q1 from=2e-08 to=4e-08
let mfq_ic_q1 = i(vic_q1)
meas tran mf_su_icmax_q1 MAX mfq_ic_q1 from=0.0 to=2e-08
meas tran mf_su_icmin_q1 MIN mfq_ic_q1 from=0.0 to=2e-08
meas tran mf_ss_icmax_q1 MAX mfq_ic_q1 from=2e-08 to=4e-08
meas tran mf_ss_icmin_q1 MIN mfq_ic_q1 from=2e-08 to=4e-08
let mfq_vce_q2 = v(c_q2)-v(e_q2)
meas tran mf_su_vcemax_q2 MAX mfq_vce_q2 from=0.0 to=2e-08
meas tran mf_su_vcemin_q2 MIN mfq_vce_q2 from=0.0 to=2e-08
meas tran mf_ss_vcemax_q2 MAX mfq_vce_q2 from=2e-08 to=4e-08
meas tran mf_ss_vcemin_q2 MIN mfq_vce_q2 from=2e-08 to=4e-08
let mfq_vbe_q2 = v(b_q2)-v(e_q2)
meas tran mf_su_vbemax_q2 MAX mfq_vbe_q2 from=0.0 to=2e-08
meas tran mf_su_vbemin_q2 MIN mfq_vbe_q2 from=0.0 to=2e-08
meas tran mf_ss_vbemax_q2 MAX mfq_vbe_q2 from=2e-08 to=4e-08
meas tran mf_ss_vbemin_q2 MIN mfq_vbe_q2 from=2e-08 to=4e-08
let mfq_ic_q2 = i(vic_q2)
meas tran mf_su_icmax_q2 MAX mfq_ic_q2 from=0.0 to=2e-08
meas tran mf_su_icmin_q2 MIN mfq_ic_q2 from=0.0 to=2e-08
meas tran mf_ss_icmax_q2 MAX mfq_ic_q2 from=2e-08 to=4e-08
meas tran mf_ss_icmin_q2 MIN mfq_ic_q2 from=2e-08 to=4e-08
let mfq_vce_q3 = v(c_q3)-v(x1)
meas tran mf_su_vcemax_q3 MAX mfq_vce_q3 from=0.0 to=2e-08
meas tran mf_su_vcemin_q3 MIN mfq_vce_q3 from=0.0 to=2e-08
meas tran mf_ss_vcemax_q3 MAX mfq_vce_q3 from=2e-08 to=4e-08
meas tran mf_ss_vcemin_q3 MIN mfq_vce_q3 from=2e-08 to=4e-08
let mfq_vbe_q3 = v(lo_p)-v(x1)
meas tran mf_su_vbemax_q3 MAX mfq_vbe_q3 from=0.0 to=2e-08
meas tran mf_su_vbemin_q3 MIN mfq_vbe_q3 from=0.0 to=2e-08
meas tran mf_ss_vbemax_q3 MAX mfq_vbe_q3 from=2e-08 to=4e-08
meas tran mf_ss_vbemin_q3 MIN mfq_vbe_q3 from=2e-08 to=4e-08
let mfq_ic_q3 = i(vic_q3)
meas tran mf_su_icmax_q3 MAX mfq_ic_q3 from=0.0 to=2e-08
meas tran mf_su_icmin_q3 MIN mfq_ic_q3 from=0.0 to=2e-08
meas tran mf_ss_icmax_q3 MAX mfq_ic_q3 from=2e-08 to=4e-08
meas tran mf_ss_icmin_q3 MIN mfq_ic_q3 from=2e-08 to=4e-08
let mfq_vce_q4 = v(c_q4)-v(x1)
meas tran mf_su_vcemax_q4 MAX mfq_vce_q4 from=0.0 to=2e-08
meas tran mf_su_vcemin_q4 MIN mfq_vce_q4 from=0.0 to=2e-08
meas tran mf_ss_vcemax_q4 MAX mfq_vce_q4 from=2e-08 to=4e-08
meas tran mf_ss_vcemin_q4 MIN mfq_vce_q4 from=2e-08 to=4e-08
let mfq_vbe_q4 = v(lo_n)-v(x1)
meas tran mf_su_vbemax_q4 MAX mfq_vbe_q4 from=0.0 to=2e-08
meas tran mf_su_vbemin_q4 MIN mfq_vbe_q4 from=0.0 to=2e-08
meas tran mf_ss_vbemax_q4 MAX mfq_vbe_q4 from=2e-08 to=4e-08
meas tran mf_ss_vbemin_q4 MIN mfq_vbe_q4 from=2e-08 to=4e-08
let mfq_ic_q4 = i(vic_q4)
meas tran mf_su_icmax_q4 MAX mfq_ic_q4 from=0.0 to=2e-08
meas tran mf_su_icmin_q4 MIN mfq_ic_q4 from=0.0 to=2e-08
meas tran mf_ss_icmax_q4 MAX mfq_ic_q4 from=2e-08 to=4e-08
meas tran mf_ss_icmin_q4 MIN mfq_ic_q4 from=2e-08 to=4e-08
let mfq_vce_q5 = v(c_q5)-v(x2)
meas tran mf_su_vcemax_q5 MAX mfq_vce_q5 from=0.0 to=2e-08
meas tran mf_su_vcemin_q5 MIN mfq_vce_q5 from=0.0 to=2e-08
meas tran mf_ss_vcemax_q5 MAX mfq_vce_q5 from=2e-08 to=4e-08
meas tran mf_ss_vcemin_q5 MIN mfq_vce_q5 from=2e-08 to=4e-08
let mfq_vbe_q5 = v(lo_p)-v(x2)
meas tran mf_su_vbemax_q5 MAX mfq_vbe_q5 from=0.0 to=2e-08
meas tran mf_su_vbemin_q5 MIN mfq_vbe_q5 from=0.0 to=2e-08
meas tran mf_ss_vbemax_q5 MAX mfq_vbe_q5 from=2e-08 to=4e-08
meas tran mf_ss_vbemin_q5 MIN mfq_vbe_q5 from=2e-08 to=4e-08
let mfq_ic_q5 = i(vic_q5)
meas tran mf_su_icmax_q5 MAX mfq_ic_q5 from=0.0 to=2e-08
meas tran mf_su_icmin_q5 MIN mfq_ic_q5 from=0.0 to=2e-08
meas tran mf_ss_icmax_q5 MAX mfq_ic_q5 from=2e-08 to=4e-08
meas tran mf_ss_icmin_q5 MIN mfq_ic_q5 from=2e-08 to=4e-08
let mfq_vce_q6 = v(c_q6)-v(x2)
meas tran mf_su_vcemax_q6 MAX mfq_vce_q6 from=0.0 to=2e-08
meas tran mf_su_vcemin_q6 MIN mfq_vce_q6 from=0.0 to=2e-08
meas tran mf_ss_vcemax_q6 MAX mfq_vce_q6 from=2e-08 to=4e-08
meas tran mf_ss_vcemin_q6 MIN mfq_vce_q6 from=2e-08 to=4e-08
let mfq_vbe_q6 = v(lo_n)-v(x2)
meas tran mf_su_vbemax_q6 MAX mfq_vbe_q6 from=0.0 to=2e-08
meas tran mf_su_vbemin_q6 MIN mfq_vbe_q6 from=0.0 to=2e-08
meas tran mf_ss_vbemax_q6 MAX mfq_vbe_q6 from=2e-08 to=4e-08
meas tran mf_ss_vbemin_q6 MIN mfq_vbe_q6 from=2e-08 to=4e-08
let mfq_ic_q6 = i(vic_q6)
meas tran mf_su_icmax_q6 MAX mfq_ic_q6 from=0.0 to=2e-08
meas tran mf_su_icmin_q6 MIN mfq_ic_q6 from=0.0 to=2e-08
meas tran mf_ss_icmax_q6 MAX mfq_ic_q6 from=2e-08 to=4e-08
meas tran mf_ss_icmin_q6 MIN mfq_ic_q6 from=2e-08 to=4e-08
meas tran mf_su_sinkmin_tail MIN v(tail) from=0.0 to=2e-08
meas tran mf_ss_sinkmin_tail MIN v(tail) from=2e-08 to=4e-08
print mf_su_vcemax_q1
print mf_su_vcemin_q1
print mf_ss_vcemax_q1
print mf_ss_vcemin_q1
print mf_su_vbemax_q1
print mf_su_vbemin_q1
print mf_ss_vbemax_q1
print mf_ss_vbemin_q1
print mf_su_icmax_q1
print mf_su_icmin_q1
print mf_ss_icmax_q1
print mf_ss_icmin_q1
print mf_su_vcemax_q2
print mf_su_vcemin_q2
print mf_ss_vcemax_q2
print mf_ss_vcemin_q2
print mf_su_vbemax_q2
print mf_su_vbemin_q2
print mf_ss_vbemax_q2
print mf_ss_vbemin_q2
print mf_su_icmax_q2
print mf_su_icmin_q2
print mf_ss_icmax_q2
print mf_ss_icmin_q2
print mf_su_vcemax_q3
print mf_su_vcemin_q3
print mf_ss_vcemax_q3
print mf_ss_vcemin_q3
print mf_su_vbemax_q3
print mf_su_vbemin_q3
print mf_ss_vbemax_q3
print mf_ss_vbemin_q3
print mf_su_icmax_q3
print mf_su_icmin_q3
print mf_ss_icmax_q3
print mf_ss_icmin_q3
print mf_su_vcemax_q4
print mf_su_vcemin_q4
print mf_ss_vcemax_q4
print mf_ss_vcemin_q4
print mf_su_vbemax_q4
print mf_su_vbemin_q4
print mf_ss_vbemax_q4
print mf_ss_vbemin_q4
print mf_su_icmax_q4
print mf_su_icmin_q4
print mf_ss_icmax_q4
print mf_ss_icmin_q4
print mf_su_vcemax_q5
print mf_su_vcemin_q5
print mf_ss_vcemax_q5
print mf_ss_vcemin_q5
print mf_su_vbemax_q5
print mf_su_vbemin_q5
print mf_ss_vbemax_q5
print mf_ss_vbemin_q5
print mf_su_icmax_q5
print mf_su_icmin_q5
print mf_ss_icmax_q5
print mf_ss_icmin_q5
print mf_su_vcemax_q6
print mf_su_vcemin_q6
print mf_ss_vcemax_q6
print mf_ss_vcemin_q6
print mf_su_vbemax_q6
print mf_su_vbemin_q6
print mf_ss_vbemax_q6
print mf_ss_vbemin_q6
print mf_su_icmax_q6
print mf_su_icmin_q6
print mf_ss_icmax_q6
print mf_ss_icmin_q6
print mf_su_sinkmin_tail
print mf_ss_sinkmin_tail
linearize
let mf_l = length(time)
let mfw = (time ge 1.99995e-08) * (time lt 3.99995e-08)
let mf_n = mean(mfw) * mf_l
let mfs = mf_l / mf_n
let mf_prail = mean(v(vdd) * (0 - i(vdd)) * mfw) * mfs
let mfph = 2 * pi * 16700000000.0 * (time - 2e-08)
let mf_lodiff_re = 2 * mean((v(lo_p)-v(lo_n)) * mfw * cos(mfph)) * mfs
let mf_lodiff_im = 2 * mean((v(lo_p)-v(lo_n)) * mfw * sin(mfph)) * mfs
let mfph = 2 * pi * 1000000000.0 * (time - 2e-08)
let mf_if_re = 2 * mean((v(if_out)) * mfw * cos(mfph)) * mfs
let mf_if_im = 2 * mean((v(if_out)) * mfw * sin(mfph)) * mfs
let mfph = 2 * pi * 16700000000.0 * (time - 2e-08)
let mf_loif_re = 2 * mean((v(if_out)) * mfw * cos(mfph)) * mfs
let mf_loif_im = 2 * mean((v(if_out)) * mfw * sin(mfph)) * mfs
let mfph = 2 * pi * 16700000000.0 * (time - 2e-08)
let mf_lorf_re = 2 * mean((v(rf_port)) * mfw * cos(mfph)) * mfs
let mf_lorf_im = 2 * mean((v(rf_port)) * mfw * sin(mfph)) * mfs
let mfph = 2 * pi * 950000000.0 * (time - 2e-08)
let mf_flifa_re = 2 * mean((v(if_out)) * mfw * cos(mfph)) * mfs
let mf_flifa_im = 2 * mean((v(if_out)) * mfw * sin(mfph)) * mfs
let mfph = 2 * pi * 1050000000.0 * (time - 2e-08)
let mf_flifb_re = 2 * mean((v(if_out)) * mfw * cos(mfph)) * mfs
let mf_flifb_im = 2 * mean((v(if_out)) * mfw * sin(mfph)) * mfs
let mfph = 2 * pi * 16750000000.0 * (time - 2e-08)
let mf_fllorf_re = 2 * mean((v(rf_port)) * mfw * cos(mfph)) * mfs
let mf_fllorf_im = 2 * mean((v(rf_port)) * mfw * sin(mfph)) * mfs
let mfph = 2 * pi * 16750000000.0 * (time - 2e-08)
let mf_flloif_re = 2 * mean((v(if_out)) * mfw * cos(mfph)) * mfs
let mf_flloif_im = 2 * mean((v(if_out)) * mfw * sin(mfph)) * mfs
print mf_l
print mf_n
print mf_prail
print mf_lodiff_re
print mf_lodiff_im
print mf_if_re
print mf_if_im
print mf_loif_re
print mf_loif_im
print mf_lorf_re
print mf_lorf_im
print mf_flifa_re
print mf_flifa_im
print mf_flifb_re
print mf_flifb_im
print mf_fllorf_re
print mf_fllorf_im
print mf_flloif_re
print mf_flloif_im
destroy all
echo "MFEND ls_f17p70_m27_rf66"
echo "MFRUN ls_f17p70_m24_rf60"
alterparam f1 = 17700000000.0
alterparam f2 = 17700000000.0
alterparam flo = 16700000000.0
alterparam vrf1 = 0.0006324555320336759
alterparam vrf2 = 0.0
alterparam vlo = 0.05643454052641856
reset
op
let mf_dcirail = 0 - i(vdd)
let mf_dc_vce_q1 = v(c_q1)-v(e_q1)
let mf_dc_vbe_q1 = v(b_q1)-v(e_q1)
let mf_dc_ic_q1 = i(vic_q1)
let mf_dc_vce_q2 = v(c_q2)-v(e_q2)
let mf_dc_vbe_q2 = v(b_q2)-v(e_q2)
let mf_dc_ic_q2 = i(vic_q2)
let mf_dc_vce_q3 = v(c_q3)-v(x1)
let mf_dc_vbe_q3 = v(lo_p)-v(x1)
let mf_dc_ic_q3 = i(vic_q3)
let mf_dc_vce_q4 = v(c_q4)-v(x1)
let mf_dc_vbe_q4 = v(lo_n)-v(x1)
let mf_dc_ic_q4 = i(vic_q4)
let mf_dc_vce_q5 = v(c_q5)-v(x2)
let mf_dc_vbe_q5 = v(lo_p)-v(x2)
let mf_dc_ic_q5 = i(vic_q5)
let mf_dc_vce_q6 = v(c_q6)-v(x2)
let mf_dc_vbe_q6 = v(lo_n)-v(x2)
let mf_dc_ic_q6 = i(vic_q6)
let mf_dc_sink_tail = v(tail)
print mf_dcirail
print mf_dc_vce_q1
print mf_dc_vbe_q1
print mf_dc_ic_q1
print mf_dc_vce_q2
print mf_dc_vbe_q2
print mf_dc_ic_q2
print mf_dc_vce_q3
print mf_dc_vbe_q3
print mf_dc_ic_q3
print mf_dc_vce_q4
print mf_dc_vbe_q4
print mf_dc_ic_q4
print mf_dc_vce_q5
print mf_dc_vbe_q5
print mf_dc_ic_q5
print mf_dc_vce_q6
print mf_dc_vbe_q6
print mf_dc_ic_q6
print mf_dc_sink_tail
tran 1e-12 4e-08 0 1e-12
let mfq_vce_q1 = v(c_q1)-v(e_q1)
meas tran mf_su_vcemax_q1 MAX mfq_vce_q1 from=0.0 to=2e-08
meas tran mf_su_vcemin_q1 MIN mfq_vce_q1 from=0.0 to=2e-08
meas tran mf_ss_vcemax_q1 MAX mfq_vce_q1 from=2e-08 to=4e-08
meas tran mf_ss_vcemin_q1 MIN mfq_vce_q1 from=2e-08 to=4e-08
let mfq_vbe_q1 = v(b_q1)-v(e_q1)
meas tran mf_su_vbemax_q1 MAX mfq_vbe_q1 from=0.0 to=2e-08
meas tran mf_su_vbemin_q1 MIN mfq_vbe_q1 from=0.0 to=2e-08
meas tran mf_ss_vbemax_q1 MAX mfq_vbe_q1 from=2e-08 to=4e-08
meas tran mf_ss_vbemin_q1 MIN mfq_vbe_q1 from=2e-08 to=4e-08
let mfq_ic_q1 = i(vic_q1)
meas tran mf_su_icmax_q1 MAX mfq_ic_q1 from=0.0 to=2e-08
meas tran mf_su_icmin_q1 MIN mfq_ic_q1 from=0.0 to=2e-08
meas tran mf_ss_icmax_q1 MAX mfq_ic_q1 from=2e-08 to=4e-08
meas tran mf_ss_icmin_q1 MIN mfq_ic_q1 from=2e-08 to=4e-08
let mfq_vce_q2 = v(c_q2)-v(e_q2)
meas tran mf_su_vcemax_q2 MAX mfq_vce_q2 from=0.0 to=2e-08
meas tran mf_su_vcemin_q2 MIN mfq_vce_q2 from=0.0 to=2e-08
meas tran mf_ss_vcemax_q2 MAX mfq_vce_q2 from=2e-08 to=4e-08
meas tran mf_ss_vcemin_q2 MIN mfq_vce_q2 from=2e-08 to=4e-08
let mfq_vbe_q2 = v(b_q2)-v(e_q2)
meas tran mf_su_vbemax_q2 MAX mfq_vbe_q2 from=0.0 to=2e-08
meas tran mf_su_vbemin_q2 MIN mfq_vbe_q2 from=0.0 to=2e-08
meas tran mf_ss_vbemax_q2 MAX mfq_vbe_q2 from=2e-08 to=4e-08
meas tran mf_ss_vbemin_q2 MIN mfq_vbe_q2 from=2e-08 to=4e-08
let mfq_ic_q2 = i(vic_q2)
meas tran mf_su_icmax_q2 MAX mfq_ic_q2 from=0.0 to=2e-08
meas tran mf_su_icmin_q2 MIN mfq_ic_q2 from=0.0 to=2e-08
meas tran mf_ss_icmax_q2 MAX mfq_ic_q2 from=2e-08 to=4e-08
meas tran mf_ss_icmin_q2 MIN mfq_ic_q2 from=2e-08 to=4e-08
let mfq_vce_q3 = v(c_q3)-v(x1)
meas tran mf_su_vcemax_q3 MAX mfq_vce_q3 from=0.0 to=2e-08
meas tran mf_su_vcemin_q3 MIN mfq_vce_q3 from=0.0 to=2e-08
meas tran mf_ss_vcemax_q3 MAX mfq_vce_q3 from=2e-08 to=4e-08
meas tran mf_ss_vcemin_q3 MIN mfq_vce_q3 from=2e-08 to=4e-08
let mfq_vbe_q3 = v(lo_p)-v(x1)
meas tran mf_su_vbemax_q3 MAX mfq_vbe_q3 from=0.0 to=2e-08
meas tran mf_su_vbemin_q3 MIN mfq_vbe_q3 from=0.0 to=2e-08
meas tran mf_ss_vbemax_q3 MAX mfq_vbe_q3 from=2e-08 to=4e-08
meas tran mf_ss_vbemin_q3 MIN mfq_vbe_q3 from=2e-08 to=4e-08
let mfq_ic_q3 = i(vic_q3)
meas tran mf_su_icmax_q3 MAX mfq_ic_q3 from=0.0 to=2e-08
meas tran mf_su_icmin_q3 MIN mfq_ic_q3 from=0.0 to=2e-08
meas tran mf_ss_icmax_q3 MAX mfq_ic_q3 from=2e-08 to=4e-08
meas tran mf_ss_icmin_q3 MIN mfq_ic_q3 from=2e-08 to=4e-08
let mfq_vce_q4 = v(c_q4)-v(x1)
meas tran mf_su_vcemax_q4 MAX mfq_vce_q4 from=0.0 to=2e-08
meas tran mf_su_vcemin_q4 MIN mfq_vce_q4 from=0.0 to=2e-08
meas tran mf_ss_vcemax_q4 MAX mfq_vce_q4 from=2e-08 to=4e-08
meas tran mf_ss_vcemin_q4 MIN mfq_vce_q4 from=2e-08 to=4e-08
let mfq_vbe_q4 = v(lo_n)-v(x1)
meas tran mf_su_vbemax_q4 MAX mfq_vbe_q4 from=0.0 to=2e-08
meas tran mf_su_vbemin_q4 MIN mfq_vbe_q4 from=0.0 to=2e-08
meas tran mf_ss_vbemax_q4 MAX mfq_vbe_q4 from=2e-08 to=4e-08
meas tran mf_ss_vbemin_q4 MIN mfq_vbe_q4 from=2e-08 to=4e-08
let mfq_ic_q4 = i(vic_q4)
meas tran mf_su_icmax_q4 MAX mfq_ic_q4 from=0.0 to=2e-08
meas tran mf_su_icmin_q4 MIN mfq_ic_q4 from=0.0 to=2e-08
meas tran mf_ss_icmax_q4 MAX mfq_ic_q4 from=2e-08 to=4e-08
meas tran mf_ss_icmin_q4 MIN mfq_ic_q4 from=2e-08 to=4e-08
let mfq_vce_q5 = v(c_q5)-v(x2)
meas tran mf_su_vcemax_q5 MAX mfq_vce_q5 from=0.0 to=2e-08
meas tran mf_su_vcemin_q5 MIN mfq_vce_q5 from=0.0 to=2e-08
meas tran mf_ss_vcemax_q5 MAX mfq_vce_q5 from=2e-08 to=4e-08
meas tran mf_ss_vcemin_q5 MIN mfq_vce_q5 from=2e-08 to=4e-08
let mfq_vbe_q5 = v(lo_p)-v(x2)
meas tran mf_su_vbemax_q5 MAX mfq_vbe_q5 from=0.0 to=2e-08
meas tran mf_su_vbemin_q5 MIN mfq_vbe_q5 from=0.0 to=2e-08
meas tran mf_ss_vbemax_q5 MAX mfq_vbe_q5 from=2e-08 to=4e-08
meas tran mf_ss_vbemin_q5 MIN mfq_vbe_q5 from=2e-08 to=4e-08
let mfq_ic_q5 = i(vic_q5)
meas tran mf_su_icmax_q5 MAX mfq_ic_q5 from=0.0 to=2e-08
meas tran mf_su_icmin_q5 MIN mfq_ic_q5 from=0.0 to=2e-08
meas tran mf_ss_icmax_q5 MAX mfq_ic_q5 from=2e-08 to=4e-08
meas tran mf_ss_icmin_q5 MIN mfq_ic_q5 from=2e-08 to=4e-08
let mfq_vce_q6 = v(c_q6)-v(x2)
meas tran mf_su_vcemax_q6 MAX mfq_vce_q6 from=0.0 to=2e-08
meas tran mf_su_vcemin_q6 MIN mfq_vce_q6 from=0.0 to=2e-08
meas tran mf_ss_vcemax_q6 MAX mfq_vce_q6 from=2e-08 to=4e-08
meas tran mf_ss_vcemin_q6 MIN mfq_vce_q6 from=2e-08 to=4e-08
let mfq_vbe_q6 = v(lo_n)-v(x2)
meas tran mf_su_vbemax_q6 MAX mfq_vbe_q6 from=0.0 to=2e-08
meas tran mf_su_vbemin_q6 MIN mfq_vbe_q6 from=0.0 to=2e-08
meas tran mf_ss_vbemax_q6 MAX mfq_vbe_q6 from=2e-08 to=4e-08
meas tran mf_ss_vbemin_q6 MIN mfq_vbe_q6 from=2e-08 to=4e-08
let mfq_ic_q6 = i(vic_q6)
meas tran mf_su_icmax_q6 MAX mfq_ic_q6 from=0.0 to=2e-08
meas tran mf_su_icmin_q6 MIN mfq_ic_q6 from=0.0 to=2e-08
meas tran mf_ss_icmax_q6 MAX mfq_ic_q6 from=2e-08 to=4e-08
meas tran mf_ss_icmin_q6 MIN mfq_ic_q6 from=2e-08 to=4e-08
meas tran mf_su_sinkmin_tail MIN v(tail) from=0.0 to=2e-08
meas tran mf_ss_sinkmin_tail MIN v(tail) from=2e-08 to=4e-08
print mf_su_vcemax_q1
print mf_su_vcemin_q1
print mf_ss_vcemax_q1
print mf_ss_vcemin_q1
print mf_su_vbemax_q1
print mf_su_vbemin_q1
print mf_ss_vbemax_q1
print mf_ss_vbemin_q1
print mf_su_icmax_q1
print mf_su_icmin_q1
print mf_ss_icmax_q1
print mf_ss_icmin_q1
print mf_su_vcemax_q2
print mf_su_vcemin_q2
print mf_ss_vcemax_q2
print mf_ss_vcemin_q2
print mf_su_vbemax_q2
print mf_su_vbemin_q2
print mf_ss_vbemax_q2
print mf_ss_vbemin_q2
print mf_su_icmax_q2
print mf_su_icmin_q2
print mf_ss_icmax_q2
print mf_ss_icmin_q2
print mf_su_vcemax_q3
print mf_su_vcemin_q3
print mf_ss_vcemax_q3
print mf_ss_vcemin_q3
print mf_su_vbemax_q3
print mf_su_vbemin_q3
print mf_ss_vbemax_q3
print mf_ss_vbemin_q3
print mf_su_icmax_q3
print mf_su_icmin_q3
print mf_ss_icmax_q3
print mf_ss_icmin_q3
print mf_su_vcemax_q4
print mf_su_vcemin_q4
print mf_ss_vcemax_q4
print mf_ss_vcemin_q4
print mf_su_vbemax_q4
print mf_su_vbemin_q4
print mf_ss_vbemax_q4
print mf_ss_vbemin_q4
print mf_su_icmax_q4
print mf_su_icmin_q4
print mf_ss_icmax_q4
print mf_ss_icmin_q4
print mf_su_vcemax_q5
print mf_su_vcemin_q5
print mf_ss_vcemax_q5
print mf_ss_vcemin_q5
print mf_su_vbemax_q5
print mf_su_vbemin_q5
print mf_ss_vbemax_q5
print mf_ss_vbemin_q5
print mf_su_icmax_q5
print mf_su_icmin_q5
print mf_ss_icmax_q5
print mf_ss_icmin_q5
print mf_su_vcemax_q6
print mf_su_vcemin_q6
print mf_ss_vcemax_q6
print mf_ss_vcemin_q6
print mf_su_vbemax_q6
print mf_su_vbemin_q6
print mf_ss_vbemax_q6
print mf_ss_vbemin_q6
print mf_su_icmax_q6
print mf_su_icmin_q6
print mf_ss_icmax_q6
print mf_ss_icmin_q6
print mf_su_sinkmin_tail
print mf_ss_sinkmin_tail
linearize
let mf_l = length(time)
let mfw = (time ge 1.99995e-08) * (time lt 3.99995e-08)
let mf_n = mean(mfw) * mf_l
let mfs = mf_l / mf_n
let mf_prail = mean(v(vdd) * (0 - i(vdd)) * mfw) * mfs
let mfph = 2 * pi * 16700000000.0 * (time - 2e-08)
let mf_lodiff_re = 2 * mean((v(lo_p)-v(lo_n)) * mfw * cos(mfph)) * mfs
let mf_lodiff_im = 2 * mean((v(lo_p)-v(lo_n)) * mfw * sin(mfph)) * mfs
let mfph = 2 * pi * 1000000000.0 * (time - 2e-08)
let mf_if_re = 2 * mean((v(if_out)) * mfw * cos(mfph)) * mfs
let mf_if_im = 2 * mean((v(if_out)) * mfw * sin(mfph)) * mfs
let mfph = 2 * pi * 16700000000.0 * (time - 2e-08)
let mf_loif_re = 2 * mean((v(if_out)) * mfw * cos(mfph)) * mfs
let mf_loif_im = 2 * mean((v(if_out)) * mfw * sin(mfph)) * mfs
let mfph = 2 * pi * 16700000000.0 * (time - 2e-08)
let mf_lorf_re = 2 * mean((v(rf_port)) * mfw * cos(mfph)) * mfs
let mf_lorf_im = 2 * mean((v(rf_port)) * mfw * sin(mfph)) * mfs
let mfph = 2 * pi * 950000000.0 * (time - 2e-08)
let mf_flifa_re = 2 * mean((v(if_out)) * mfw * cos(mfph)) * mfs
let mf_flifa_im = 2 * mean((v(if_out)) * mfw * sin(mfph)) * mfs
let mfph = 2 * pi * 1050000000.0 * (time - 2e-08)
let mf_flifb_re = 2 * mean((v(if_out)) * mfw * cos(mfph)) * mfs
let mf_flifb_im = 2 * mean((v(if_out)) * mfw * sin(mfph)) * mfs
let mfph = 2 * pi * 16750000000.0 * (time - 2e-08)
let mf_fllorf_re = 2 * mean((v(rf_port)) * mfw * cos(mfph)) * mfs
let mf_fllorf_im = 2 * mean((v(rf_port)) * mfw * sin(mfph)) * mfs
let mfph = 2 * pi * 16750000000.0 * (time - 2e-08)
let mf_flloif_re = 2 * mean((v(if_out)) * mfw * cos(mfph)) * mfs
let mf_flloif_im = 2 * mean((v(if_out)) * mfw * sin(mfph)) * mfs
print mf_l
print mf_n
print mf_prail
print mf_lodiff_re
print mf_lodiff_im
print mf_if_re
print mf_if_im
print mf_loif_re
print mf_loif_im
print mf_lorf_re
print mf_lorf_im
print mf_flifa_re
print mf_flifa_im
print mf_flifb_re
print mf_flifb_im
print mf_fllorf_re
print mf_fllorf_im
print mf_flloif_re
print mf_flloif_im
destroy all
echo "MFEND ls_f17p70_m24_rf60"
echo "MFRUN ls_f17p70_m24_rf66"
alterparam f1 = 17700000000.0
alterparam f2 = 17700000000.0
alterparam flo = 16700000000.0
alterparam vrf1 = 0.00031697863849222284
alterparam vrf2 = 0.0
alterparam vlo = 0.05643454052641856
reset
op
let mf_dcirail = 0 - i(vdd)
let mf_dc_vce_q1 = v(c_q1)-v(e_q1)
let mf_dc_vbe_q1 = v(b_q1)-v(e_q1)
let mf_dc_ic_q1 = i(vic_q1)
let mf_dc_vce_q2 = v(c_q2)-v(e_q2)
let mf_dc_vbe_q2 = v(b_q2)-v(e_q2)
let mf_dc_ic_q2 = i(vic_q2)
let mf_dc_vce_q3 = v(c_q3)-v(x1)
let mf_dc_vbe_q3 = v(lo_p)-v(x1)
let mf_dc_ic_q3 = i(vic_q3)
let mf_dc_vce_q4 = v(c_q4)-v(x1)
let mf_dc_vbe_q4 = v(lo_n)-v(x1)
let mf_dc_ic_q4 = i(vic_q4)
let mf_dc_vce_q5 = v(c_q5)-v(x2)
let mf_dc_vbe_q5 = v(lo_p)-v(x2)
let mf_dc_ic_q5 = i(vic_q5)
let mf_dc_vce_q6 = v(c_q6)-v(x2)
let mf_dc_vbe_q6 = v(lo_n)-v(x2)
let mf_dc_ic_q6 = i(vic_q6)
let mf_dc_sink_tail = v(tail)
print mf_dcirail
print mf_dc_vce_q1
print mf_dc_vbe_q1
print mf_dc_ic_q1
print mf_dc_vce_q2
print mf_dc_vbe_q2
print mf_dc_ic_q2
print mf_dc_vce_q3
print mf_dc_vbe_q3
print mf_dc_ic_q3
print mf_dc_vce_q4
print mf_dc_vbe_q4
print mf_dc_ic_q4
print mf_dc_vce_q5
print mf_dc_vbe_q5
print mf_dc_ic_q5
print mf_dc_vce_q6
print mf_dc_vbe_q6
print mf_dc_ic_q6
print mf_dc_sink_tail
tran 1e-12 4e-08 0 1e-12
let mfq_vce_q1 = v(c_q1)-v(e_q1)
meas tran mf_su_vcemax_q1 MAX mfq_vce_q1 from=0.0 to=2e-08
meas tran mf_su_vcemin_q1 MIN mfq_vce_q1 from=0.0 to=2e-08
meas tran mf_ss_vcemax_q1 MAX mfq_vce_q1 from=2e-08 to=4e-08
meas tran mf_ss_vcemin_q1 MIN mfq_vce_q1 from=2e-08 to=4e-08
let mfq_vbe_q1 = v(b_q1)-v(e_q1)
meas tran mf_su_vbemax_q1 MAX mfq_vbe_q1 from=0.0 to=2e-08
meas tran mf_su_vbemin_q1 MIN mfq_vbe_q1 from=0.0 to=2e-08
meas tran mf_ss_vbemax_q1 MAX mfq_vbe_q1 from=2e-08 to=4e-08
meas tran mf_ss_vbemin_q1 MIN mfq_vbe_q1 from=2e-08 to=4e-08
let mfq_ic_q1 = i(vic_q1)
meas tran mf_su_icmax_q1 MAX mfq_ic_q1 from=0.0 to=2e-08
meas tran mf_su_icmin_q1 MIN mfq_ic_q1 from=0.0 to=2e-08
meas tran mf_ss_icmax_q1 MAX mfq_ic_q1 from=2e-08 to=4e-08
meas tran mf_ss_icmin_q1 MIN mfq_ic_q1 from=2e-08 to=4e-08
let mfq_vce_q2 = v(c_q2)-v(e_q2)
meas tran mf_su_vcemax_q2 MAX mfq_vce_q2 from=0.0 to=2e-08
meas tran mf_su_vcemin_q2 MIN mfq_vce_q2 from=0.0 to=2e-08
meas tran mf_ss_vcemax_q2 MAX mfq_vce_q2 from=2e-08 to=4e-08
meas tran mf_ss_vcemin_q2 MIN mfq_vce_q2 from=2e-08 to=4e-08
let mfq_vbe_q2 = v(b_q2)-v(e_q2)
meas tran mf_su_vbemax_q2 MAX mfq_vbe_q2 from=0.0 to=2e-08
meas tran mf_su_vbemin_q2 MIN mfq_vbe_q2 from=0.0 to=2e-08
meas tran mf_ss_vbemax_q2 MAX mfq_vbe_q2 from=2e-08 to=4e-08
meas tran mf_ss_vbemin_q2 MIN mfq_vbe_q2 from=2e-08 to=4e-08
let mfq_ic_q2 = i(vic_q2)
meas tran mf_su_icmax_q2 MAX mfq_ic_q2 from=0.0 to=2e-08
meas tran mf_su_icmin_q2 MIN mfq_ic_q2 from=0.0 to=2e-08
meas tran mf_ss_icmax_q2 MAX mfq_ic_q2 from=2e-08 to=4e-08
meas tran mf_ss_icmin_q2 MIN mfq_ic_q2 from=2e-08 to=4e-08
let mfq_vce_q3 = v(c_q3)-v(x1)
meas tran mf_su_vcemax_q3 MAX mfq_vce_q3 from=0.0 to=2e-08
meas tran mf_su_vcemin_q3 MIN mfq_vce_q3 from=0.0 to=2e-08
meas tran mf_ss_vcemax_q3 MAX mfq_vce_q3 from=2e-08 to=4e-08
meas tran mf_ss_vcemin_q3 MIN mfq_vce_q3 from=2e-08 to=4e-08
let mfq_vbe_q3 = v(lo_p)-v(x1)
meas tran mf_su_vbemax_q3 MAX mfq_vbe_q3 from=0.0 to=2e-08
meas tran mf_su_vbemin_q3 MIN mfq_vbe_q3 from=0.0 to=2e-08
meas tran mf_ss_vbemax_q3 MAX mfq_vbe_q3 from=2e-08 to=4e-08
meas tran mf_ss_vbemin_q3 MIN mfq_vbe_q3 from=2e-08 to=4e-08
let mfq_ic_q3 = i(vic_q3)
meas tran mf_su_icmax_q3 MAX mfq_ic_q3 from=0.0 to=2e-08
meas tran mf_su_icmin_q3 MIN mfq_ic_q3 from=0.0 to=2e-08
meas tran mf_ss_icmax_q3 MAX mfq_ic_q3 from=2e-08 to=4e-08
meas tran mf_ss_icmin_q3 MIN mfq_ic_q3 from=2e-08 to=4e-08
let mfq_vce_q4 = v(c_q4)-v(x1)
meas tran mf_su_vcemax_q4 MAX mfq_vce_q4 from=0.0 to=2e-08
meas tran mf_su_vcemin_q4 MIN mfq_vce_q4 from=0.0 to=2e-08
meas tran mf_ss_vcemax_q4 MAX mfq_vce_q4 from=2e-08 to=4e-08
meas tran mf_ss_vcemin_q4 MIN mfq_vce_q4 from=2e-08 to=4e-08
let mfq_vbe_q4 = v(lo_n)-v(x1)
meas tran mf_su_vbemax_q4 MAX mfq_vbe_q4 from=0.0 to=2e-08
meas tran mf_su_vbemin_q4 MIN mfq_vbe_q4 from=0.0 to=2e-08
meas tran mf_ss_vbemax_q4 MAX mfq_vbe_q4 from=2e-08 to=4e-08
meas tran mf_ss_vbemin_q4 MIN mfq_vbe_q4 from=2e-08 to=4e-08
let mfq_ic_q4 = i(vic_q4)
meas tran mf_su_icmax_q4 MAX mfq_ic_q4 from=0.0 to=2e-08
meas tran mf_su_icmin_q4 MIN mfq_ic_q4 from=0.0 to=2e-08
meas tran mf_ss_icmax_q4 MAX mfq_ic_q4 from=2e-08 to=4e-08
meas tran mf_ss_icmin_q4 MIN mfq_ic_q4 from=2e-08 to=4e-08
let mfq_vce_q5 = v(c_q5)-v(x2)
meas tran mf_su_vcemax_q5 MAX mfq_vce_q5 from=0.0 to=2e-08
meas tran mf_su_vcemin_q5 MIN mfq_vce_q5 from=0.0 to=2e-08
meas tran mf_ss_vcemax_q5 MAX mfq_vce_q5 from=2e-08 to=4e-08
meas tran mf_ss_vcemin_q5 MIN mfq_vce_q5 from=2e-08 to=4e-08
let mfq_vbe_q5 = v(lo_p)-v(x2)
meas tran mf_su_vbemax_q5 MAX mfq_vbe_q5 from=0.0 to=2e-08
meas tran mf_su_vbemin_q5 MIN mfq_vbe_q5 from=0.0 to=2e-08
meas tran mf_ss_vbemax_q5 MAX mfq_vbe_q5 from=2e-08 to=4e-08
meas tran mf_ss_vbemin_q5 MIN mfq_vbe_q5 from=2e-08 to=4e-08
let mfq_ic_q5 = i(vic_q5)
meas tran mf_su_icmax_q5 MAX mfq_ic_q5 from=0.0 to=2e-08
meas tran mf_su_icmin_q5 MIN mfq_ic_q5 from=0.0 to=2e-08
meas tran mf_ss_icmax_q5 MAX mfq_ic_q5 from=2e-08 to=4e-08
meas tran mf_ss_icmin_q5 MIN mfq_ic_q5 from=2e-08 to=4e-08
let mfq_vce_q6 = v(c_q6)-v(x2)
meas tran mf_su_vcemax_q6 MAX mfq_vce_q6 from=0.0 to=2e-08
meas tran mf_su_vcemin_q6 MIN mfq_vce_q6 from=0.0 to=2e-08
meas tran mf_ss_vcemax_q6 MAX mfq_vce_q6 from=2e-08 to=4e-08
meas tran mf_ss_vcemin_q6 MIN mfq_vce_q6 from=2e-08 to=4e-08
let mfq_vbe_q6 = v(lo_n)-v(x2)
meas tran mf_su_vbemax_q6 MAX mfq_vbe_q6 from=0.0 to=2e-08
meas tran mf_su_vbemin_q6 MIN mfq_vbe_q6 from=0.0 to=2e-08
meas tran mf_ss_vbemax_q6 MAX mfq_vbe_q6 from=2e-08 to=4e-08
meas tran mf_ss_vbemin_q6 MIN mfq_vbe_q6 from=2e-08 to=4e-08
let mfq_ic_q6 = i(vic_q6)
meas tran mf_su_icmax_q6 MAX mfq_ic_q6 from=0.0 to=2e-08
meas tran mf_su_icmin_q6 MIN mfq_ic_q6 from=0.0 to=2e-08
meas tran mf_ss_icmax_q6 MAX mfq_ic_q6 from=2e-08 to=4e-08
meas tran mf_ss_icmin_q6 MIN mfq_ic_q6 from=2e-08 to=4e-08
meas tran mf_su_sinkmin_tail MIN v(tail) from=0.0 to=2e-08
meas tran mf_ss_sinkmin_tail MIN v(tail) from=2e-08 to=4e-08
print mf_su_vcemax_q1
print mf_su_vcemin_q1
print mf_ss_vcemax_q1
print mf_ss_vcemin_q1
print mf_su_vbemax_q1
print mf_su_vbemin_q1
print mf_ss_vbemax_q1
print mf_ss_vbemin_q1
print mf_su_icmax_q1
print mf_su_icmin_q1
print mf_ss_icmax_q1
print mf_ss_icmin_q1
print mf_su_vcemax_q2
print mf_su_vcemin_q2
print mf_ss_vcemax_q2
print mf_ss_vcemin_q2
print mf_su_vbemax_q2
print mf_su_vbemin_q2
print mf_ss_vbemax_q2
print mf_ss_vbemin_q2
print mf_su_icmax_q2
print mf_su_icmin_q2
print mf_ss_icmax_q2
print mf_ss_icmin_q2
print mf_su_vcemax_q3
print mf_su_vcemin_q3
print mf_ss_vcemax_q3
print mf_ss_vcemin_q3
print mf_su_vbemax_q3
print mf_su_vbemin_q3
print mf_ss_vbemax_q3
print mf_ss_vbemin_q3
print mf_su_icmax_q3
print mf_su_icmin_q3
print mf_ss_icmax_q3
print mf_ss_icmin_q3
print mf_su_vcemax_q4
print mf_su_vcemin_q4
print mf_ss_vcemax_q4
print mf_ss_vcemin_q4
print mf_su_vbemax_q4
print mf_su_vbemin_q4
print mf_ss_vbemax_q4
print mf_ss_vbemin_q4
print mf_su_icmax_q4
print mf_su_icmin_q4
print mf_ss_icmax_q4
print mf_ss_icmin_q4
print mf_su_vcemax_q5
print mf_su_vcemin_q5
print mf_ss_vcemax_q5
print mf_ss_vcemin_q5
print mf_su_vbemax_q5
print mf_su_vbemin_q5
print mf_ss_vbemax_q5
print mf_ss_vbemin_q5
print mf_su_icmax_q5
print mf_su_icmin_q5
print mf_ss_icmax_q5
print mf_ss_icmin_q5
print mf_su_vcemax_q6
print mf_su_vcemin_q6
print mf_ss_vcemax_q6
print mf_ss_vcemin_q6
print mf_su_vbemax_q6
print mf_su_vbemin_q6
print mf_ss_vbemax_q6
print mf_ss_vbemin_q6
print mf_su_icmax_q6
print mf_su_icmin_q6
print mf_ss_icmax_q6
print mf_ss_icmin_q6
print mf_su_sinkmin_tail
print mf_ss_sinkmin_tail
linearize
let mf_l = length(time)
let mfw = (time ge 1.99995e-08) * (time lt 3.99995e-08)
let mf_n = mean(mfw) * mf_l
let mfs = mf_l / mf_n
let mf_prail = mean(v(vdd) * (0 - i(vdd)) * mfw) * mfs
let mfph = 2 * pi * 16700000000.0 * (time - 2e-08)
let mf_lodiff_re = 2 * mean((v(lo_p)-v(lo_n)) * mfw * cos(mfph)) * mfs
let mf_lodiff_im = 2 * mean((v(lo_p)-v(lo_n)) * mfw * sin(mfph)) * mfs
let mfph = 2 * pi * 1000000000.0 * (time - 2e-08)
let mf_if_re = 2 * mean((v(if_out)) * mfw * cos(mfph)) * mfs
let mf_if_im = 2 * mean((v(if_out)) * mfw * sin(mfph)) * mfs
let mfph = 2 * pi * 16700000000.0 * (time - 2e-08)
let mf_loif_re = 2 * mean((v(if_out)) * mfw * cos(mfph)) * mfs
let mf_loif_im = 2 * mean((v(if_out)) * mfw * sin(mfph)) * mfs
let mfph = 2 * pi * 16700000000.0 * (time - 2e-08)
let mf_lorf_re = 2 * mean((v(rf_port)) * mfw * cos(mfph)) * mfs
let mf_lorf_im = 2 * mean((v(rf_port)) * mfw * sin(mfph)) * mfs
let mfph = 2 * pi * 950000000.0 * (time - 2e-08)
let mf_flifa_re = 2 * mean((v(if_out)) * mfw * cos(mfph)) * mfs
let mf_flifa_im = 2 * mean((v(if_out)) * mfw * sin(mfph)) * mfs
let mfph = 2 * pi * 1050000000.0 * (time - 2e-08)
let mf_flifb_re = 2 * mean((v(if_out)) * mfw * cos(mfph)) * mfs
let mf_flifb_im = 2 * mean((v(if_out)) * mfw * sin(mfph)) * mfs
let mfph = 2 * pi * 16750000000.0 * (time - 2e-08)
let mf_fllorf_re = 2 * mean((v(rf_port)) * mfw * cos(mfph)) * mfs
let mf_fllorf_im = 2 * mean((v(rf_port)) * mfw * sin(mfph)) * mfs
let mfph = 2 * pi * 16750000000.0 * (time - 2e-08)
let mf_flloif_re = 2 * mean((v(if_out)) * mfw * cos(mfph)) * mfs
let mf_flloif_im = 2 * mean((v(if_out)) * mfw * sin(mfph)) * mfs
print mf_l
print mf_n
print mf_prail
print mf_lodiff_re
print mf_lodiff_im
print mf_if_re
print mf_if_im
print mf_loif_re
print mf_loif_im
print mf_lorf_re
print mf_lorf_im
print mf_flifa_re
print mf_flifa_im
print mf_flifb_re
print mf_flifb_im
print mf_fllorf_re
print mf_fllorf_im
print mf_flloif_re
print mf_flloif_im
destroy all
echo "MFEND ls_f17p70_m24_rf66"
echo "MFRUN ls_f17p70_m21_rf60"
alterparam f1 = 17700000000.0
alterparam f2 = 17700000000.0
alterparam flo = 16700000000.0
alterparam vrf1 = 0.0006324555320336759
alterparam vrf2 = 0.0
alterparam vlo = 0.07971590730710057
reset
op
let mf_dcirail = 0 - i(vdd)
let mf_dc_vce_q1 = v(c_q1)-v(e_q1)
let mf_dc_vbe_q1 = v(b_q1)-v(e_q1)
let mf_dc_ic_q1 = i(vic_q1)
let mf_dc_vce_q2 = v(c_q2)-v(e_q2)
let mf_dc_vbe_q2 = v(b_q2)-v(e_q2)
let mf_dc_ic_q2 = i(vic_q2)
let mf_dc_vce_q3 = v(c_q3)-v(x1)
let mf_dc_vbe_q3 = v(lo_p)-v(x1)
let mf_dc_ic_q3 = i(vic_q3)
let mf_dc_vce_q4 = v(c_q4)-v(x1)
let mf_dc_vbe_q4 = v(lo_n)-v(x1)
let mf_dc_ic_q4 = i(vic_q4)
let mf_dc_vce_q5 = v(c_q5)-v(x2)
let mf_dc_vbe_q5 = v(lo_p)-v(x2)
let mf_dc_ic_q5 = i(vic_q5)
let mf_dc_vce_q6 = v(c_q6)-v(x2)
let mf_dc_vbe_q6 = v(lo_n)-v(x2)
let mf_dc_ic_q6 = i(vic_q6)
let mf_dc_sink_tail = v(tail)
print mf_dcirail
print mf_dc_vce_q1
print mf_dc_vbe_q1
print mf_dc_ic_q1
print mf_dc_vce_q2
print mf_dc_vbe_q2
print mf_dc_ic_q2
print mf_dc_vce_q3
print mf_dc_vbe_q3
print mf_dc_ic_q3
print mf_dc_vce_q4
print mf_dc_vbe_q4
print mf_dc_ic_q4
print mf_dc_vce_q5
print mf_dc_vbe_q5
print mf_dc_ic_q5
print mf_dc_vce_q6
print mf_dc_vbe_q6
print mf_dc_ic_q6
print mf_dc_sink_tail
tran 1e-12 4e-08 0 1e-12
let mfq_vce_q1 = v(c_q1)-v(e_q1)
meas tran mf_su_vcemax_q1 MAX mfq_vce_q1 from=0.0 to=2e-08
meas tran mf_su_vcemin_q1 MIN mfq_vce_q1 from=0.0 to=2e-08
meas tran mf_ss_vcemax_q1 MAX mfq_vce_q1 from=2e-08 to=4e-08
meas tran mf_ss_vcemin_q1 MIN mfq_vce_q1 from=2e-08 to=4e-08
let mfq_vbe_q1 = v(b_q1)-v(e_q1)
meas tran mf_su_vbemax_q1 MAX mfq_vbe_q1 from=0.0 to=2e-08
meas tran mf_su_vbemin_q1 MIN mfq_vbe_q1 from=0.0 to=2e-08
meas tran mf_ss_vbemax_q1 MAX mfq_vbe_q1 from=2e-08 to=4e-08
meas tran mf_ss_vbemin_q1 MIN mfq_vbe_q1 from=2e-08 to=4e-08
let mfq_ic_q1 = i(vic_q1)
meas tran mf_su_icmax_q1 MAX mfq_ic_q1 from=0.0 to=2e-08
meas tran mf_su_icmin_q1 MIN mfq_ic_q1 from=0.0 to=2e-08
meas tran mf_ss_icmax_q1 MAX mfq_ic_q1 from=2e-08 to=4e-08
meas tran mf_ss_icmin_q1 MIN mfq_ic_q1 from=2e-08 to=4e-08
let mfq_vce_q2 = v(c_q2)-v(e_q2)
meas tran mf_su_vcemax_q2 MAX mfq_vce_q2 from=0.0 to=2e-08
meas tran mf_su_vcemin_q2 MIN mfq_vce_q2 from=0.0 to=2e-08
meas tran mf_ss_vcemax_q2 MAX mfq_vce_q2 from=2e-08 to=4e-08
meas tran mf_ss_vcemin_q2 MIN mfq_vce_q2 from=2e-08 to=4e-08
let mfq_vbe_q2 = v(b_q2)-v(e_q2)
meas tran mf_su_vbemax_q2 MAX mfq_vbe_q2 from=0.0 to=2e-08
meas tran mf_su_vbemin_q2 MIN mfq_vbe_q2 from=0.0 to=2e-08
meas tran mf_ss_vbemax_q2 MAX mfq_vbe_q2 from=2e-08 to=4e-08
meas tran mf_ss_vbemin_q2 MIN mfq_vbe_q2 from=2e-08 to=4e-08
let mfq_ic_q2 = i(vic_q2)
meas tran mf_su_icmax_q2 MAX mfq_ic_q2 from=0.0 to=2e-08
meas tran mf_su_icmin_q2 MIN mfq_ic_q2 from=0.0 to=2e-08
meas tran mf_ss_icmax_q2 MAX mfq_ic_q2 from=2e-08 to=4e-08
meas tran mf_ss_icmin_q2 MIN mfq_ic_q2 from=2e-08 to=4e-08
let mfq_vce_q3 = v(c_q3)-v(x1)
meas tran mf_su_vcemax_q3 MAX mfq_vce_q3 from=0.0 to=2e-08
meas tran mf_su_vcemin_q3 MIN mfq_vce_q3 from=0.0 to=2e-08
meas tran mf_ss_vcemax_q3 MAX mfq_vce_q3 from=2e-08 to=4e-08
meas tran mf_ss_vcemin_q3 MIN mfq_vce_q3 from=2e-08 to=4e-08
let mfq_vbe_q3 = v(lo_p)-v(x1)
meas tran mf_su_vbemax_q3 MAX mfq_vbe_q3 from=0.0 to=2e-08
meas tran mf_su_vbemin_q3 MIN mfq_vbe_q3 from=0.0 to=2e-08
meas tran mf_ss_vbemax_q3 MAX mfq_vbe_q3 from=2e-08 to=4e-08
meas tran mf_ss_vbemin_q3 MIN mfq_vbe_q3 from=2e-08 to=4e-08
let mfq_ic_q3 = i(vic_q3)
meas tran mf_su_icmax_q3 MAX mfq_ic_q3 from=0.0 to=2e-08
meas tran mf_su_icmin_q3 MIN mfq_ic_q3 from=0.0 to=2e-08
meas tran mf_ss_icmax_q3 MAX mfq_ic_q3 from=2e-08 to=4e-08
meas tran mf_ss_icmin_q3 MIN mfq_ic_q3 from=2e-08 to=4e-08
let mfq_vce_q4 = v(c_q4)-v(x1)
meas tran mf_su_vcemax_q4 MAX mfq_vce_q4 from=0.0 to=2e-08
meas tran mf_su_vcemin_q4 MIN mfq_vce_q4 from=0.0 to=2e-08
meas tran mf_ss_vcemax_q4 MAX mfq_vce_q4 from=2e-08 to=4e-08
meas tran mf_ss_vcemin_q4 MIN mfq_vce_q4 from=2e-08 to=4e-08
let mfq_vbe_q4 = v(lo_n)-v(x1)
meas tran mf_su_vbemax_q4 MAX mfq_vbe_q4 from=0.0 to=2e-08
meas tran mf_su_vbemin_q4 MIN mfq_vbe_q4 from=0.0 to=2e-08
meas tran mf_ss_vbemax_q4 MAX mfq_vbe_q4 from=2e-08 to=4e-08
meas tran mf_ss_vbemin_q4 MIN mfq_vbe_q4 from=2e-08 to=4e-08
let mfq_ic_q4 = i(vic_q4)
meas tran mf_su_icmax_q4 MAX mfq_ic_q4 from=0.0 to=2e-08
meas tran mf_su_icmin_q4 MIN mfq_ic_q4 from=0.0 to=2e-08
meas tran mf_ss_icmax_q4 MAX mfq_ic_q4 from=2e-08 to=4e-08
meas tran mf_ss_icmin_q4 MIN mfq_ic_q4 from=2e-08 to=4e-08
let mfq_vce_q5 = v(c_q5)-v(x2)
meas tran mf_su_vcemax_q5 MAX mfq_vce_q5 from=0.0 to=2e-08
meas tran mf_su_vcemin_q5 MIN mfq_vce_q5 from=0.0 to=2e-08
meas tran mf_ss_vcemax_q5 MAX mfq_vce_q5 from=2e-08 to=4e-08
meas tran mf_ss_vcemin_q5 MIN mfq_vce_q5 from=2e-08 to=4e-08
let mfq_vbe_q5 = v(lo_p)-v(x2)
meas tran mf_su_vbemax_q5 MAX mfq_vbe_q5 from=0.0 to=2e-08
meas tran mf_su_vbemin_q5 MIN mfq_vbe_q5 from=0.0 to=2e-08
meas tran mf_ss_vbemax_q5 MAX mfq_vbe_q5 from=2e-08 to=4e-08
meas tran mf_ss_vbemin_q5 MIN mfq_vbe_q5 from=2e-08 to=4e-08
let mfq_ic_q5 = i(vic_q5)
meas tran mf_su_icmax_q5 MAX mfq_ic_q5 from=0.0 to=2e-08
meas tran mf_su_icmin_q5 MIN mfq_ic_q5 from=0.0 to=2e-08
meas tran mf_ss_icmax_q5 MAX mfq_ic_q5 from=2e-08 to=4e-08
meas tran mf_ss_icmin_q5 MIN mfq_ic_q5 from=2e-08 to=4e-08
let mfq_vce_q6 = v(c_q6)-v(x2)
meas tran mf_su_vcemax_q6 MAX mfq_vce_q6 from=0.0 to=2e-08
meas tran mf_su_vcemin_q6 MIN mfq_vce_q6 from=0.0 to=2e-08
meas tran mf_ss_vcemax_q6 MAX mfq_vce_q6 from=2e-08 to=4e-08
meas tran mf_ss_vcemin_q6 MIN mfq_vce_q6 from=2e-08 to=4e-08
let mfq_vbe_q6 = v(lo_n)-v(x2)
meas tran mf_su_vbemax_q6 MAX mfq_vbe_q6 from=0.0 to=2e-08
meas tran mf_su_vbemin_q6 MIN mfq_vbe_q6 from=0.0 to=2e-08
meas tran mf_ss_vbemax_q6 MAX mfq_vbe_q6 from=2e-08 to=4e-08
meas tran mf_ss_vbemin_q6 MIN mfq_vbe_q6 from=2e-08 to=4e-08
let mfq_ic_q6 = i(vic_q6)
meas tran mf_su_icmax_q6 MAX mfq_ic_q6 from=0.0 to=2e-08
meas tran mf_su_icmin_q6 MIN mfq_ic_q6 from=0.0 to=2e-08
meas tran mf_ss_icmax_q6 MAX mfq_ic_q6 from=2e-08 to=4e-08
meas tran mf_ss_icmin_q6 MIN mfq_ic_q6 from=2e-08 to=4e-08
meas tran mf_su_sinkmin_tail MIN v(tail) from=0.0 to=2e-08
meas tran mf_ss_sinkmin_tail MIN v(tail) from=2e-08 to=4e-08
print mf_su_vcemax_q1
print mf_su_vcemin_q1
print mf_ss_vcemax_q1
print mf_ss_vcemin_q1
print mf_su_vbemax_q1
print mf_su_vbemin_q1
print mf_ss_vbemax_q1
print mf_ss_vbemin_q1
print mf_su_icmax_q1
print mf_su_icmin_q1
print mf_ss_icmax_q1
print mf_ss_icmin_q1
print mf_su_vcemax_q2
print mf_su_vcemin_q2
print mf_ss_vcemax_q2
print mf_ss_vcemin_q2
print mf_su_vbemax_q2
print mf_su_vbemin_q2
print mf_ss_vbemax_q2
print mf_ss_vbemin_q2
print mf_su_icmax_q2
print mf_su_icmin_q2
print mf_ss_icmax_q2
print mf_ss_icmin_q2
print mf_su_vcemax_q3
print mf_su_vcemin_q3
print mf_ss_vcemax_q3
print mf_ss_vcemin_q3
print mf_su_vbemax_q3
print mf_su_vbemin_q3
print mf_ss_vbemax_q3
print mf_ss_vbemin_q3
print mf_su_icmax_q3
print mf_su_icmin_q3
print mf_ss_icmax_q3
print mf_ss_icmin_q3
print mf_su_vcemax_q4
print mf_su_vcemin_q4
print mf_ss_vcemax_q4
print mf_ss_vcemin_q4
print mf_su_vbemax_q4
print mf_su_vbemin_q4
print mf_ss_vbemax_q4
print mf_ss_vbemin_q4
print mf_su_icmax_q4
print mf_su_icmin_q4
print mf_ss_icmax_q4
print mf_ss_icmin_q4
print mf_su_vcemax_q5
print mf_su_vcemin_q5
print mf_ss_vcemax_q5
print mf_ss_vcemin_q5
print mf_su_vbemax_q5
print mf_su_vbemin_q5
print mf_ss_vbemax_q5
print mf_ss_vbemin_q5
print mf_su_icmax_q5
print mf_su_icmin_q5
print mf_ss_icmax_q5
print mf_ss_icmin_q5
print mf_su_vcemax_q6
print mf_su_vcemin_q6
print mf_ss_vcemax_q6
print mf_ss_vcemin_q6
print mf_su_vbemax_q6
print mf_su_vbemin_q6
print mf_ss_vbemax_q6
print mf_ss_vbemin_q6
print mf_su_icmax_q6
print mf_su_icmin_q6
print mf_ss_icmax_q6
print mf_ss_icmin_q6
print mf_su_sinkmin_tail
print mf_ss_sinkmin_tail
linearize
let mf_l = length(time)
let mfw = (time ge 1.99995e-08) * (time lt 3.99995e-08)
let mf_n = mean(mfw) * mf_l
let mfs = mf_l / mf_n
let mf_prail = mean(v(vdd) * (0 - i(vdd)) * mfw) * mfs
let mfph = 2 * pi * 16700000000.0 * (time - 2e-08)
let mf_lodiff_re = 2 * mean((v(lo_p)-v(lo_n)) * mfw * cos(mfph)) * mfs
let mf_lodiff_im = 2 * mean((v(lo_p)-v(lo_n)) * mfw * sin(mfph)) * mfs
let mfph = 2 * pi * 1000000000.0 * (time - 2e-08)
let mf_if_re = 2 * mean((v(if_out)) * mfw * cos(mfph)) * mfs
let mf_if_im = 2 * mean((v(if_out)) * mfw * sin(mfph)) * mfs
let mfph = 2 * pi * 16700000000.0 * (time - 2e-08)
let mf_loif_re = 2 * mean((v(if_out)) * mfw * cos(mfph)) * mfs
let mf_loif_im = 2 * mean((v(if_out)) * mfw * sin(mfph)) * mfs
let mfph = 2 * pi * 16700000000.0 * (time - 2e-08)
let mf_lorf_re = 2 * mean((v(rf_port)) * mfw * cos(mfph)) * mfs
let mf_lorf_im = 2 * mean((v(rf_port)) * mfw * sin(mfph)) * mfs
let mfph = 2 * pi * 950000000.0 * (time - 2e-08)
let mf_flifa_re = 2 * mean((v(if_out)) * mfw * cos(mfph)) * mfs
let mf_flifa_im = 2 * mean((v(if_out)) * mfw * sin(mfph)) * mfs
let mfph = 2 * pi * 1050000000.0 * (time - 2e-08)
let mf_flifb_re = 2 * mean((v(if_out)) * mfw * cos(mfph)) * mfs
let mf_flifb_im = 2 * mean((v(if_out)) * mfw * sin(mfph)) * mfs
let mfph = 2 * pi * 16750000000.0 * (time - 2e-08)
let mf_fllorf_re = 2 * mean((v(rf_port)) * mfw * cos(mfph)) * mfs
let mf_fllorf_im = 2 * mean((v(rf_port)) * mfw * sin(mfph)) * mfs
let mfph = 2 * pi * 16750000000.0 * (time - 2e-08)
let mf_flloif_re = 2 * mean((v(if_out)) * mfw * cos(mfph)) * mfs
let mf_flloif_im = 2 * mean((v(if_out)) * mfw * sin(mfph)) * mfs
print mf_l
print mf_n
print mf_prail
print mf_lodiff_re
print mf_lodiff_im
print mf_if_re
print mf_if_im
print mf_loif_re
print mf_loif_im
print mf_lorf_re
print mf_lorf_im
print mf_flifa_re
print mf_flifa_im
print mf_flifb_re
print mf_flifb_im
print mf_fllorf_re
print mf_fllorf_im
print mf_flloif_re
print mf_flloif_im
destroy all
echo "MFEND ls_f17p70_m21_rf60"
echo "MFRUN ls_f17p70_m21_rf66"
alterparam f1 = 17700000000.0
alterparam f2 = 17700000000.0
alterparam flo = 16700000000.0
alterparam vrf1 = 0.00031697863849222284
alterparam vrf2 = 0.0
alterparam vlo = 0.07971590730710057
reset
op
let mf_dcirail = 0 - i(vdd)
let mf_dc_vce_q1 = v(c_q1)-v(e_q1)
let mf_dc_vbe_q1 = v(b_q1)-v(e_q1)
let mf_dc_ic_q1 = i(vic_q1)
let mf_dc_vce_q2 = v(c_q2)-v(e_q2)
let mf_dc_vbe_q2 = v(b_q2)-v(e_q2)
let mf_dc_ic_q2 = i(vic_q2)
let mf_dc_vce_q3 = v(c_q3)-v(x1)
let mf_dc_vbe_q3 = v(lo_p)-v(x1)
let mf_dc_ic_q3 = i(vic_q3)
let mf_dc_vce_q4 = v(c_q4)-v(x1)
let mf_dc_vbe_q4 = v(lo_n)-v(x1)
let mf_dc_ic_q4 = i(vic_q4)
let mf_dc_vce_q5 = v(c_q5)-v(x2)
let mf_dc_vbe_q5 = v(lo_p)-v(x2)
let mf_dc_ic_q5 = i(vic_q5)
let mf_dc_vce_q6 = v(c_q6)-v(x2)
let mf_dc_vbe_q6 = v(lo_n)-v(x2)
let mf_dc_ic_q6 = i(vic_q6)
let mf_dc_sink_tail = v(tail)
print mf_dcirail
print mf_dc_vce_q1
print mf_dc_vbe_q1
print mf_dc_ic_q1
print mf_dc_vce_q2
print mf_dc_vbe_q2
print mf_dc_ic_q2
print mf_dc_vce_q3
print mf_dc_vbe_q3
print mf_dc_ic_q3
print mf_dc_vce_q4
print mf_dc_vbe_q4
print mf_dc_ic_q4
print mf_dc_vce_q5
print mf_dc_vbe_q5
print mf_dc_ic_q5
print mf_dc_vce_q6
print mf_dc_vbe_q6
print mf_dc_ic_q6
print mf_dc_sink_tail
tran 1e-12 4e-08 0 1e-12
let mfq_vce_q1 = v(c_q1)-v(e_q1)
meas tran mf_su_vcemax_q1 MAX mfq_vce_q1 from=0.0 to=2e-08
meas tran mf_su_vcemin_q1 MIN mfq_vce_q1 from=0.0 to=2e-08
meas tran mf_ss_vcemax_q1 MAX mfq_vce_q1 from=2e-08 to=4e-08
meas tran mf_ss_vcemin_q1 MIN mfq_vce_q1 from=2e-08 to=4e-08
let mfq_vbe_q1 = v(b_q1)-v(e_q1)
meas tran mf_su_vbemax_q1 MAX mfq_vbe_q1 from=0.0 to=2e-08
meas tran mf_su_vbemin_q1 MIN mfq_vbe_q1 from=0.0 to=2e-08
meas tran mf_ss_vbemax_q1 MAX mfq_vbe_q1 from=2e-08 to=4e-08
meas tran mf_ss_vbemin_q1 MIN mfq_vbe_q1 from=2e-08 to=4e-08
let mfq_ic_q1 = i(vic_q1)
meas tran mf_su_icmax_q1 MAX mfq_ic_q1 from=0.0 to=2e-08
meas tran mf_su_icmin_q1 MIN mfq_ic_q1 from=0.0 to=2e-08
meas tran mf_ss_icmax_q1 MAX mfq_ic_q1 from=2e-08 to=4e-08
meas tran mf_ss_icmin_q1 MIN mfq_ic_q1 from=2e-08 to=4e-08
let mfq_vce_q2 = v(c_q2)-v(e_q2)
meas tran mf_su_vcemax_q2 MAX mfq_vce_q2 from=0.0 to=2e-08
meas tran mf_su_vcemin_q2 MIN mfq_vce_q2 from=0.0 to=2e-08
meas tran mf_ss_vcemax_q2 MAX mfq_vce_q2 from=2e-08 to=4e-08
meas tran mf_ss_vcemin_q2 MIN mfq_vce_q2 from=2e-08 to=4e-08
let mfq_vbe_q2 = v(b_q2)-v(e_q2)
meas tran mf_su_vbemax_q2 MAX mfq_vbe_q2 from=0.0 to=2e-08
meas tran mf_su_vbemin_q2 MIN mfq_vbe_q2 from=0.0 to=2e-08
meas tran mf_ss_vbemax_q2 MAX mfq_vbe_q2 from=2e-08 to=4e-08
meas tran mf_ss_vbemin_q2 MIN mfq_vbe_q2 from=2e-08 to=4e-08
let mfq_ic_q2 = i(vic_q2)
meas tran mf_su_icmax_q2 MAX mfq_ic_q2 from=0.0 to=2e-08
meas tran mf_su_icmin_q2 MIN mfq_ic_q2 from=0.0 to=2e-08
meas tran mf_ss_icmax_q2 MAX mfq_ic_q2 from=2e-08 to=4e-08
meas tran mf_ss_icmin_q2 MIN mfq_ic_q2 from=2e-08 to=4e-08
let mfq_vce_q3 = v(c_q3)-v(x1)
meas tran mf_su_vcemax_q3 MAX mfq_vce_q3 from=0.0 to=2e-08
meas tran mf_su_vcemin_q3 MIN mfq_vce_q3 from=0.0 to=2e-08
meas tran mf_ss_vcemax_q3 MAX mfq_vce_q3 from=2e-08 to=4e-08
meas tran mf_ss_vcemin_q3 MIN mfq_vce_q3 from=2e-08 to=4e-08
let mfq_vbe_q3 = v(lo_p)-v(x1)
meas tran mf_su_vbemax_q3 MAX mfq_vbe_q3 from=0.0 to=2e-08
meas tran mf_su_vbemin_q3 MIN mfq_vbe_q3 from=0.0 to=2e-08
meas tran mf_ss_vbemax_q3 MAX mfq_vbe_q3 from=2e-08 to=4e-08
meas tran mf_ss_vbemin_q3 MIN mfq_vbe_q3 from=2e-08 to=4e-08
let mfq_ic_q3 = i(vic_q3)
meas tran mf_su_icmax_q3 MAX mfq_ic_q3 from=0.0 to=2e-08
meas tran mf_su_icmin_q3 MIN mfq_ic_q3 from=0.0 to=2e-08
meas tran mf_ss_icmax_q3 MAX mfq_ic_q3 from=2e-08 to=4e-08
meas tran mf_ss_icmin_q3 MIN mfq_ic_q3 from=2e-08 to=4e-08
let mfq_vce_q4 = v(c_q4)-v(x1)
meas tran mf_su_vcemax_q4 MAX mfq_vce_q4 from=0.0 to=2e-08
meas tran mf_su_vcemin_q4 MIN mfq_vce_q4 from=0.0 to=2e-08
meas tran mf_ss_vcemax_q4 MAX mfq_vce_q4 from=2e-08 to=4e-08
meas tran mf_ss_vcemin_q4 MIN mfq_vce_q4 from=2e-08 to=4e-08
let mfq_vbe_q4 = v(lo_n)-v(x1)
meas tran mf_su_vbemax_q4 MAX mfq_vbe_q4 from=0.0 to=2e-08
meas tran mf_su_vbemin_q4 MIN mfq_vbe_q4 from=0.0 to=2e-08
meas tran mf_ss_vbemax_q4 MAX mfq_vbe_q4 from=2e-08 to=4e-08
meas tran mf_ss_vbemin_q4 MIN mfq_vbe_q4 from=2e-08 to=4e-08
let mfq_ic_q4 = i(vic_q4)
meas tran mf_su_icmax_q4 MAX mfq_ic_q4 from=0.0 to=2e-08
meas tran mf_su_icmin_q4 MIN mfq_ic_q4 from=0.0 to=2e-08
meas tran mf_ss_icmax_q4 MAX mfq_ic_q4 from=2e-08 to=4e-08
meas tran mf_ss_icmin_q4 MIN mfq_ic_q4 from=2e-08 to=4e-08
let mfq_vce_q5 = v(c_q5)-v(x2)
meas tran mf_su_vcemax_q5 MAX mfq_vce_q5 from=0.0 to=2e-08
meas tran mf_su_vcemin_q5 MIN mfq_vce_q5 from=0.0 to=2e-08
meas tran mf_ss_vcemax_q5 MAX mfq_vce_q5 from=2e-08 to=4e-08
meas tran mf_ss_vcemin_q5 MIN mfq_vce_q5 from=2e-08 to=4e-08
let mfq_vbe_q5 = v(lo_p)-v(x2)
meas tran mf_su_vbemax_q5 MAX mfq_vbe_q5 from=0.0 to=2e-08
meas tran mf_su_vbemin_q5 MIN mfq_vbe_q5 from=0.0 to=2e-08
meas tran mf_ss_vbemax_q5 MAX mfq_vbe_q5 from=2e-08 to=4e-08
meas tran mf_ss_vbemin_q5 MIN mfq_vbe_q5 from=2e-08 to=4e-08
let mfq_ic_q5 = i(vic_q5)
meas tran mf_su_icmax_q5 MAX mfq_ic_q5 from=0.0 to=2e-08
meas tran mf_su_icmin_q5 MIN mfq_ic_q5 from=0.0 to=2e-08
meas tran mf_ss_icmax_q5 MAX mfq_ic_q5 from=2e-08 to=4e-08
meas tran mf_ss_icmin_q5 MIN mfq_ic_q5 from=2e-08 to=4e-08
let mfq_vce_q6 = v(c_q6)-v(x2)
meas tran mf_su_vcemax_q6 MAX mfq_vce_q6 from=0.0 to=2e-08
meas tran mf_su_vcemin_q6 MIN mfq_vce_q6 from=0.0 to=2e-08
meas tran mf_ss_vcemax_q6 MAX mfq_vce_q6 from=2e-08 to=4e-08
meas tran mf_ss_vcemin_q6 MIN mfq_vce_q6 from=2e-08 to=4e-08
let mfq_vbe_q6 = v(lo_n)-v(x2)
meas tran mf_su_vbemax_q6 MAX mfq_vbe_q6 from=0.0 to=2e-08
meas tran mf_su_vbemin_q6 MIN mfq_vbe_q6 from=0.0 to=2e-08
meas tran mf_ss_vbemax_q6 MAX mfq_vbe_q6 from=2e-08 to=4e-08
meas tran mf_ss_vbemin_q6 MIN mfq_vbe_q6 from=2e-08 to=4e-08
let mfq_ic_q6 = i(vic_q6)
meas tran mf_su_icmax_q6 MAX mfq_ic_q6 from=0.0 to=2e-08
meas tran mf_su_icmin_q6 MIN mfq_ic_q6 from=0.0 to=2e-08
meas tran mf_ss_icmax_q6 MAX mfq_ic_q6 from=2e-08 to=4e-08
meas tran mf_ss_icmin_q6 MIN mfq_ic_q6 from=2e-08 to=4e-08
meas tran mf_su_sinkmin_tail MIN v(tail) from=0.0 to=2e-08
meas tran mf_ss_sinkmin_tail MIN v(tail) from=2e-08 to=4e-08
print mf_su_vcemax_q1
print mf_su_vcemin_q1
print mf_ss_vcemax_q1
print mf_ss_vcemin_q1
print mf_su_vbemax_q1
print mf_su_vbemin_q1
print mf_ss_vbemax_q1
print mf_ss_vbemin_q1
print mf_su_icmax_q1
print mf_su_icmin_q1
print mf_ss_icmax_q1
print mf_ss_icmin_q1
print mf_su_vcemax_q2
print mf_su_vcemin_q2
print mf_ss_vcemax_q2
print mf_ss_vcemin_q2
print mf_su_vbemax_q2
print mf_su_vbemin_q2
print mf_ss_vbemax_q2
print mf_ss_vbemin_q2
print mf_su_icmax_q2
print mf_su_icmin_q2
print mf_ss_icmax_q2
print mf_ss_icmin_q2
print mf_su_vcemax_q3
print mf_su_vcemin_q3
print mf_ss_vcemax_q3
print mf_ss_vcemin_q3
print mf_su_vbemax_q3
print mf_su_vbemin_q3
print mf_ss_vbemax_q3
print mf_ss_vbemin_q3
print mf_su_icmax_q3
print mf_su_icmin_q3
print mf_ss_icmax_q3
print mf_ss_icmin_q3
print mf_su_vcemax_q4
print mf_su_vcemin_q4
print mf_ss_vcemax_q4
print mf_ss_vcemin_q4
print mf_su_vbemax_q4
print mf_su_vbemin_q4
print mf_ss_vbemax_q4
print mf_ss_vbemin_q4
print mf_su_icmax_q4
print mf_su_icmin_q4
print mf_ss_icmax_q4
print mf_ss_icmin_q4
print mf_su_vcemax_q5
print mf_su_vcemin_q5
print mf_ss_vcemax_q5
print mf_ss_vcemin_q5
print mf_su_vbemax_q5
print mf_su_vbemin_q5
print mf_ss_vbemax_q5
print mf_ss_vbemin_q5
print mf_su_icmax_q5
print mf_su_icmin_q5
print mf_ss_icmax_q5
print mf_ss_icmin_q5
print mf_su_vcemax_q6
print mf_su_vcemin_q6
print mf_ss_vcemax_q6
print mf_ss_vcemin_q6
print mf_su_vbemax_q6
print mf_su_vbemin_q6
print mf_ss_vbemax_q6
print mf_ss_vbemin_q6
print mf_su_icmax_q6
print mf_su_icmin_q6
print mf_ss_icmax_q6
print mf_ss_icmin_q6
print mf_su_sinkmin_tail
print mf_ss_sinkmin_tail
linearize
let mf_l = length(time)
let mfw = (time ge 1.99995e-08) * (time lt 3.99995e-08)
let mf_n = mean(mfw) * mf_l
let mfs = mf_l / mf_n
let mf_prail = mean(v(vdd) * (0 - i(vdd)) * mfw) * mfs
let mfph = 2 * pi * 16700000000.0 * (time - 2e-08)
let mf_lodiff_re = 2 * mean((v(lo_p)-v(lo_n)) * mfw * cos(mfph)) * mfs
let mf_lodiff_im = 2 * mean((v(lo_p)-v(lo_n)) * mfw * sin(mfph)) * mfs
let mfph = 2 * pi * 1000000000.0 * (time - 2e-08)
let mf_if_re = 2 * mean((v(if_out)) * mfw * cos(mfph)) * mfs
let mf_if_im = 2 * mean((v(if_out)) * mfw * sin(mfph)) * mfs
let mfph = 2 * pi * 16700000000.0 * (time - 2e-08)
let mf_loif_re = 2 * mean((v(if_out)) * mfw * cos(mfph)) * mfs
let mf_loif_im = 2 * mean((v(if_out)) * mfw * sin(mfph)) * mfs
let mfph = 2 * pi * 16700000000.0 * (time - 2e-08)
let mf_lorf_re = 2 * mean((v(rf_port)) * mfw * cos(mfph)) * mfs
let mf_lorf_im = 2 * mean((v(rf_port)) * mfw * sin(mfph)) * mfs
let mfph = 2 * pi * 950000000.0 * (time - 2e-08)
let mf_flifa_re = 2 * mean((v(if_out)) * mfw * cos(mfph)) * mfs
let mf_flifa_im = 2 * mean((v(if_out)) * mfw * sin(mfph)) * mfs
let mfph = 2 * pi * 1050000000.0 * (time - 2e-08)
let mf_flifb_re = 2 * mean((v(if_out)) * mfw * cos(mfph)) * mfs
let mf_flifb_im = 2 * mean((v(if_out)) * mfw * sin(mfph)) * mfs
let mfph = 2 * pi * 16750000000.0 * (time - 2e-08)
let mf_fllorf_re = 2 * mean((v(rf_port)) * mfw * cos(mfph)) * mfs
let mf_fllorf_im = 2 * mean((v(rf_port)) * mfw * sin(mfph)) * mfs
let mfph = 2 * pi * 16750000000.0 * (time - 2e-08)
let mf_flloif_re = 2 * mean((v(if_out)) * mfw * cos(mfph)) * mfs
let mf_flloif_im = 2 * mean((v(if_out)) * mfw * sin(mfph)) * mfs
print mf_l
print mf_n
print mf_prail
print mf_lodiff_re
print mf_lodiff_im
print mf_if_re
print mf_if_im
print mf_loif_re
print mf_loif_im
print mf_lorf_re
print mf_lorf_im
print mf_flifa_re
print mf_flifa_im
print mf_flifb_re
print mf_flifb_im
print mf_fllorf_re
print mf_fllorf_im
print mf_flloif_re
print mf_flloif_im
destroy all
echo "MFEND ls_f17p70_m21_rf66"
echo "MFRUN ls_f17p70_m18_rf60"
alterparam f1 = 17700000000.0
alterparam f2 = 17700000000.0
alterparam flo = 16700000000.0
alterparam vrf1 = 0.0006324555320336759
alterparam vrf2 = 0.0
alterparam vlo = 0.11260171197494694
reset
op
let mf_dcirail = 0 - i(vdd)
let mf_dc_vce_q1 = v(c_q1)-v(e_q1)
let mf_dc_vbe_q1 = v(b_q1)-v(e_q1)
let mf_dc_ic_q1 = i(vic_q1)
let mf_dc_vce_q2 = v(c_q2)-v(e_q2)
let mf_dc_vbe_q2 = v(b_q2)-v(e_q2)
let mf_dc_ic_q2 = i(vic_q2)
let mf_dc_vce_q3 = v(c_q3)-v(x1)
let mf_dc_vbe_q3 = v(lo_p)-v(x1)
let mf_dc_ic_q3 = i(vic_q3)
let mf_dc_vce_q4 = v(c_q4)-v(x1)
let mf_dc_vbe_q4 = v(lo_n)-v(x1)
let mf_dc_ic_q4 = i(vic_q4)
let mf_dc_vce_q5 = v(c_q5)-v(x2)
let mf_dc_vbe_q5 = v(lo_p)-v(x2)
let mf_dc_ic_q5 = i(vic_q5)
let mf_dc_vce_q6 = v(c_q6)-v(x2)
let mf_dc_vbe_q6 = v(lo_n)-v(x2)
let mf_dc_ic_q6 = i(vic_q6)
let mf_dc_sink_tail = v(tail)
print mf_dcirail
print mf_dc_vce_q1
print mf_dc_vbe_q1
print mf_dc_ic_q1
print mf_dc_vce_q2
print mf_dc_vbe_q2
print mf_dc_ic_q2
print mf_dc_vce_q3
print mf_dc_vbe_q3
print mf_dc_ic_q3
print mf_dc_vce_q4
print mf_dc_vbe_q4
print mf_dc_ic_q4
print mf_dc_vce_q5
print mf_dc_vbe_q5
print mf_dc_ic_q5
print mf_dc_vce_q6
print mf_dc_vbe_q6
print mf_dc_ic_q6
print mf_dc_sink_tail
tran 1e-12 4e-08 0 1e-12
let mfq_vce_q1 = v(c_q1)-v(e_q1)
meas tran mf_su_vcemax_q1 MAX mfq_vce_q1 from=0.0 to=2e-08
meas tran mf_su_vcemin_q1 MIN mfq_vce_q1 from=0.0 to=2e-08
meas tran mf_ss_vcemax_q1 MAX mfq_vce_q1 from=2e-08 to=4e-08
meas tran mf_ss_vcemin_q1 MIN mfq_vce_q1 from=2e-08 to=4e-08
let mfq_vbe_q1 = v(b_q1)-v(e_q1)
meas tran mf_su_vbemax_q1 MAX mfq_vbe_q1 from=0.0 to=2e-08
meas tran mf_su_vbemin_q1 MIN mfq_vbe_q1 from=0.0 to=2e-08
meas tran mf_ss_vbemax_q1 MAX mfq_vbe_q1 from=2e-08 to=4e-08
meas tran mf_ss_vbemin_q1 MIN mfq_vbe_q1 from=2e-08 to=4e-08
let mfq_ic_q1 = i(vic_q1)
meas tran mf_su_icmax_q1 MAX mfq_ic_q1 from=0.0 to=2e-08
meas tran mf_su_icmin_q1 MIN mfq_ic_q1 from=0.0 to=2e-08
meas tran mf_ss_icmax_q1 MAX mfq_ic_q1 from=2e-08 to=4e-08
meas tran mf_ss_icmin_q1 MIN mfq_ic_q1 from=2e-08 to=4e-08
let mfq_vce_q2 = v(c_q2)-v(e_q2)
meas tran mf_su_vcemax_q2 MAX mfq_vce_q2 from=0.0 to=2e-08
meas tran mf_su_vcemin_q2 MIN mfq_vce_q2 from=0.0 to=2e-08
meas tran mf_ss_vcemax_q2 MAX mfq_vce_q2 from=2e-08 to=4e-08
meas tran mf_ss_vcemin_q2 MIN mfq_vce_q2 from=2e-08 to=4e-08
let mfq_vbe_q2 = v(b_q2)-v(e_q2)
meas tran mf_su_vbemax_q2 MAX mfq_vbe_q2 from=0.0 to=2e-08
meas tran mf_su_vbemin_q2 MIN mfq_vbe_q2 from=0.0 to=2e-08
meas tran mf_ss_vbemax_q2 MAX mfq_vbe_q2 from=2e-08 to=4e-08
meas tran mf_ss_vbemin_q2 MIN mfq_vbe_q2 from=2e-08 to=4e-08
let mfq_ic_q2 = i(vic_q2)
meas tran mf_su_icmax_q2 MAX mfq_ic_q2 from=0.0 to=2e-08
meas tran mf_su_icmin_q2 MIN mfq_ic_q2 from=0.0 to=2e-08
meas tran mf_ss_icmax_q2 MAX mfq_ic_q2 from=2e-08 to=4e-08
meas tran mf_ss_icmin_q2 MIN mfq_ic_q2 from=2e-08 to=4e-08
let mfq_vce_q3 = v(c_q3)-v(x1)
meas tran mf_su_vcemax_q3 MAX mfq_vce_q3 from=0.0 to=2e-08
meas tran mf_su_vcemin_q3 MIN mfq_vce_q3 from=0.0 to=2e-08
meas tran mf_ss_vcemax_q3 MAX mfq_vce_q3 from=2e-08 to=4e-08
meas tran mf_ss_vcemin_q3 MIN mfq_vce_q3 from=2e-08 to=4e-08
let mfq_vbe_q3 = v(lo_p)-v(x1)
meas tran mf_su_vbemax_q3 MAX mfq_vbe_q3 from=0.0 to=2e-08
meas tran mf_su_vbemin_q3 MIN mfq_vbe_q3 from=0.0 to=2e-08
meas tran mf_ss_vbemax_q3 MAX mfq_vbe_q3 from=2e-08 to=4e-08
meas tran mf_ss_vbemin_q3 MIN mfq_vbe_q3 from=2e-08 to=4e-08
let mfq_ic_q3 = i(vic_q3)
meas tran mf_su_icmax_q3 MAX mfq_ic_q3 from=0.0 to=2e-08
meas tran mf_su_icmin_q3 MIN mfq_ic_q3 from=0.0 to=2e-08
meas tran mf_ss_icmax_q3 MAX mfq_ic_q3 from=2e-08 to=4e-08
meas tran mf_ss_icmin_q3 MIN mfq_ic_q3 from=2e-08 to=4e-08
let mfq_vce_q4 = v(c_q4)-v(x1)
meas tran mf_su_vcemax_q4 MAX mfq_vce_q4 from=0.0 to=2e-08
meas tran mf_su_vcemin_q4 MIN mfq_vce_q4 from=0.0 to=2e-08
meas tran mf_ss_vcemax_q4 MAX mfq_vce_q4 from=2e-08 to=4e-08
meas tran mf_ss_vcemin_q4 MIN mfq_vce_q4 from=2e-08 to=4e-08
let mfq_vbe_q4 = v(lo_n)-v(x1)
meas tran mf_su_vbemax_q4 MAX mfq_vbe_q4 from=0.0 to=2e-08
meas tran mf_su_vbemin_q4 MIN mfq_vbe_q4 from=0.0 to=2e-08
meas tran mf_ss_vbemax_q4 MAX mfq_vbe_q4 from=2e-08 to=4e-08
meas tran mf_ss_vbemin_q4 MIN mfq_vbe_q4 from=2e-08 to=4e-08
let mfq_ic_q4 = i(vic_q4)
meas tran mf_su_icmax_q4 MAX mfq_ic_q4 from=0.0 to=2e-08
meas tran mf_su_icmin_q4 MIN mfq_ic_q4 from=0.0 to=2e-08
meas tran mf_ss_icmax_q4 MAX mfq_ic_q4 from=2e-08 to=4e-08
meas tran mf_ss_icmin_q4 MIN mfq_ic_q4 from=2e-08 to=4e-08
let mfq_vce_q5 = v(c_q5)-v(x2)
meas tran mf_su_vcemax_q5 MAX mfq_vce_q5 from=0.0 to=2e-08
meas tran mf_su_vcemin_q5 MIN mfq_vce_q5 from=0.0 to=2e-08
meas tran mf_ss_vcemax_q5 MAX mfq_vce_q5 from=2e-08 to=4e-08
meas tran mf_ss_vcemin_q5 MIN mfq_vce_q5 from=2e-08 to=4e-08
let mfq_vbe_q5 = v(lo_p)-v(x2)
meas tran mf_su_vbemax_q5 MAX mfq_vbe_q5 from=0.0 to=2e-08
meas tran mf_su_vbemin_q5 MIN mfq_vbe_q5 from=0.0 to=2e-08
meas tran mf_ss_vbemax_q5 MAX mfq_vbe_q5 from=2e-08 to=4e-08
meas tran mf_ss_vbemin_q5 MIN mfq_vbe_q5 from=2e-08 to=4e-08
let mfq_ic_q5 = i(vic_q5)
meas tran mf_su_icmax_q5 MAX mfq_ic_q5 from=0.0 to=2e-08
meas tran mf_su_icmin_q5 MIN mfq_ic_q5 from=0.0 to=2e-08
meas tran mf_ss_icmax_q5 MAX mfq_ic_q5 from=2e-08 to=4e-08
meas tran mf_ss_icmin_q5 MIN mfq_ic_q5 from=2e-08 to=4e-08
let mfq_vce_q6 = v(c_q6)-v(x2)
meas tran mf_su_vcemax_q6 MAX mfq_vce_q6 from=0.0 to=2e-08
meas tran mf_su_vcemin_q6 MIN mfq_vce_q6 from=0.0 to=2e-08
meas tran mf_ss_vcemax_q6 MAX mfq_vce_q6 from=2e-08 to=4e-08
meas tran mf_ss_vcemin_q6 MIN mfq_vce_q6 from=2e-08 to=4e-08
let mfq_vbe_q6 = v(lo_n)-v(x2)
meas tran mf_su_vbemax_q6 MAX mfq_vbe_q6 from=0.0 to=2e-08
meas tran mf_su_vbemin_q6 MIN mfq_vbe_q6 from=0.0 to=2e-08
meas tran mf_ss_vbemax_q6 MAX mfq_vbe_q6 from=2e-08 to=4e-08
meas tran mf_ss_vbemin_q6 MIN mfq_vbe_q6 from=2e-08 to=4e-08
let mfq_ic_q6 = i(vic_q6)
meas tran mf_su_icmax_q6 MAX mfq_ic_q6 from=0.0 to=2e-08
meas tran mf_su_icmin_q6 MIN mfq_ic_q6 from=0.0 to=2e-08
meas tran mf_ss_icmax_q6 MAX mfq_ic_q6 from=2e-08 to=4e-08
meas tran mf_ss_icmin_q6 MIN mfq_ic_q6 from=2e-08 to=4e-08
meas tran mf_su_sinkmin_tail MIN v(tail) from=0.0 to=2e-08
meas tran mf_ss_sinkmin_tail MIN v(tail) from=2e-08 to=4e-08
print mf_su_vcemax_q1
print mf_su_vcemin_q1
print mf_ss_vcemax_q1
print mf_ss_vcemin_q1
print mf_su_vbemax_q1
print mf_su_vbemin_q1
print mf_ss_vbemax_q1
print mf_ss_vbemin_q1
print mf_su_icmax_q1
print mf_su_icmin_q1
print mf_ss_icmax_q1
print mf_ss_icmin_q1
print mf_su_vcemax_q2
print mf_su_vcemin_q2
print mf_ss_vcemax_q2
print mf_ss_vcemin_q2
print mf_su_vbemax_q2
print mf_su_vbemin_q2
print mf_ss_vbemax_q2
print mf_ss_vbemin_q2
print mf_su_icmax_q2
print mf_su_icmin_q2
print mf_ss_icmax_q2
print mf_ss_icmin_q2
print mf_su_vcemax_q3
print mf_su_vcemin_q3
print mf_ss_vcemax_q3
print mf_ss_vcemin_q3
print mf_su_vbemax_q3
print mf_su_vbemin_q3
print mf_ss_vbemax_q3
print mf_ss_vbemin_q3
print mf_su_icmax_q3
print mf_su_icmin_q3
print mf_ss_icmax_q3
print mf_ss_icmin_q3
print mf_su_vcemax_q4
print mf_su_vcemin_q4
print mf_ss_vcemax_q4
print mf_ss_vcemin_q4
print mf_su_vbemax_q4
print mf_su_vbemin_q4
print mf_ss_vbemax_q4
print mf_ss_vbemin_q4
print mf_su_icmax_q4
print mf_su_icmin_q4
print mf_ss_icmax_q4
print mf_ss_icmin_q4
print mf_su_vcemax_q5
print mf_su_vcemin_q5
print mf_ss_vcemax_q5
print mf_ss_vcemin_q5
print mf_su_vbemax_q5
print mf_su_vbemin_q5
print mf_ss_vbemax_q5
print mf_ss_vbemin_q5
print mf_su_icmax_q5
print mf_su_icmin_q5
print mf_ss_icmax_q5
print mf_ss_icmin_q5
print mf_su_vcemax_q6
print mf_su_vcemin_q6
print mf_ss_vcemax_q6
print mf_ss_vcemin_q6
print mf_su_vbemax_q6
print mf_su_vbemin_q6
print mf_ss_vbemax_q6
print mf_ss_vbemin_q6
print mf_su_icmax_q6
print mf_su_icmin_q6
print mf_ss_icmax_q6
print mf_ss_icmin_q6
print mf_su_sinkmin_tail
print mf_ss_sinkmin_tail
linearize
let mf_l = length(time)
let mfw = (time ge 1.99995e-08) * (time lt 3.99995e-08)
let mf_n = mean(mfw) * mf_l
let mfs = mf_l / mf_n
let mf_prail = mean(v(vdd) * (0 - i(vdd)) * mfw) * mfs
let mfph = 2 * pi * 16700000000.0 * (time - 2e-08)
let mf_lodiff_re = 2 * mean((v(lo_p)-v(lo_n)) * mfw * cos(mfph)) * mfs
let mf_lodiff_im = 2 * mean((v(lo_p)-v(lo_n)) * mfw * sin(mfph)) * mfs
let mfph = 2 * pi * 1000000000.0 * (time - 2e-08)
let mf_if_re = 2 * mean((v(if_out)) * mfw * cos(mfph)) * mfs
let mf_if_im = 2 * mean((v(if_out)) * mfw * sin(mfph)) * mfs
let mfph = 2 * pi * 16700000000.0 * (time - 2e-08)
let mf_loif_re = 2 * mean((v(if_out)) * mfw * cos(mfph)) * mfs
let mf_loif_im = 2 * mean((v(if_out)) * mfw * sin(mfph)) * mfs
let mfph = 2 * pi * 16700000000.0 * (time - 2e-08)
let mf_lorf_re = 2 * mean((v(rf_port)) * mfw * cos(mfph)) * mfs
let mf_lorf_im = 2 * mean((v(rf_port)) * mfw * sin(mfph)) * mfs
let mfph = 2 * pi * 950000000.0 * (time - 2e-08)
let mf_flifa_re = 2 * mean((v(if_out)) * mfw * cos(mfph)) * mfs
let mf_flifa_im = 2 * mean((v(if_out)) * mfw * sin(mfph)) * mfs
let mfph = 2 * pi * 1050000000.0 * (time - 2e-08)
let mf_flifb_re = 2 * mean((v(if_out)) * mfw * cos(mfph)) * mfs
let mf_flifb_im = 2 * mean((v(if_out)) * mfw * sin(mfph)) * mfs
let mfph = 2 * pi * 16750000000.0 * (time - 2e-08)
let mf_fllorf_re = 2 * mean((v(rf_port)) * mfw * cos(mfph)) * mfs
let mf_fllorf_im = 2 * mean((v(rf_port)) * mfw * sin(mfph)) * mfs
let mfph = 2 * pi * 16750000000.0 * (time - 2e-08)
let mf_flloif_re = 2 * mean((v(if_out)) * mfw * cos(mfph)) * mfs
let mf_flloif_im = 2 * mean((v(if_out)) * mfw * sin(mfph)) * mfs
print mf_l
print mf_n
print mf_prail
print mf_lodiff_re
print mf_lodiff_im
print mf_if_re
print mf_if_im
print mf_loif_re
print mf_loif_im
print mf_lorf_re
print mf_lorf_im
print mf_flifa_re
print mf_flifa_im
print mf_flifb_re
print mf_flifb_im
print mf_fllorf_re
print mf_fllorf_im
print mf_flloif_re
print mf_flloif_im
destroy all
echo "MFEND ls_f17p70_m18_rf60"
echo "MFRUN ls_f17p70_m18_rf66"
alterparam f1 = 17700000000.0
alterparam f2 = 17700000000.0
alterparam flo = 16700000000.0
alterparam vrf1 = 0.00031697863849222284
alterparam vrf2 = 0.0
alterparam vlo = 0.11260171197494694
reset
op
let mf_dcirail = 0 - i(vdd)
let mf_dc_vce_q1 = v(c_q1)-v(e_q1)
let mf_dc_vbe_q1 = v(b_q1)-v(e_q1)
let mf_dc_ic_q1 = i(vic_q1)
let mf_dc_vce_q2 = v(c_q2)-v(e_q2)
let mf_dc_vbe_q2 = v(b_q2)-v(e_q2)
let mf_dc_ic_q2 = i(vic_q2)
let mf_dc_vce_q3 = v(c_q3)-v(x1)
let mf_dc_vbe_q3 = v(lo_p)-v(x1)
let mf_dc_ic_q3 = i(vic_q3)
let mf_dc_vce_q4 = v(c_q4)-v(x1)
let mf_dc_vbe_q4 = v(lo_n)-v(x1)
let mf_dc_ic_q4 = i(vic_q4)
let mf_dc_vce_q5 = v(c_q5)-v(x2)
let mf_dc_vbe_q5 = v(lo_p)-v(x2)
let mf_dc_ic_q5 = i(vic_q5)
let mf_dc_vce_q6 = v(c_q6)-v(x2)
let mf_dc_vbe_q6 = v(lo_n)-v(x2)
let mf_dc_ic_q6 = i(vic_q6)
let mf_dc_sink_tail = v(tail)
print mf_dcirail
print mf_dc_vce_q1
print mf_dc_vbe_q1
print mf_dc_ic_q1
print mf_dc_vce_q2
print mf_dc_vbe_q2
print mf_dc_ic_q2
print mf_dc_vce_q3
print mf_dc_vbe_q3
print mf_dc_ic_q3
print mf_dc_vce_q4
print mf_dc_vbe_q4
print mf_dc_ic_q4
print mf_dc_vce_q5
print mf_dc_vbe_q5
print mf_dc_ic_q5
print mf_dc_vce_q6
print mf_dc_vbe_q6
print mf_dc_ic_q6
print mf_dc_sink_tail
tran 1e-12 4e-08 0 1e-12
let mfq_vce_q1 = v(c_q1)-v(e_q1)
meas tran mf_su_vcemax_q1 MAX mfq_vce_q1 from=0.0 to=2e-08
meas tran mf_su_vcemin_q1 MIN mfq_vce_q1 from=0.0 to=2e-08
meas tran mf_ss_vcemax_q1 MAX mfq_vce_q1 from=2e-08 to=4e-08
meas tran mf_ss_vcemin_q1 MIN mfq_vce_q1 from=2e-08 to=4e-08
let mfq_vbe_q1 = v(b_q1)-v(e_q1)
meas tran mf_su_vbemax_q1 MAX mfq_vbe_q1 from=0.0 to=2e-08
meas tran mf_su_vbemin_q1 MIN mfq_vbe_q1 from=0.0 to=2e-08
meas tran mf_ss_vbemax_q1 MAX mfq_vbe_q1 from=2e-08 to=4e-08
meas tran mf_ss_vbemin_q1 MIN mfq_vbe_q1 from=2e-08 to=4e-08
let mfq_ic_q1 = i(vic_q1)
meas tran mf_su_icmax_q1 MAX mfq_ic_q1 from=0.0 to=2e-08
meas tran mf_su_icmin_q1 MIN mfq_ic_q1 from=0.0 to=2e-08
meas tran mf_ss_icmax_q1 MAX mfq_ic_q1 from=2e-08 to=4e-08
meas tran mf_ss_icmin_q1 MIN mfq_ic_q1 from=2e-08 to=4e-08
let mfq_vce_q2 = v(c_q2)-v(e_q2)
meas tran mf_su_vcemax_q2 MAX mfq_vce_q2 from=0.0 to=2e-08
meas tran mf_su_vcemin_q2 MIN mfq_vce_q2 from=0.0 to=2e-08
meas tran mf_ss_vcemax_q2 MAX mfq_vce_q2 from=2e-08 to=4e-08
meas tran mf_ss_vcemin_q2 MIN mfq_vce_q2 from=2e-08 to=4e-08
let mfq_vbe_q2 = v(b_q2)-v(e_q2)
meas tran mf_su_vbemax_q2 MAX mfq_vbe_q2 from=0.0 to=2e-08
meas tran mf_su_vbemin_q2 MIN mfq_vbe_q2 from=0.0 to=2e-08
meas tran mf_ss_vbemax_q2 MAX mfq_vbe_q2 from=2e-08 to=4e-08
meas tran mf_ss_vbemin_q2 MIN mfq_vbe_q2 from=2e-08 to=4e-08
let mfq_ic_q2 = i(vic_q2)
meas tran mf_su_icmax_q2 MAX mfq_ic_q2 from=0.0 to=2e-08
meas tran mf_su_icmin_q2 MIN mfq_ic_q2 from=0.0 to=2e-08
meas tran mf_ss_icmax_q2 MAX mfq_ic_q2 from=2e-08 to=4e-08
meas tran mf_ss_icmin_q2 MIN mfq_ic_q2 from=2e-08 to=4e-08
let mfq_vce_q3 = v(c_q3)-v(x1)
meas tran mf_su_vcemax_q3 MAX mfq_vce_q3 from=0.0 to=2e-08
meas tran mf_su_vcemin_q3 MIN mfq_vce_q3 from=0.0 to=2e-08
meas tran mf_ss_vcemax_q3 MAX mfq_vce_q3 from=2e-08 to=4e-08
meas tran mf_ss_vcemin_q3 MIN mfq_vce_q3 from=2e-08 to=4e-08
let mfq_vbe_q3 = v(lo_p)-v(x1)
meas tran mf_su_vbemax_q3 MAX mfq_vbe_q3 from=0.0 to=2e-08
meas tran mf_su_vbemin_q3 MIN mfq_vbe_q3 from=0.0 to=2e-08
meas tran mf_ss_vbemax_q3 MAX mfq_vbe_q3 from=2e-08 to=4e-08
meas tran mf_ss_vbemin_q3 MIN mfq_vbe_q3 from=2e-08 to=4e-08
let mfq_ic_q3 = i(vic_q3)
meas tran mf_su_icmax_q3 MAX mfq_ic_q3 from=0.0 to=2e-08
meas tran mf_su_icmin_q3 MIN mfq_ic_q3 from=0.0 to=2e-08
meas tran mf_ss_icmax_q3 MAX mfq_ic_q3 from=2e-08 to=4e-08
meas tran mf_ss_icmin_q3 MIN mfq_ic_q3 from=2e-08 to=4e-08
let mfq_vce_q4 = v(c_q4)-v(x1)
meas tran mf_su_vcemax_q4 MAX mfq_vce_q4 from=0.0 to=2e-08
meas tran mf_su_vcemin_q4 MIN mfq_vce_q4 from=0.0 to=2e-08
meas tran mf_ss_vcemax_q4 MAX mfq_vce_q4 from=2e-08 to=4e-08
meas tran mf_ss_vcemin_q4 MIN mfq_vce_q4 from=2e-08 to=4e-08
let mfq_vbe_q4 = v(lo_n)-v(x1)
meas tran mf_su_vbemax_q4 MAX mfq_vbe_q4 from=0.0 to=2e-08
meas tran mf_su_vbemin_q4 MIN mfq_vbe_q4 from=0.0 to=2e-08
meas tran mf_ss_vbemax_q4 MAX mfq_vbe_q4 from=2e-08 to=4e-08
meas tran mf_ss_vbemin_q4 MIN mfq_vbe_q4 from=2e-08 to=4e-08
let mfq_ic_q4 = i(vic_q4)
meas tran mf_su_icmax_q4 MAX mfq_ic_q4 from=0.0 to=2e-08
meas tran mf_su_icmin_q4 MIN mfq_ic_q4 from=0.0 to=2e-08
meas tran mf_ss_icmax_q4 MAX mfq_ic_q4 from=2e-08 to=4e-08
meas tran mf_ss_icmin_q4 MIN mfq_ic_q4 from=2e-08 to=4e-08
let mfq_vce_q5 = v(c_q5)-v(x2)
meas tran mf_su_vcemax_q5 MAX mfq_vce_q5 from=0.0 to=2e-08
meas tran mf_su_vcemin_q5 MIN mfq_vce_q5 from=0.0 to=2e-08
meas tran mf_ss_vcemax_q5 MAX mfq_vce_q5 from=2e-08 to=4e-08
meas tran mf_ss_vcemin_q5 MIN mfq_vce_q5 from=2e-08 to=4e-08
let mfq_vbe_q5 = v(lo_p)-v(x2)
meas tran mf_su_vbemax_q5 MAX mfq_vbe_q5 from=0.0 to=2e-08
meas tran mf_su_vbemin_q5 MIN mfq_vbe_q5 from=0.0 to=2e-08
meas tran mf_ss_vbemax_q5 MAX mfq_vbe_q5 from=2e-08 to=4e-08
meas tran mf_ss_vbemin_q5 MIN mfq_vbe_q5 from=2e-08 to=4e-08
let mfq_ic_q5 = i(vic_q5)
meas tran mf_su_icmax_q5 MAX mfq_ic_q5 from=0.0 to=2e-08
meas tran mf_su_icmin_q5 MIN mfq_ic_q5 from=0.0 to=2e-08
meas tran mf_ss_icmax_q5 MAX mfq_ic_q5 from=2e-08 to=4e-08
meas tran mf_ss_icmin_q5 MIN mfq_ic_q5 from=2e-08 to=4e-08
let mfq_vce_q6 = v(c_q6)-v(x2)
meas tran mf_su_vcemax_q6 MAX mfq_vce_q6 from=0.0 to=2e-08
meas tran mf_su_vcemin_q6 MIN mfq_vce_q6 from=0.0 to=2e-08
meas tran mf_ss_vcemax_q6 MAX mfq_vce_q6 from=2e-08 to=4e-08
meas tran mf_ss_vcemin_q6 MIN mfq_vce_q6 from=2e-08 to=4e-08
let mfq_vbe_q6 = v(lo_n)-v(x2)
meas tran mf_su_vbemax_q6 MAX mfq_vbe_q6 from=0.0 to=2e-08
meas tran mf_su_vbemin_q6 MIN mfq_vbe_q6 from=0.0 to=2e-08
meas tran mf_ss_vbemax_q6 MAX mfq_vbe_q6 from=2e-08 to=4e-08
meas tran mf_ss_vbemin_q6 MIN mfq_vbe_q6 from=2e-08 to=4e-08
let mfq_ic_q6 = i(vic_q6)
meas tran mf_su_icmax_q6 MAX mfq_ic_q6 from=0.0 to=2e-08
meas tran mf_su_icmin_q6 MIN mfq_ic_q6 from=0.0 to=2e-08
meas tran mf_ss_icmax_q6 MAX mfq_ic_q6 from=2e-08 to=4e-08
meas tran mf_ss_icmin_q6 MIN mfq_ic_q6 from=2e-08 to=4e-08
meas tran mf_su_sinkmin_tail MIN v(tail) from=0.0 to=2e-08
meas tran mf_ss_sinkmin_tail MIN v(tail) from=2e-08 to=4e-08
print mf_su_vcemax_q1
print mf_su_vcemin_q1
print mf_ss_vcemax_q1
print mf_ss_vcemin_q1
print mf_su_vbemax_q1
print mf_su_vbemin_q1
print mf_ss_vbemax_q1
print mf_ss_vbemin_q1
print mf_su_icmax_q1
print mf_su_icmin_q1
print mf_ss_icmax_q1
print mf_ss_icmin_q1
print mf_su_vcemax_q2
print mf_su_vcemin_q2
print mf_ss_vcemax_q2
print mf_ss_vcemin_q2
print mf_su_vbemax_q2
print mf_su_vbemin_q2
print mf_ss_vbemax_q2
print mf_ss_vbemin_q2
print mf_su_icmax_q2
print mf_su_icmin_q2
print mf_ss_icmax_q2
print mf_ss_icmin_q2
print mf_su_vcemax_q3
print mf_su_vcemin_q3
print mf_ss_vcemax_q3
print mf_ss_vcemin_q3
print mf_su_vbemax_q3
print mf_su_vbemin_q3
print mf_ss_vbemax_q3
print mf_ss_vbemin_q3
print mf_su_icmax_q3
print mf_su_icmin_q3
print mf_ss_icmax_q3
print mf_ss_icmin_q3
print mf_su_vcemax_q4
print mf_su_vcemin_q4
print mf_ss_vcemax_q4
print mf_ss_vcemin_q4
print mf_su_vbemax_q4
print mf_su_vbemin_q4
print mf_ss_vbemax_q4
print mf_ss_vbemin_q4
print mf_su_icmax_q4
print mf_su_icmin_q4
print mf_ss_icmax_q4
print mf_ss_icmin_q4
print mf_su_vcemax_q5
print mf_su_vcemin_q5
print mf_ss_vcemax_q5
print mf_ss_vcemin_q5
print mf_su_vbemax_q5
print mf_su_vbemin_q5
print mf_ss_vbemax_q5
print mf_ss_vbemin_q5
print mf_su_icmax_q5
print mf_su_icmin_q5
print mf_ss_icmax_q5
print mf_ss_icmin_q5
print mf_su_vcemax_q6
print mf_su_vcemin_q6
print mf_ss_vcemax_q6
print mf_ss_vcemin_q6
print mf_su_vbemax_q6
print mf_su_vbemin_q6
print mf_ss_vbemax_q6
print mf_ss_vbemin_q6
print mf_su_icmax_q6
print mf_su_icmin_q6
print mf_ss_icmax_q6
print mf_ss_icmin_q6
print mf_su_sinkmin_tail
print mf_ss_sinkmin_tail
linearize
let mf_l = length(time)
let mfw = (time ge 1.99995e-08) * (time lt 3.99995e-08)
let mf_n = mean(mfw) * mf_l
let mfs = mf_l / mf_n
let mf_prail = mean(v(vdd) * (0 - i(vdd)) * mfw) * mfs
let mfph = 2 * pi * 16700000000.0 * (time - 2e-08)
let mf_lodiff_re = 2 * mean((v(lo_p)-v(lo_n)) * mfw * cos(mfph)) * mfs
let mf_lodiff_im = 2 * mean((v(lo_p)-v(lo_n)) * mfw * sin(mfph)) * mfs
let mfph = 2 * pi * 1000000000.0 * (time - 2e-08)
let mf_if_re = 2 * mean((v(if_out)) * mfw * cos(mfph)) * mfs
let mf_if_im = 2 * mean((v(if_out)) * mfw * sin(mfph)) * mfs
let mfph = 2 * pi * 16700000000.0 * (time - 2e-08)
let mf_loif_re = 2 * mean((v(if_out)) * mfw * cos(mfph)) * mfs
let mf_loif_im = 2 * mean((v(if_out)) * mfw * sin(mfph)) * mfs
let mfph = 2 * pi * 16700000000.0 * (time - 2e-08)
let mf_lorf_re = 2 * mean((v(rf_port)) * mfw * cos(mfph)) * mfs
let mf_lorf_im = 2 * mean((v(rf_port)) * mfw * sin(mfph)) * mfs
let mfph = 2 * pi * 950000000.0 * (time - 2e-08)
let mf_flifa_re = 2 * mean((v(if_out)) * mfw * cos(mfph)) * mfs
let mf_flifa_im = 2 * mean((v(if_out)) * mfw * sin(mfph)) * mfs
let mfph = 2 * pi * 1050000000.0 * (time - 2e-08)
let mf_flifb_re = 2 * mean((v(if_out)) * mfw * cos(mfph)) * mfs
let mf_flifb_im = 2 * mean((v(if_out)) * mfw * sin(mfph)) * mfs
let mfph = 2 * pi * 16750000000.0 * (time - 2e-08)
let mf_fllorf_re = 2 * mean((v(rf_port)) * mfw * cos(mfph)) * mfs
let mf_fllorf_im = 2 * mean((v(rf_port)) * mfw * sin(mfph)) * mfs
let mfph = 2 * pi * 16750000000.0 * (time - 2e-08)
let mf_flloif_re = 2 * mean((v(if_out)) * mfw * cos(mfph)) * mfs
let mf_flloif_im = 2 * mean((v(if_out)) * mfw * sin(mfph)) * mfs
print mf_l
print mf_n
print mf_prail
print mf_lodiff_re
print mf_lodiff_im
print mf_if_re
print mf_if_im
print mf_loif_re
print mf_loif_im
print mf_lorf_re
print mf_lorf_im
print mf_flifa_re
print mf_flifa_im
print mf_flifb_re
print mf_flifb_im
print mf_fllorf_re
print mf_fllorf_im
print mf_flloif_re
print mf_flloif_im
destroy all
echo "MFEND ls_f17p70_m18_rf66"
echo "MFRUN ls_f17p70_m15_rf60"
alterparam f1 = 17700000000.0
alterparam f2 = 17700000000.0
alterparam flo = 16700000000.0
alterparam vrf1 = 0.0006324555320336759
alterparam vrf2 = 0.0
alterparam vlo = 0.15905414575341015
reset
op
let mf_dcirail = 0 - i(vdd)
let mf_dc_vce_q1 = v(c_q1)-v(e_q1)
let mf_dc_vbe_q1 = v(b_q1)-v(e_q1)
let mf_dc_ic_q1 = i(vic_q1)
let mf_dc_vce_q2 = v(c_q2)-v(e_q2)
let mf_dc_vbe_q2 = v(b_q2)-v(e_q2)
let mf_dc_ic_q2 = i(vic_q2)
let mf_dc_vce_q3 = v(c_q3)-v(x1)
let mf_dc_vbe_q3 = v(lo_p)-v(x1)
let mf_dc_ic_q3 = i(vic_q3)
let mf_dc_vce_q4 = v(c_q4)-v(x1)
let mf_dc_vbe_q4 = v(lo_n)-v(x1)
let mf_dc_ic_q4 = i(vic_q4)
let mf_dc_vce_q5 = v(c_q5)-v(x2)
let mf_dc_vbe_q5 = v(lo_p)-v(x2)
let mf_dc_ic_q5 = i(vic_q5)
let mf_dc_vce_q6 = v(c_q6)-v(x2)
let mf_dc_vbe_q6 = v(lo_n)-v(x2)
let mf_dc_ic_q6 = i(vic_q6)
let mf_dc_sink_tail = v(tail)
print mf_dcirail
print mf_dc_vce_q1
print mf_dc_vbe_q1
print mf_dc_ic_q1
print mf_dc_vce_q2
print mf_dc_vbe_q2
print mf_dc_ic_q2
print mf_dc_vce_q3
print mf_dc_vbe_q3
print mf_dc_ic_q3
print mf_dc_vce_q4
print mf_dc_vbe_q4
print mf_dc_ic_q4
print mf_dc_vce_q5
print mf_dc_vbe_q5
print mf_dc_ic_q5
print mf_dc_vce_q6
print mf_dc_vbe_q6
print mf_dc_ic_q6
print mf_dc_sink_tail
tran 1e-12 4e-08 0 1e-12
let mfq_vce_q1 = v(c_q1)-v(e_q1)
meas tran mf_su_vcemax_q1 MAX mfq_vce_q1 from=0.0 to=2e-08
meas tran mf_su_vcemin_q1 MIN mfq_vce_q1 from=0.0 to=2e-08
meas tran mf_ss_vcemax_q1 MAX mfq_vce_q1 from=2e-08 to=4e-08
meas tran mf_ss_vcemin_q1 MIN mfq_vce_q1 from=2e-08 to=4e-08
let mfq_vbe_q1 = v(b_q1)-v(e_q1)
meas tran mf_su_vbemax_q1 MAX mfq_vbe_q1 from=0.0 to=2e-08
meas tran mf_su_vbemin_q1 MIN mfq_vbe_q1 from=0.0 to=2e-08
meas tran mf_ss_vbemax_q1 MAX mfq_vbe_q1 from=2e-08 to=4e-08
meas tran mf_ss_vbemin_q1 MIN mfq_vbe_q1 from=2e-08 to=4e-08
let mfq_ic_q1 = i(vic_q1)
meas tran mf_su_icmax_q1 MAX mfq_ic_q1 from=0.0 to=2e-08
meas tran mf_su_icmin_q1 MIN mfq_ic_q1 from=0.0 to=2e-08
meas tran mf_ss_icmax_q1 MAX mfq_ic_q1 from=2e-08 to=4e-08
meas tran mf_ss_icmin_q1 MIN mfq_ic_q1 from=2e-08 to=4e-08
let mfq_vce_q2 = v(c_q2)-v(e_q2)
meas tran mf_su_vcemax_q2 MAX mfq_vce_q2 from=0.0 to=2e-08
meas tran mf_su_vcemin_q2 MIN mfq_vce_q2 from=0.0 to=2e-08
meas tran mf_ss_vcemax_q2 MAX mfq_vce_q2 from=2e-08 to=4e-08
meas tran mf_ss_vcemin_q2 MIN mfq_vce_q2 from=2e-08 to=4e-08
let mfq_vbe_q2 = v(b_q2)-v(e_q2)
meas tran mf_su_vbemax_q2 MAX mfq_vbe_q2 from=0.0 to=2e-08
meas tran mf_su_vbemin_q2 MIN mfq_vbe_q2 from=0.0 to=2e-08
meas tran mf_ss_vbemax_q2 MAX mfq_vbe_q2 from=2e-08 to=4e-08
meas tran mf_ss_vbemin_q2 MIN mfq_vbe_q2 from=2e-08 to=4e-08
let mfq_ic_q2 = i(vic_q2)
meas tran mf_su_icmax_q2 MAX mfq_ic_q2 from=0.0 to=2e-08
meas tran mf_su_icmin_q2 MIN mfq_ic_q2 from=0.0 to=2e-08
meas tran mf_ss_icmax_q2 MAX mfq_ic_q2 from=2e-08 to=4e-08
meas tran mf_ss_icmin_q2 MIN mfq_ic_q2 from=2e-08 to=4e-08
let mfq_vce_q3 = v(c_q3)-v(x1)
meas tran mf_su_vcemax_q3 MAX mfq_vce_q3 from=0.0 to=2e-08
meas tran mf_su_vcemin_q3 MIN mfq_vce_q3 from=0.0 to=2e-08
meas tran mf_ss_vcemax_q3 MAX mfq_vce_q3 from=2e-08 to=4e-08
meas tran mf_ss_vcemin_q3 MIN mfq_vce_q3 from=2e-08 to=4e-08
let mfq_vbe_q3 = v(lo_p)-v(x1)
meas tran mf_su_vbemax_q3 MAX mfq_vbe_q3 from=0.0 to=2e-08
meas tran mf_su_vbemin_q3 MIN mfq_vbe_q3 from=0.0 to=2e-08
meas tran mf_ss_vbemax_q3 MAX mfq_vbe_q3 from=2e-08 to=4e-08
meas tran mf_ss_vbemin_q3 MIN mfq_vbe_q3 from=2e-08 to=4e-08
let mfq_ic_q3 = i(vic_q3)
meas tran mf_su_icmax_q3 MAX mfq_ic_q3 from=0.0 to=2e-08
meas tran mf_su_icmin_q3 MIN mfq_ic_q3 from=0.0 to=2e-08
meas tran mf_ss_icmax_q3 MAX mfq_ic_q3 from=2e-08 to=4e-08
meas tran mf_ss_icmin_q3 MIN mfq_ic_q3 from=2e-08 to=4e-08
let mfq_vce_q4 = v(c_q4)-v(x1)
meas tran mf_su_vcemax_q4 MAX mfq_vce_q4 from=0.0 to=2e-08
meas tran mf_su_vcemin_q4 MIN mfq_vce_q4 from=0.0 to=2e-08
meas tran mf_ss_vcemax_q4 MAX mfq_vce_q4 from=2e-08 to=4e-08
meas tran mf_ss_vcemin_q4 MIN mfq_vce_q4 from=2e-08 to=4e-08
let mfq_vbe_q4 = v(lo_n)-v(x1)
meas tran mf_su_vbemax_q4 MAX mfq_vbe_q4 from=0.0 to=2e-08
meas tran mf_su_vbemin_q4 MIN mfq_vbe_q4 from=0.0 to=2e-08
meas tran mf_ss_vbemax_q4 MAX mfq_vbe_q4 from=2e-08 to=4e-08
meas tran mf_ss_vbemin_q4 MIN mfq_vbe_q4 from=2e-08 to=4e-08
let mfq_ic_q4 = i(vic_q4)
meas tran mf_su_icmax_q4 MAX mfq_ic_q4 from=0.0 to=2e-08
meas tran mf_su_icmin_q4 MIN mfq_ic_q4 from=0.0 to=2e-08
meas tran mf_ss_icmax_q4 MAX mfq_ic_q4 from=2e-08 to=4e-08
meas tran mf_ss_icmin_q4 MIN mfq_ic_q4 from=2e-08 to=4e-08
let mfq_vce_q5 = v(c_q5)-v(x2)
meas tran mf_su_vcemax_q5 MAX mfq_vce_q5 from=0.0 to=2e-08
meas tran mf_su_vcemin_q5 MIN mfq_vce_q5 from=0.0 to=2e-08
meas tran mf_ss_vcemax_q5 MAX mfq_vce_q5 from=2e-08 to=4e-08
meas tran mf_ss_vcemin_q5 MIN mfq_vce_q5 from=2e-08 to=4e-08
let mfq_vbe_q5 = v(lo_p)-v(x2)
meas tran mf_su_vbemax_q5 MAX mfq_vbe_q5 from=0.0 to=2e-08
meas tran mf_su_vbemin_q5 MIN mfq_vbe_q5 from=0.0 to=2e-08
meas tran mf_ss_vbemax_q5 MAX mfq_vbe_q5 from=2e-08 to=4e-08
meas tran mf_ss_vbemin_q5 MIN mfq_vbe_q5 from=2e-08 to=4e-08
let mfq_ic_q5 = i(vic_q5)
meas tran mf_su_icmax_q5 MAX mfq_ic_q5 from=0.0 to=2e-08
meas tran mf_su_icmin_q5 MIN mfq_ic_q5 from=0.0 to=2e-08
meas tran mf_ss_icmax_q5 MAX mfq_ic_q5 from=2e-08 to=4e-08
meas tran mf_ss_icmin_q5 MIN mfq_ic_q5 from=2e-08 to=4e-08
let mfq_vce_q6 = v(c_q6)-v(x2)
meas tran mf_su_vcemax_q6 MAX mfq_vce_q6 from=0.0 to=2e-08
meas tran mf_su_vcemin_q6 MIN mfq_vce_q6 from=0.0 to=2e-08
meas tran mf_ss_vcemax_q6 MAX mfq_vce_q6 from=2e-08 to=4e-08
meas tran mf_ss_vcemin_q6 MIN mfq_vce_q6 from=2e-08 to=4e-08
let mfq_vbe_q6 = v(lo_n)-v(x2)
meas tran mf_su_vbemax_q6 MAX mfq_vbe_q6 from=0.0 to=2e-08
meas tran mf_su_vbemin_q6 MIN mfq_vbe_q6 from=0.0 to=2e-08
meas tran mf_ss_vbemax_q6 MAX mfq_vbe_q6 from=2e-08 to=4e-08
meas tran mf_ss_vbemin_q6 MIN mfq_vbe_q6 from=2e-08 to=4e-08
let mfq_ic_q6 = i(vic_q6)
meas tran mf_su_icmax_q6 MAX mfq_ic_q6 from=0.0 to=2e-08
meas tran mf_su_icmin_q6 MIN mfq_ic_q6 from=0.0 to=2e-08
meas tran mf_ss_icmax_q6 MAX mfq_ic_q6 from=2e-08 to=4e-08
meas tran mf_ss_icmin_q6 MIN mfq_ic_q6 from=2e-08 to=4e-08
meas tran mf_su_sinkmin_tail MIN v(tail) from=0.0 to=2e-08
meas tran mf_ss_sinkmin_tail MIN v(tail) from=2e-08 to=4e-08
print mf_su_vcemax_q1
print mf_su_vcemin_q1
print mf_ss_vcemax_q1
print mf_ss_vcemin_q1
print mf_su_vbemax_q1
print mf_su_vbemin_q1
print mf_ss_vbemax_q1
print mf_ss_vbemin_q1
print mf_su_icmax_q1
print mf_su_icmin_q1
print mf_ss_icmax_q1
print mf_ss_icmin_q1
print mf_su_vcemax_q2
print mf_su_vcemin_q2
print mf_ss_vcemax_q2
print mf_ss_vcemin_q2
print mf_su_vbemax_q2
print mf_su_vbemin_q2
print mf_ss_vbemax_q2
print mf_ss_vbemin_q2
print mf_su_icmax_q2
print mf_su_icmin_q2
print mf_ss_icmax_q2
print mf_ss_icmin_q2
print mf_su_vcemax_q3
print mf_su_vcemin_q3
print mf_ss_vcemax_q3
print mf_ss_vcemin_q3
print mf_su_vbemax_q3
print mf_su_vbemin_q3
print mf_ss_vbemax_q3
print mf_ss_vbemin_q3
print mf_su_icmax_q3
print mf_su_icmin_q3
print mf_ss_icmax_q3
print mf_ss_icmin_q3
print mf_su_vcemax_q4
print mf_su_vcemin_q4
print mf_ss_vcemax_q4
print mf_ss_vcemin_q4
print mf_su_vbemax_q4
print mf_su_vbemin_q4
print mf_ss_vbemax_q4
print mf_ss_vbemin_q4
print mf_su_icmax_q4
print mf_su_icmin_q4
print mf_ss_icmax_q4
print mf_ss_icmin_q4
print mf_su_vcemax_q5
print mf_su_vcemin_q5
print mf_ss_vcemax_q5
print mf_ss_vcemin_q5
print mf_su_vbemax_q5
print mf_su_vbemin_q5
print mf_ss_vbemax_q5
print mf_ss_vbemin_q5
print mf_su_icmax_q5
print mf_su_icmin_q5
print mf_ss_icmax_q5
print mf_ss_icmin_q5
print mf_su_vcemax_q6
print mf_su_vcemin_q6
print mf_ss_vcemax_q6
print mf_ss_vcemin_q6
print mf_su_vbemax_q6
print mf_su_vbemin_q6
print mf_ss_vbemax_q6
print mf_ss_vbemin_q6
print mf_su_icmax_q6
print mf_su_icmin_q6
print mf_ss_icmax_q6
print mf_ss_icmin_q6
print mf_su_sinkmin_tail
print mf_ss_sinkmin_tail
linearize
let mf_l = length(time)
let mfw = (time ge 1.99995e-08) * (time lt 3.99995e-08)
let mf_n = mean(mfw) * mf_l
let mfs = mf_l / mf_n
let mf_prail = mean(v(vdd) * (0 - i(vdd)) * mfw) * mfs
let mfph = 2 * pi * 16700000000.0 * (time - 2e-08)
let mf_lodiff_re = 2 * mean((v(lo_p)-v(lo_n)) * mfw * cos(mfph)) * mfs
let mf_lodiff_im = 2 * mean((v(lo_p)-v(lo_n)) * mfw * sin(mfph)) * mfs
let mfph = 2 * pi * 1000000000.0 * (time - 2e-08)
let mf_if_re = 2 * mean((v(if_out)) * mfw * cos(mfph)) * mfs
let mf_if_im = 2 * mean((v(if_out)) * mfw * sin(mfph)) * mfs
let mfph = 2 * pi * 16700000000.0 * (time - 2e-08)
let mf_loif_re = 2 * mean((v(if_out)) * mfw * cos(mfph)) * mfs
let mf_loif_im = 2 * mean((v(if_out)) * mfw * sin(mfph)) * mfs
let mfph = 2 * pi * 16700000000.0 * (time - 2e-08)
let mf_lorf_re = 2 * mean((v(rf_port)) * mfw * cos(mfph)) * mfs
let mf_lorf_im = 2 * mean((v(rf_port)) * mfw * sin(mfph)) * mfs
let mfph = 2 * pi * 950000000.0 * (time - 2e-08)
let mf_flifa_re = 2 * mean((v(if_out)) * mfw * cos(mfph)) * mfs
let mf_flifa_im = 2 * mean((v(if_out)) * mfw * sin(mfph)) * mfs
let mfph = 2 * pi * 1050000000.0 * (time - 2e-08)
let mf_flifb_re = 2 * mean((v(if_out)) * mfw * cos(mfph)) * mfs
let mf_flifb_im = 2 * mean((v(if_out)) * mfw * sin(mfph)) * mfs
let mfph = 2 * pi * 16750000000.0 * (time - 2e-08)
let mf_fllorf_re = 2 * mean((v(rf_port)) * mfw * cos(mfph)) * mfs
let mf_fllorf_im = 2 * mean((v(rf_port)) * mfw * sin(mfph)) * mfs
let mfph = 2 * pi * 16750000000.0 * (time - 2e-08)
let mf_flloif_re = 2 * mean((v(if_out)) * mfw * cos(mfph)) * mfs
let mf_flloif_im = 2 * mean((v(if_out)) * mfw * sin(mfph)) * mfs
print mf_l
print mf_n
print mf_prail
print mf_lodiff_re
print mf_lodiff_im
print mf_if_re
print mf_if_im
print mf_loif_re
print mf_loif_im
print mf_lorf_re
print mf_lorf_im
print mf_flifa_re
print mf_flifa_im
print mf_flifb_re
print mf_flifb_im
print mf_fllorf_re
print mf_fllorf_im
print mf_flloif_re
print mf_flloif_im
destroy all
echo "MFEND ls_f17p70_m15_rf60"
echo "MFRUN ls_f17p70_m15_rf66"
alterparam f1 = 17700000000.0
alterparam f2 = 17700000000.0
alterparam flo = 16700000000.0
alterparam vrf1 = 0.00031697863849222284
alterparam vrf2 = 0.0
alterparam vlo = 0.15905414575341015
reset
op
let mf_dcirail = 0 - i(vdd)
let mf_dc_vce_q1 = v(c_q1)-v(e_q1)
let mf_dc_vbe_q1 = v(b_q1)-v(e_q1)
let mf_dc_ic_q1 = i(vic_q1)
let mf_dc_vce_q2 = v(c_q2)-v(e_q2)
let mf_dc_vbe_q2 = v(b_q2)-v(e_q2)
let mf_dc_ic_q2 = i(vic_q2)
let mf_dc_vce_q3 = v(c_q3)-v(x1)
let mf_dc_vbe_q3 = v(lo_p)-v(x1)
let mf_dc_ic_q3 = i(vic_q3)
let mf_dc_vce_q4 = v(c_q4)-v(x1)
let mf_dc_vbe_q4 = v(lo_n)-v(x1)
let mf_dc_ic_q4 = i(vic_q4)
let mf_dc_vce_q5 = v(c_q5)-v(x2)
let mf_dc_vbe_q5 = v(lo_p)-v(x2)
let mf_dc_ic_q5 = i(vic_q5)
let mf_dc_vce_q6 = v(c_q6)-v(x2)
let mf_dc_vbe_q6 = v(lo_n)-v(x2)
let mf_dc_ic_q6 = i(vic_q6)
let mf_dc_sink_tail = v(tail)
print mf_dcirail
print mf_dc_vce_q1
print mf_dc_vbe_q1
print mf_dc_ic_q1
print mf_dc_vce_q2
print mf_dc_vbe_q2
print mf_dc_ic_q2
print mf_dc_vce_q3
print mf_dc_vbe_q3
print mf_dc_ic_q3
print mf_dc_vce_q4
print mf_dc_vbe_q4
print mf_dc_ic_q4
print mf_dc_vce_q5
print mf_dc_vbe_q5
print mf_dc_ic_q5
print mf_dc_vce_q6
print mf_dc_vbe_q6
print mf_dc_ic_q6
print mf_dc_sink_tail
tran 1e-12 4e-08 0 1e-12
let mfq_vce_q1 = v(c_q1)-v(e_q1)
meas tran mf_su_vcemax_q1 MAX mfq_vce_q1 from=0.0 to=2e-08
meas tran mf_su_vcemin_q1 MIN mfq_vce_q1 from=0.0 to=2e-08
meas tran mf_ss_vcemax_q1 MAX mfq_vce_q1 from=2e-08 to=4e-08
meas tran mf_ss_vcemin_q1 MIN mfq_vce_q1 from=2e-08 to=4e-08
let mfq_vbe_q1 = v(b_q1)-v(e_q1)
meas tran mf_su_vbemax_q1 MAX mfq_vbe_q1 from=0.0 to=2e-08
meas tran mf_su_vbemin_q1 MIN mfq_vbe_q1 from=0.0 to=2e-08
meas tran mf_ss_vbemax_q1 MAX mfq_vbe_q1 from=2e-08 to=4e-08
meas tran mf_ss_vbemin_q1 MIN mfq_vbe_q1 from=2e-08 to=4e-08
let mfq_ic_q1 = i(vic_q1)
meas tran mf_su_icmax_q1 MAX mfq_ic_q1 from=0.0 to=2e-08
meas tran mf_su_icmin_q1 MIN mfq_ic_q1 from=0.0 to=2e-08
meas tran mf_ss_icmax_q1 MAX mfq_ic_q1 from=2e-08 to=4e-08
meas tran mf_ss_icmin_q1 MIN mfq_ic_q1 from=2e-08 to=4e-08
let mfq_vce_q2 = v(c_q2)-v(e_q2)
meas tran mf_su_vcemax_q2 MAX mfq_vce_q2 from=0.0 to=2e-08
meas tran mf_su_vcemin_q2 MIN mfq_vce_q2 from=0.0 to=2e-08
meas tran mf_ss_vcemax_q2 MAX mfq_vce_q2 from=2e-08 to=4e-08
meas tran mf_ss_vcemin_q2 MIN mfq_vce_q2 from=2e-08 to=4e-08
let mfq_vbe_q2 = v(b_q2)-v(e_q2)
meas tran mf_su_vbemax_q2 MAX mfq_vbe_q2 from=0.0 to=2e-08
meas tran mf_su_vbemin_q2 MIN mfq_vbe_q2 from=0.0 to=2e-08
meas tran mf_ss_vbemax_q2 MAX mfq_vbe_q2 from=2e-08 to=4e-08
meas tran mf_ss_vbemin_q2 MIN mfq_vbe_q2 from=2e-08 to=4e-08
let mfq_ic_q2 = i(vic_q2)
meas tran mf_su_icmax_q2 MAX mfq_ic_q2 from=0.0 to=2e-08
meas tran mf_su_icmin_q2 MIN mfq_ic_q2 from=0.0 to=2e-08
meas tran mf_ss_icmax_q2 MAX mfq_ic_q2 from=2e-08 to=4e-08
meas tran mf_ss_icmin_q2 MIN mfq_ic_q2 from=2e-08 to=4e-08
let mfq_vce_q3 = v(c_q3)-v(x1)
meas tran mf_su_vcemax_q3 MAX mfq_vce_q3 from=0.0 to=2e-08
meas tran mf_su_vcemin_q3 MIN mfq_vce_q3 from=0.0 to=2e-08
meas tran mf_ss_vcemax_q3 MAX mfq_vce_q3 from=2e-08 to=4e-08
meas tran mf_ss_vcemin_q3 MIN mfq_vce_q3 from=2e-08 to=4e-08
let mfq_vbe_q3 = v(lo_p)-v(x1)
meas tran mf_su_vbemax_q3 MAX mfq_vbe_q3 from=0.0 to=2e-08
meas tran mf_su_vbemin_q3 MIN mfq_vbe_q3 from=0.0 to=2e-08
meas tran mf_ss_vbemax_q3 MAX mfq_vbe_q3 from=2e-08 to=4e-08
meas tran mf_ss_vbemin_q3 MIN mfq_vbe_q3 from=2e-08 to=4e-08
let mfq_ic_q3 = i(vic_q3)
meas tran mf_su_icmax_q3 MAX mfq_ic_q3 from=0.0 to=2e-08
meas tran mf_su_icmin_q3 MIN mfq_ic_q3 from=0.0 to=2e-08
meas tran mf_ss_icmax_q3 MAX mfq_ic_q3 from=2e-08 to=4e-08
meas tran mf_ss_icmin_q3 MIN mfq_ic_q3 from=2e-08 to=4e-08
let mfq_vce_q4 = v(c_q4)-v(x1)
meas tran mf_su_vcemax_q4 MAX mfq_vce_q4 from=0.0 to=2e-08
meas tran mf_su_vcemin_q4 MIN mfq_vce_q4 from=0.0 to=2e-08
meas tran mf_ss_vcemax_q4 MAX mfq_vce_q4 from=2e-08 to=4e-08
meas tran mf_ss_vcemin_q4 MIN mfq_vce_q4 from=2e-08 to=4e-08
let mfq_vbe_q4 = v(lo_n)-v(x1)
meas tran mf_su_vbemax_q4 MAX mfq_vbe_q4 from=0.0 to=2e-08
meas tran mf_su_vbemin_q4 MIN mfq_vbe_q4 from=0.0 to=2e-08
meas tran mf_ss_vbemax_q4 MAX mfq_vbe_q4 from=2e-08 to=4e-08
meas tran mf_ss_vbemin_q4 MIN mfq_vbe_q4 from=2e-08 to=4e-08
let mfq_ic_q4 = i(vic_q4)
meas tran mf_su_icmax_q4 MAX mfq_ic_q4 from=0.0 to=2e-08
meas tran mf_su_icmin_q4 MIN mfq_ic_q4 from=0.0 to=2e-08
meas tran mf_ss_icmax_q4 MAX mfq_ic_q4 from=2e-08 to=4e-08
meas tran mf_ss_icmin_q4 MIN mfq_ic_q4 from=2e-08 to=4e-08
let mfq_vce_q5 = v(c_q5)-v(x2)
meas tran mf_su_vcemax_q5 MAX mfq_vce_q5 from=0.0 to=2e-08
meas tran mf_su_vcemin_q5 MIN mfq_vce_q5 from=0.0 to=2e-08
meas tran mf_ss_vcemax_q5 MAX mfq_vce_q5 from=2e-08 to=4e-08
meas tran mf_ss_vcemin_q5 MIN mfq_vce_q5 from=2e-08 to=4e-08
let mfq_vbe_q5 = v(lo_p)-v(x2)
meas tran mf_su_vbemax_q5 MAX mfq_vbe_q5 from=0.0 to=2e-08
meas tran mf_su_vbemin_q5 MIN mfq_vbe_q5 from=0.0 to=2e-08
meas tran mf_ss_vbemax_q5 MAX mfq_vbe_q5 from=2e-08 to=4e-08
meas tran mf_ss_vbemin_q5 MIN mfq_vbe_q5 from=2e-08 to=4e-08
let mfq_ic_q5 = i(vic_q5)
meas tran mf_su_icmax_q5 MAX mfq_ic_q5 from=0.0 to=2e-08
meas tran mf_su_icmin_q5 MIN mfq_ic_q5 from=0.0 to=2e-08
meas tran mf_ss_icmax_q5 MAX mfq_ic_q5 from=2e-08 to=4e-08
meas tran mf_ss_icmin_q5 MIN mfq_ic_q5 from=2e-08 to=4e-08
let mfq_vce_q6 = v(c_q6)-v(x2)
meas tran mf_su_vcemax_q6 MAX mfq_vce_q6 from=0.0 to=2e-08
meas tran mf_su_vcemin_q6 MIN mfq_vce_q6 from=0.0 to=2e-08
meas tran mf_ss_vcemax_q6 MAX mfq_vce_q6 from=2e-08 to=4e-08
meas tran mf_ss_vcemin_q6 MIN mfq_vce_q6 from=2e-08 to=4e-08
let mfq_vbe_q6 = v(lo_n)-v(x2)
meas tran mf_su_vbemax_q6 MAX mfq_vbe_q6 from=0.0 to=2e-08
meas tran mf_su_vbemin_q6 MIN mfq_vbe_q6 from=0.0 to=2e-08
meas tran mf_ss_vbemax_q6 MAX mfq_vbe_q6 from=2e-08 to=4e-08
meas tran mf_ss_vbemin_q6 MIN mfq_vbe_q6 from=2e-08 to=4e-08
let mfq_ic_q6 = i(vic_q6)
meas tran mf_su_icmax_q6 MAX mfq_ic_q6 from=0.0 to=2e-08
meas tran mf_su_icmin_q6 MIN mfq_ic_q6 from=0.0 to=2e-08
meas tran mf_ss_icmax_q6 MAX mfq_ic_q6 from=2e-08 to=4e-08
meas tran mf_ss_icmin_q6 MIN mfq_ic_q6 from=2e-08 to=4e-08
meas tran mf_su_sinkmin_tail MIN v(tail) from=0.0 to=2e-08
meas tran mf_ss_sinkmin_tail MIN v(tail) from=2e-08 to=4e-08
print mf_su_vcemax_q1
print mf_su_vcemin_q1
print mf_ss_vcemax_q1
print mf_ss_vcemin_q1
print mf_su_vbemax_q1
print mf_su_vbemin_q1
print mf_ss_vbemax_q1
print mf_ss_vbemin_q1
print mf_su_icmax_q1
print mf_su_icmin_q1
print mf_ss_icmax_q1
print mf_ss_icmin_q1
print mf_su_vcemax_q2
print mf_su_vcemin_q2
print mf_ss_vcemax_q2
print mf_ss_vcemin_q2
print mf_su_vbemax_q2
print mf_su_vbemin_q2
print mf_ss_vbemax_q2
print mf_ss_vbemin_q2
print mf_su_icmax_q2
print mf_su_icmin_q2
print mf_ss_icmax_q2
print mf_ss_icmin_q2
print mf_su_vcemax_q3
print mf_su_vcemin_q3
print mf_ss_vcemax_q3
print mf_ss_vcemin_q3
print mf_su_vbemax_q3
print mf_su_vbemin_q3
print mf_ss_vbemax_q3
print mf_ss_vbemin_q3
print mf_su_icmax_q3
print mf_su_icmin_q3
print mf_ss_icmax_q3
print mf_ss_icmin_q3
print mf_su_vcemax_q4
print mf_su_vcemin_q4
print mf_ss_vcemax_q4
print mf_ss_vcemin_q4
print mf_su_vbemax_q4
print mf_su_vbemin_q4
print mf_ss_vbemax_q4
print mf_ss_vbemin_q4
print mf_su_icmax_q4
print mf_su_icmin_q4
print mf_ss_icmax_q4
print mf_ss_icmin_q4
print mf_su_vcemax_q5
print mf_su_vcemin_q5
print mf_ss_vcemax_q5
print mf_ss_vcemin_q5
print mf_su_vbemax_q5
print mf_su_vbemin_q5
print mf_ss_vbemax_q5
print mf_ss_vbemin_q5
print mf_su_icmax_q5
print mf_su_icmin_q5
print mf_ss_icmax_q5
print mf_ss_icmin_q5
print mf_su_vcemax_q6
print mf_su_vcemin_q6
print mf_ss_vcemax_q6
print mf_ss_vcemin_q6
print mf_su_vbemax_q6
print mf_su_vbemin_q6
print mf_ss_vbemax_q6
print mf_ss_vbemin_q6
print mf_su_icmax_q6
print mf_su_icmin_q6
print mf_ss_icmax_q6
print mf_ss_icmin_q6
print mf_su_sinkmin_tail
print mf_ss_sinkmin_tail
linearize
let mf_l = length(time)
let mfw = (time ge 1.99995e-08) * (time lt 3.99995e-08)
let mf_n = mean(mfw) * mf_l
let mfs = mf_l / mf_n
let mf_prail = mean(v(vdd) * (0 - i(vdd)) * mfw) * mfs
let mfph = 2 * pi * 16700000000.0 * (time - 2e-08)
let mf_lodiff_re = 2 * mean((v(lo_p)-v(lo_n)) * mfw * cos(mfph)) * mfs
let mf_lodiff_im = 2 * mean((v(lo_p)-v(lo_n)) * mfw * sin(mfph)) * mfs
let mfph = 2 * pi * 1000000000.0 * (time - 2e-08)
let mf_if_re = 2 * mean((v(if_out)) * mfw * cos(mfph)) * mfs
let mf_if_im = 2 * mean((v(if_out)) * mfw * sin(mfph)) * mfs
let mfph = 2 * pi * 16700000000.0 * (time - 2e-08)
let mf_loif_re = 2 * mean((v(if_out)) * mfw * cos(mfph)) * mfs
let mf_loif_im = 2 * mean((v(if_out)) * mfw * sin(mfph)) * mfs
let mfph = 2 * pi * 16700000000.0 * (time - 2e-08)
let mf_lorf_re = 2 * mean((v(rf_port)) * mfw * cos(mfph)) * mfs
let mf_lorf_im = 2 * mean((v(rf_port)) * mfw * sin(mfph)) * mfs
let mfph = 2 * pi * 950000000.0 * (time - 2e-08)
let mf_flifa_re = 2 * mean((v(if_out)) * mfw * cos(mfph)) * mfs
let mf_flifa_im = 2 * mean((v(if_out)) * mfw * sin(mfph)) * mfs
let mfph = 2 * pi * 1050000000.0 * (time - 2e-08)
let mf_flifb_re = 2 * mean((v(if_out)) * mfw * cos(mfph)) * mfs
let mf_flifb_im = 2 * mean((v(if_out)) * mfw * sin(mfph)) * mfs
let mfph = 2 * pi * 16750000000.0 * (time - 2e-08)
let mf_fllorf_re = 2 * mean((v(rf_port)) * mfw * cos(mfph)) * mfs
let mf_fllorf_im = 2 * mean((v(rf_port)) * mfw * sin(mfph)) * mfs
let mfph = 2 * pi * 16750000000.0 * (time - 2e-08)
let mf_flloif_re = 2 * mean((v(if_out)) * mfw * cos(mfph)) * mfs
let mf_flloif_im = 2 * mean((v(if_out)) * mfw * sin(mfph)) * mfs
print mf_l
print mf_n
print mf_prail
print mf_lodiff_re
print mf_lodiff_im
print mf_if_re
print mf_if_im
print mf_loif_re
print mf_loif_im
print mf_lorf_re
print mf_lorf_im
print mf_flifa_re
print mf_flifa_im
print mf_flifb_re
print mf_flifb_im
print mf_fllorf_re
print mf_fllorf_im
print mf_flloif_re
print mf_flloif_im
destroy all
echo "MFEND ls_f17p70_m15_rf66"
echo "MFRUN ls_f17p70_m12_rf60"
alterparam f1 = 17700000000.0
alterparam f2 = 17700000000.0
alterparam flo = 16700000000.0
alterparam vrf1 = 0.0006324555320336759
alterparam vrf2 = 0.0
alterparam vlo = 0.22466995250459165
reset
op
let mf_dcirail = 0 - i(vdd)
let mf_dc_vce_q1 = v(c_q1)-v(e_q1)
let mf_dc_vbe_q1 = v(b_q1)-v(e_q1)
let mf_dc_ic_q1 = i(vic_q1)
let mf_dc_vce_q2 = v(c_q2)-v(e_q2)
let mf_dc_vbe_q2 = v(b_q2)-v(e_q2)
let mf_dc_ic_q2 = i(vic_q2)
let mf_dc_vce_q3 = v(c_q3)-v(x1)
let mf_dc_vbe_q3 = v(lo_p)-v(x1)
let mf_dc_ic_q3 = i(vic_q3)
let mf_dc_vce_q4 = v(c_q4)-v(x1)
let mf_dc_vbe_q4 = v(lo_n)-v(x1)
let mf_dc_ic_q4 = i(vic_q4)
let mf_dc_vce_q5 = v(c_q5)-v(x2)
let mf_dc_vbe_q5 = v(lo_p)-v(x2)
let mf_dc_ic_q5 = i(vic_q5)
let mf_dc_vce_q6 = v(c_q6)-v(x2)
let mf_dc_vbe_q6 = v(lo_n)-v(x2)
let mf_dc_ic_q6 = i(vic_q6)
let mf_dc_sink_tail = v(tail)
print mf_dcirail
print mf_dc_vce_q1
print mf_dc_vbe_q1
print mf_dc_ic_q1
print mf_dc_vce_q2
print mf_dc_vbe_q2
print mf_dc_ic_q2
print mf_dc_vce_q3
print mf_dc_vbe_q3
print mf_dc_ic_q3
print mf_dc_vce_q4
print mf_dc_vbe_q4
print mf_dc_ic_q4
print mf_dc_vce_q5
print mf_dc_vbe_q5
print mf_dc_ic_q5
print mf_dc_vce_q6
print mf_dc_vbe_q6
print mf_dc_ic_q6
print mf_dc_sink_tail
tran 1e-12 4e-08 0 1e-12
let mfq_vce_q1 = v(c_q1)-v(e_q1)
meas tran mf_su_vcemax_q1 MAX mfq_vce_q1 from=0.0 to=2e-08
meas tran mf_su_vcemin_q1 MIN mfq_vce_q1 from=0.0 to=2e-08
meas tran mf_ss_vcemax_q1 MAX mfq_vce_q1 from=2e-08 to=4e-08
meas tran mf_ss_vcemin_q1 MIN mfq_vce_q1 from=2e-08 to=4e-08
let mfq_vbe_q1 = v(b_q1)-v(e_q1)
meas tran mf_su_vbemax_q1 MAX mfq_vbe_q1 from=0.0 to=2e-08
meas tran mf_su_vbemin_q1 MIN mfq_vbe_q1 from=0.0 to=2e-08
meas tran mf_ss_vbemax_q1 MAX mfq_vbe_q1 from=2e-08 to=4e-08
meas tran mf_ss_vbemin_q1 MIN mfq_vbe_q1 from=2e-08 to=4e-08
let mfq_ic_q1 = i(vic_q1)
meas tran mf_su_icmax_q1 MAX mfq_ic_q1 from=0.0 to=2e-08
meas tran mf_su_icmin_q1 MIN mfq_ic_q1 from=0.0 to=2e-08
meas tran mf_ss_icmax_q1 MAX mfq_ic_q1 from=2e-08 to=4e-08
meas tran mf_ss_icmin_q1 MIN mfq_ic_q1 from=2e-08 to=4e-08
let mfq_vce_q2 = v(c_q2)-v(e_q2)
meas tran mf_su_vcemax_q2 MAX mfq_vce_q2 from=0.0 to=2e-08
meas tran mf_su_vcemin_q2 MIN mfq_vce_q2 from=0.0 to=2e-08
meas tran mf_ss_vcemax_q2 MAX mfq_vce_q2 from=2e-08 to=4e-08
meas tran mf_ss_vcemin_q2 MIN mfq_vce_q2 from=2e-08 to=4e-08
let mfq_vbe_q2 = v(b_q2)-v(e_q2)
meas tran mf_su_vbemax_q2 MAX mfq_vbe_q2 from=0.0 to=2e-08
meas tran mf_su_vbemin_q2 MIN mfq_vbe_q2 from=0.0 to=2e-08
meas tran mf_ss_vbemax_q2 MAX mfq_vbe_q2 from=2e-08 to=4e-08
meas tran mf_ss_vbemin_q2 MIN mfq_vbe_q2 from=2e-08 to=4e-08
let mfq_ic_q2 = i(vic_q2)
meas tran mf_su_icmax_q2 MAX mfq_ic_q2 from=0.0 to=2e-08
meas tran mf_su_icmin_q2 MIN mfq_ic_q2 from=0.0 to=2e-08
meas tran mf_ss_icmax_q2 MAX mfq_ic_q2 from=2e-08 to=4e-08
meas tran mf_ss_icmin_q2 MIN mfq_ic_q2 from=2e-08 to=4e-08
let mfq_vce_q3 = v(c_q3)-v(x1)
meas tran mf_su_vcemax_q3 MAX mfq_vce_q3 from=0.0 to=2e-08
meas tran mf_su_vcemin_q3 MIN mfq_vce_q3 from=0.0 to=2e-08
meas tran mf_ss_vcemax_q3 MAX mfq_vce_q3 from=2e-08 to=4e-08
meas tran mf_ss_vcemin_q3 MIN mfq_vce_q3 from=2e-08 to=4e-08
let mfq_vbe_q3 = v(lo_p)-v(x1)
meas tran mf_su_vbemax_q3 MAX mfq_vbe_q3 from=0.0 to=2e-08
meas tran mf_su_vbemin_q3 MIN mfq_vbe_q3 from=0.0 to=2e-08
meas tran mf_ss_vbemax_q3 MAX mfq_vbe_q3 from=2e-08 to=4e-08
meas tran mf_ss_vbemin_q3 MIN mfq_vbe_q3 from=2e-08 to=4e-08
let mfq_ic_q3 = i(vic_q3)
meas tran mf_su_icmax_q3 MAX mfq_ic_q3 from=0.0 to=2e-08
meas tran mf_su_icmin_q3 MIN mfq_ic_q3 from=0.0 to=2e-08
meas tran mf_ss_icmax_q3 MAX mfq_ic_q3 from=2e-08 to=4e-08
meas tran mf_ss_icmin_q3 MIN mfq_ic_q3 from=2e-08 to=4e-08
let mfq_vce_q4 = v(c_q4)-v(x1)
meas tran mf_su_vcemax_q4 MAX mfq_vce_q4 from=0.0 to=2e-08
meas tran mf_su_vcemin_q4 MIN mfq_vce_q4 from=0.0 to=2e-08
meas tran mf_ss_vcemax_q4 MAX mfq_vce_q4 from=2e-08 to=4e-08
meas tran mf_ss_vcemin_q4 MIN mfq_vce_q4 from=2e-08 to=4e-08
let mfq_vbe_q4 = v(lo_n)-v(x1)
meas tran mf_su_vbemax_q4 MAX mfq_vbe_q4 from=0.0 to=2e-08
meas tran mf_su_vbemin_q4 MIN mfq_vbe_q4 from=0.0 to=2e-08
meas tran mf_ss_vbemax_q4 MAX mfq_vbe_q4 from=2e-08 to=4e-08
meas tran mf_ss_vbemin_q4 MIN mfq_vbe_q4 from=2e-08 to=4e-08
let mfq_ic_q4 = i(vic_q4)
meas tran mf_su_icmax_q4 MAX mfq_ic_q4 from=0.0 to=2e-08
meas tran mf_su_icmin_q4 MIN mfq_ic_q4 from=0.0 to=2e-08
meas tran mf_ss_icmax_q4 MAX mfq_ic_q4 from=2e-08 to=4e-08
meas tran mf_ss_icmin_q4 MIN mfq_ic_q4 from=2e-08 to=4e-08
let mfq_vce_q5 = v(c_q5)-v(x2)
meas tran mf_su_vcemax_q5 MAX mfq_vce_q5 from=0.0 to=2e-08
meas tran mf_su_vcemin_q5 MIN mfq_vce_q5 from=0.0 to=2e-08
meas tran mf_ss_vcemax_q5 MAX mfq_vce_q5 from=2e-08 to=4e-08
meas tran mf_ss_vcemin_q5 MIN mfq_vce_q5 from=2e-08 to=4e-08
let mfq_vbe_q5 = v(lo_p)-v(x2)
meas tran mf_su_vbemax_q5 MAX mfq_vbe_q5 from=0.0 to=2e-08
meas tran mf_su_vbemin_q5 MIN mfq_vbe_q5 from=0.0 to=2e-08
meas tran mf_ss_vbemax_q5 MAX mfq_vbe_q5 from=2e-08 to=4e-08
meas tran mf_ss_vbemin_q5 MIN mfq_vbe_q5 from=2e-08 to=4e-08
let mfq_ic_q5 = i(vic_q5)
meas tran mf_su_icmax_q5 MAX mfq_ic_q5 from=0.0 to=2e-08
meas tran mf_su_icmin_q5 MIN mfq_ic_q5 from=0.0 to=2e-08
meas tran mf_ss_icmax_q5 MAX mfq_ic_q5 from=2e-08 to=4e-08
meas tran mf_ss_icmin_q5 MIN mfq_ic_q5 from=2e-08 to=4e-08
let mfq_vce_q6 = v(c_q6)-v(x2)
meas tran mf_su_vcemax_q6 MAX mfq_vce_q6 from=0.0 to=2e-08
meas tran mf_su_vcemin_q6 MIN mfq_vce_q6 from=0.0 to=2e-08
meas tran mf_ss_vcemax_q6 MAX mfq_vce_q6 from=2e-08 to=4e-08
meas tran mf_ss_vcemin_q6 MIN mfq_vce_q6 from=2e-08 to=4e-08
let mfq_vbe_q6 = v(lo_n)-v(x2)
meas tran mf_su_vbemax_q6 MAX mfq_vbe_q6 from=0.0 to=2e-08
meas tran mf_su_vbemin_q6 MIN mfq_vbe_q6 from=0.0 to=2e-08
meas tran mf_ss_vbemax_q6 MAX mfq_vbe_q6 from=2e-08 to=4e-08
meas tran mf_ss_vbemin_q6 MIN mfq_vbe_q6 from=2e-08 to=4e-08
let mfq_ic_q6 = i(vic_q6)
meas tran mf_su_icmax_q6 MAX mfq_ic_q6 from=0.0 to=2e-08
meas tran mf_su_icmin_q6 MIN mfq_ic_q6 from=0.0 to=2e-08
meas tran mf_ss_icmax_q6 MAX mfq_ic_q6 from=2e-08 to=4e-08
meas tran mf_ss_icmin_q6 MIN mfq_ic_q6 from=2e-08 to=4e-08
meas tran mf_su_sinkmin_tail MIN v(tail) from=0.0 to=2e-08
meas tran mf_ss_sinkmin_tail MIN v(tail) from=2e-08 to=4e-08
print mf_su_vcemax_q1
print mf_su_vcemin_q1
print mf_ss_vcemax_q1
print mf_ss_vcemin_q1
print mf_su_vbemax_q1
print mf_su_vbemin_q1
print mf_ss_vbemax_q1
print mf_ss_vbemin_q1
print mf_su_icmax_q1
print mf_su_icmin_q1
print mf_ss_icmax_q1
print mf_ss_icmin_q1
print mf_su_vcemax_q2
print mf_su_vcemin_q2
print mf_ss_vcemax_q2
print mf_ss_vcemin_q2
print mf_su_vbemax_q2
print mf_su_vbemin_q2
print mf_ss_vbemax_q2
print mf_ss_vbemin_q2
print mf_su_icmax_q2
print mf_su_icmin_q2
print mf_ss_icmax_q2
print mf_ss_icmin_q2
print mf_su_vcemax_q3
print mf_su_vcemin_q3
print mf_ss_vcemax_q3
print mf_ss_vcemin_q3
print mf_su_vbemax_q3
print mf_su_vbemin_q3
print mf_ss_vbemax_q3
print mf_ss_vbemin_q3
print mf_su_icmax_q3
print mf_su_icmin_q3
print mf_ss_icmax_q3
print mf_ss_icmin_q3
print mf_su_vcemax_q4
print mf_su_vcemin_q4
print mf_ss_vcemax_q4
print mf_ss_vcemin_q4
print mf_su_vbemax_q4
print mf_su_vbemin_q4
print mf_ss_vbemax_q4
print mf_ss_vbemin_q4
print mf_su_icmax_q4
print mf_su_icmin_q4
print mf_ss_icmax_q4
print mf_ss_icmin_q4
print mf_su_vcemax_q5
print mf_su_vcemin_q5
print mf_ss_vcemax_q5
print mf_ss_vcemin_q5
print mf_su_vbemax_q5
print mf_su_vbemin_q5
print mf_ss_vbemax_q5
print mf_ss_vbemin_q5
print mf_su_icmax_q5
print mf_su_icmin_q5
print mf_ss_icmax_q5
print mf_ss_icmin_q5
print mf_su_vcemax_q6
print mf_su_vcemin_q6
print mf_ss_vcemax_q6
print mf_ss_vcemin_q6
print mf_su_vbemax_q6
print mf_su_vbemin_q6
print mf_ss_vbemax_q6
print mf_ss_vbemin_q6
print mf_su_icmax_q6
print mf_su_icmin_q6
print mf_ss_icmax_q6
print mf_ss_icmin_q6
print mf_su_sinkmin_tail
print mf_ss_sinkmin_tail
linearize
let mf_l = length(time)
let mfw = (time ge 1.99995e-08) * (time lt 3.99995e-08)
let mf_n = mean(mfw) * mf_l
let mfs = mf_l / mf_n
let mf_prail = mean(v(vdd) * (0 - i(vdd)) * mfw) * mfs
let mfph = 2 * pi * 16700000000.0 * (time - 2e-08)
let mf_lodiff_re = 2 * mean((v(lo_p)-v(lo_n)) * mfw * cos(mfph)) * mfs
let mf_lodiff_im = 2 * mean((v(lo_p)-v(lo_n)) * mfw * sin(mfph)) * mfs
let mfph = 2 * pi * 1000000000.0 * (time - 2e-08)
let mf_if_re = 2 * mean((v(if_out)) * mfw * cos(mfph)) * mfs
let mf_if_im = 2 * mean((v(if_out)) * mfw * sin(mfph)) * mfs
let mfph = 2 * pi * 16700000000.0 * (time - 2e-08)
let mf_loif_re = 2 * mean((v(if_out)) * mfw * cos(mfph)) * mfs
let mf_loif_im = 2 * mean((v(if_out)) * mfw * sin(mfph)) * mfs
let mfph = 2 * pi * 16700000000.0 * (time - 2e-08)
let mf_lorf_re = 2 * mean((v(rf_port)) * mfw * cos(mfph)) * mfs
let mf_lorf_im = 2 * mean((v(rf_port)) * mfw * sin(mfph)) * mfs
let mfph = 2 * pi * 950000000.0 * (time - 2e-08)
let mf_flifa_re = 2 * mean((v(if_out)) * mfw * cos(mfph)) * mfs
let mf_flifa_im = 2 * mean((v(if_out)) * mfw * sin(mfph)) * mfs
let mfph = 2 * pi * 1050000000.0 * (time - 2e-08)
let mf_flifb_re = 2 * mean((v(if_out)) * mfw * cos(mfph)) * mfs
let mf_flifb_im = 2 * mean((v(if_out)) * mfw * sin(mfph)) * mfs
let mfph = 2 * pi * 16750000000.0 * (time - 2e-08)
let mf_fllorf_re = 2 * mean((v(rf_port)) * mfw * cos(mfph)) * mfs
let mf_fllorf_im = 2 * mean((v(rf_port)) * mfw * sin(mfph)) * mfs
let mfph = 2 * pi * 16750000000.0 * (time - 2e-08)
let mf_flloif_re = 2 * mean((v(if_out)) * mfw * cos(mfph)) * mfs
let mf_flloif_im = 2 * mean((v(if_out)) * mfw * sin(mfph)) * mfs
print mf_l
print mf_n
print mf_prail
print mf_lodiff_re
print mf_lodiff_im
print mf_if_re
print mf_if_im
print mf_loif_re
print mf_loif_im
print mf_lorf_re
print mf_lorf_im
print mf_flifa_re
print mf_flifa_im
print mf_flifb_re
print mf_flifb_im
print mf_fllorf_re
print mf_fllorf_im
print mf_flloif_re
print mf_flloif_im
destroy all
echo "MFEND ls_f17p70_m12_rf60"
echo "MFRUN ls_f17p70_m12_rf66"
alterparam f1 = 17700000000.0
alterparam f2 = 17700000000.0
alterparam flo = 16700000000.0
alterparam vrf1 = 0.00031697863849222284
alterparam vrf2 = 0.0
alterparam vlo = 0.22466995250459165
reset
op
let mf_dcirail = 0 - i(vdd)
let mf_dc_vce_q1 = v(c_q1)-v(e_q1)
let mf_dc_vbe_q1 = v(b_q1)-v(e_q1)
let mf_dc_ic_q1 = i(vic_q1)
let mf_dc_vce_q2 = v(c_q2)-v(e_q2)
let mf_dc_vbe_q2 = v(b_q2)-v(e_q2)
let mf_dc_ic_q2 = i(vic_q2)
let mf_dc_vce_q3 = v(c_q3)-v(x1)
let mf_dc_vbe_q3 = v(lo_p)-v(x1)
let mf_dc_ic_q3 = i(vic_q3)
let mf_dc_vce_q4 = v(c_q4)-v(x1)
let mf_dc_vbe_q4 = v(lo_n)-v(x1)
let mf_dc_ic_q4 = i(vic_q4)
let mf_dc_vce_q5 = v(c_q5)-v(x2)
let mf_dc_vbe_q5 = v(lo_p)-v(x2)
let mf_dc_ic_q5 = i(vic_q5)
let mf_dc_vce_q6 = v(c_q6)-v(x2)
let mf_dc_vbe_q6 = v(lo_n)-v(x2)
let mf_dc_ic_q6 = i(vic_q6)
let mf_dc_sink_tail = v(tail)
print mf_dcirail
print mf_dc_vce_q1
print mf_dc_vbe_q1
print mf_dc_ic_q1
print mf_dc_vce_q2
print mf_dc_vbe_q2
print mf_dc_ic_q2
print mf_dc_vce_q3
print mf_dc_vbe_q3
print mf_dc_ic_q3
print mf_dc_vce_q4
print mf_dc_vbe_q4
print mf_dc_ic_q4
print mf_dc_vce_q5
print mf_dc_vbe_q5
print mf_dc_ic_q5
print mf_dc_vce_q6
print mf_dc_vbe_q6
print mf_dc_ic_q6
print mf_dc_sink_tail
tran 1e-12 4e-08 0 1e-12
let mfq_vce_q1 = v(c_q1)-v(e_q1)
meas tran mf_su_vcemax_q1 MAX mfq_vce_q1 from=0.0 to=2e-08
meas tran mf_su_vcemin_q1 MIN mfq_vce_q1 from=0.0 to=2e-08
meas tran mf_ss_vcemax_q1 MAX mfq_vce_q1 from=2e-08 to=4e-08
meas tran mf_ss_vcemin_q1 MIN mfq_vce_q1 from=2e-08 to=4e-08
let mfq_vbe_q1 = v(b_q1)-v(e_q1)
meas tran mf_su_vbemax_q1 MAX mfq_vbe_q1 from=0.0 to=2e-08
meas tran mf_su_vbemin_q1 MIN mfq_vbe_q1 from=0.0 to=2e-08
meas tran mf_ss_vbemax_q1 MAX mfq_vbe_q1 from=2e-08 to=4e-08
meas tran mf_ss_vbemin_q1 MIN mfq_vbe_q1 from=2e-08 to=4e-08
let mfq_ic_q1 = i(vic_q1)
meas tran mf_su_icmax_q1 MAX mfq_ic_q1 from=0.0 to=2e-08
meas tran mf_su_icmin_q1 MIN mfq_ic_q1 from=0.0 to=2e-08
meas tran mf_ss_icmax_q1 MAX mfq_ic_q1 from=2e-08 to=4e-08
meas tran mf_ss_icmin_q1 MIN mfq_ic_q1 from=2e-08 to=4e-08
let mfq_vce_q2 = v(c_q2)-v(e_q2)
meas tran mf_su_vcemax_q2 MAX mfq_vce_q2 from=0.0 to=2e-08
meas tran mf_su_vcemin_q2 MIN mfq_vce_q2 from=0.0 to=2e-08
meas tran mf_ss_vcemax_q2 MAX mfq_vce_q2 from=2e-08 to=4e-08
meas tran mf_ss_vcemin_q2 MIN mfq_vce_q2 from=2e-08 to=4e-08
let mfq_vbe_q2 = v(b_q2)-v(e_q2)
meas tran mf_su_vbemax_q2 MAX mfq_vbe_q2 from=0.0 to=2e-08
meas tran mf_su_vbemin_q2 MIN mfq_vbe_q2 from=0.0 to=2e-08
meas tran mf_ss_vbemax_q2 MAX mfq_vbe_q2 from=2e-08 to=4e-08
meas tran mf_ss_vbemin_q2 MIN mfq_vbe_q2 from=2e-08 to=4e-08
let mfq_ic_q2 = i(vic_q2)
meas tran mf_su_icmax_q2 MAX mfq_ic_q2 from=0.0 to=2e-08
meas tran mf_su_icmin_q2 MIN mfq_ic_q2 from=0.0 to=2e-08
meas tran mf_ss_icmax_q2 MAX mfq_ic_q2 from=2e-08 to=4e-08
meas tran mf_ss_icmin_q2 MIN mfq_ic_q2 from=2e-08 to=4e-08
let mfq_vce_q3 = v(c_q3)-v(x1)
meas tran mf_su_vcemax_q3 MAX mfq_vce_q3 from=0.0 to=2e-08
meas tran mf_su_vcemin_q3 MIN mfq_vce_q3 from=0.0 to=2e-08
meas tran mf_ss_vcemax_q3 MAX mfq_vce_q3 from=2e-08 to=4e-08
meas tran mf_ss_vcemin_q3 MIN mfq_vce_q3 from=2e-08 to=4e-08
let mfq_vbe_q3 = v(lo_p)-v(x1)
meas tran mf_su_vbemax_q3 MAX mfq_vbe_q3 from=0.0 to=2e-08
meas tran mf_su_vbemin_q3 MIN mfq_vbe_q3 from=0.0 to=2e-08
meas tran mf_ss_vbemax_q3 MAX mfq_vbe_q3 from=2e-08 to=4e-08
meas tran mf_ss_vbemin_q3 MIN mfq_vbe_q3 from=2e-08 to=4e-08
let mfq_ic_q3 = i(vic_q3)
meas tran mf_su_icmax_q3 MAX mfq_ic_q3 from=0.0 to=2e-08
meas tran mf_su_icmin_q3 MIN mfq_ic_q3 from=0.0 to=2e-08
meas tran mf_ss_icmax_q3 MAX mfq_ic_q3 from=2e-08 to=4e-08
meas tran mf_ss_icmin_q3 MIN mfq_ic_q3 from=2e-08 to=4e-08
let mfq_vce_q4 = v(c_q4)-v(x1)
meas tran mf_su_vcemax_q4 MAX mfq_vce_q4 from=0.0 to=2e-08
meas tran mf_su_vcemin_q4 MIN mfq_vce_q4 from=0.0 to=2e-08
meas tran mf_ss_vcemax_q4 MAX mfq_vce_q4 from=2e-08 to=4e-08
meas tran mf_ss_vcemin_q4 MIN mfq_vce_q4 from=2e-08 to=4e-08
let mfq_vbe_q4 = v(lo_n)-v(x1)
meas tran mf_su_vbemax_q4 MAX mfq_vbe_q4 from=0.0 to=2e-08
meas tran mf_su_vbemin_q4 MIN mfq_vbe_q4 from=0.0 to=2e-08
meas tran mf_ss_vbemax_q4 MAX mfq_vbe_q4 from=2e-08 to=4e-08
meas tran mf_ss_vbemin_q4 MIN mfq_vbe_q4 from=2e-08 to=4e-08
let mfq_ic_q4 = i(vic_q4)
meas tran mf_su_icmax_q4 MAX mfq_ic_q4 from=0.0 to=2e-08
meas tran mf_su_icmin_q4 MIN mfq_ic_q4 from=0.0 to=2e-08
meas tran mf_ss_icmax_q4 MAX mfq_ic_q4 from=2e-08 to=4e-08
meas tran mf_ss_icmin_q4 MIN mfq_ic_q4 from=2e-08 to=4e-08
let mfq_vce_q5 = v(c_q5)-v(x2)
meas tran mf_su_vcemax_q5 MAX mfq_vce_q5 from=0.0 to=2e-08
meas tran mf_su_vcemin_q5 MIN mfq_vce_q5 from=0.0 to=2e-08
meas tran mf_ss_vcemax_q5 MAX mfq_vce_q5 from=2e-08 to=4e-08
meas tran mf_ss_vcemin_q5 MIN mfq_vce_q5 from=2e-08 to=4e-08
let mfq_vbe_q5 = v(lo_p)-v(x2)
meas tran mf_su_vbemax_q5 MAX mfq_vbe_q5 from=0.0 to=2e-08
meas tran mf_su_vbemin_q5 MIN mfq_vbe_q5 from=0.0 to=2e-08
meas tran mf_ss_vbemax_q5 MAX mfq_vbe_q5 from=2e-08 to=4e-08
meas tran mf_ss_vbemin_q5 MIN mfq_vbe_q5 from=2e-08 to=4e-08
let mfq_ic_q5 = i(vic_q5)
meas tran mf_su_icmax_q5 MAX mfq_ic_q5 from=0.0 to=2e-08
meas tran mf_su_icmin_q5 MIN mfq_ic_q5 from=0.0 to=2e-08
meas tran mf_ss_icmax_q5 MAX mfq_ic_q5 from=2e-08 to=4e-08
meas tran mf_ss_icmin_q5 MIN mfq_ic_q5 from=2e-08 to=4e-08
let mfq_vce_q6 = v(c_q6)-v(x2)
meas tran mf_su_vcemax_q6 MAX mfq_vce_q6 from=0.0 to=2e-08
meas tran mf_su_vcemin_q6 MIN mfq_vce_q6 from=0.0 to=2e-08
meas tran mf_ss_vcemax_q6 MAX mfq_vce_q6 from=2e-08 to=4e-08
meas tran mf_ss_vcemin_q6 MIN mfq_vce_q6 from=2e-08 to=4e-08
let mfq_vbe_q6 = v(lo_n)-v(x2)
meas tran mf_su_vbemax_q6 MAX mfq_vbe_q6 from=0.0 to=2e-08
meas tran mf_su_vbemin_q6 MIN mfq_vbe_q6 from=0.0 to=2e-08
meas tran mf_ss_vbemax_q6 MAX mfq_vbe_q6 from=2e-08 to=4e-08
meas tran mf_ss_vbemin_q6 MIN mfq_vbe_q6 from=2e-08 to=4e-08
let mfq_ic_q6 = i(vic_q6)
meas tran mf_su_icmax_q6 MAX mfq_ic_q6 from=0.0 to=2e-08
meas tran mf_su_icmin_q6 MIN mfq_ic_q6 from=0.0 to=2e-08
meas tran mf_ss_icmax_q6 MAX mfq_ic_q6 from=2e-08 to=4e-08
meas tran mf_ss_icmin_q6 MIN mfq_ic_q6 from=2e-08 to=4e-08
meas tran mf_su_sinkmin_tail MIN v(tail) from=0.0 to=2e-08
meas tran mf_ss_sinkmin_tail MIN v(tail) from=2e-08 to=4e-08
print mf_su_vcemax_q1
print mf_su_vcemin_q1
print mf_ss_vcemax_q1
print mf_ss_vcemin_q1
print mf_su_vbemax_q1
print mf_su_vbemin_q1
print mf_ss_vbemax_q1
print mf_ss_vbemin_q1
print mf_su_icmax_q1
print mf_su_icmin_q1
print mf_ss_icmax_q1
print mf_ss_icmin_q1
print mf_su_vcemax_q2
print mf_su_vcemin_q2
print mf_ss_vcemax_q2
print mf_ss_vcemin_q2
print mf_su_vbemax_q2
print mf_su_vbemin_q2
print mf_ss_vbemax_q2
print mf_ss_vbemin_q2
print mf_su_icmax_q2
print mf_su_icmin_q2
print mf_ss_icmax_q2
print mf_ss_icmin_q2
print mf_su_vcemax_q3
print mf_su_vcemin_q3
print mf_ss_vcemax_q3
print mf_ss_vcemin_q3
print mf_su_vbemax_q3
print mf_su_vbemin_q3
print mf_ss_vbemax_q3
print mf_ss_vbemin_q3
print mf_su_icmax_q3
print mf_su_icmin_q3
print mf_ss_icmax_q3
print mf_ss_icmin_q3
print mf_su_vcemax_q4
print mf_su_vcemin_q4
print mf_ss_vcemax_q4
print mf_ss_vcemin_q4
print mf_su_vbemax_q4
print mf_su_vbemin_q4
print mf_ss_vbemax_q4
print mf_ss_vbemin_q4
print mf_su_icmax_q4
print mf_su_icmin_q4
print mf_ss_icmax_q4
print mf_ss_icmin_q4
print mf_su_vcemax_q5
print mf_su_vcemin_q5
print mf_ss_vcemax_q5
print mf_ss_vcemin_q5
print mf_su_vbemax_q5
print mf_su_vbemin_q5
print mf_ss_vbemax_q5
print mf_ss_vbemin_q5
print mf_su_icmax_q5
print mf_su_icmin_q5
print mf_ss_icmax_q5
print mf_ss_icmin_q5
print mf_su_vcemax_q6
print mf_su_vcemin_q6
print mf_ss_vcemax_q6
print mf_ss_vcemin_q6
print mf_su_vbemax_q6
print mf_su_vbemin_q6
print mf_ss_vbemax_q6
print mf_ss_vbemin_q6
print mf_su_icmax_q6
print mf_su_icmin_q6
print mf_ss_icmax_q6
print mf_ss_icmin_q6
print mf_su_sinkmin_tail
print mf_ss_sinkmin_tail
linearize
let mf_l = length(time)
let mfw = (time ge 1.99995e-08) * (time lt 3.99995e-08)
let mf_n = mean(mfw) * mf_l
let mfs = mf_l / mf_n
let mf_prail = mean(v(vdd) * (0 - i(vdd)) * mfw) * mfs
let mfph = 2 * pi * 16700000000.0 * (time - 2e-08)
let mf_lodiff_re = 2 * mean((v(lo_p)-v(lo_n)) * mfw * cos(mfph)) * mfs
let mf_lodiff_im = 2 * mean((v(lo_p)-v(lo_n)) * mfw * sin(mfph)) * mfs
let mfph = 2 * pi * 1000000000.0 * (time - 2e-08)
let mf_if_re = 2 * mean((v(if_out)) * mfw * cos(mfph)) * mfs
let mf_if_im = 2 * mean((v(if_out)) * mfw * sin(mfph)) * mfs
let mfph = 2 * pi * 16700000000.0 * (time - 2e-08)
let mf_loif_re = 2 * mean((v(if_out)) * mfw * cos(mfph)) * mfs
let mf_loif_im = 2 * mean((v(if_out)) * mfw * sin(mfph)) * mfs
let mfph = 2 * pi * 16700000000.0 * (time - 2e-08)
let mf_lorf_re = 2 * mean((v(rf_port)) * mfw * cos(mfph)) * mfs
let mf_lorf_im = 2 * mean((v(rf_port)) * mfw * sin(mfph)) * mfs
let mfph = 2 * pi * 950000000.0 * (time - 2e-08)
let mf_flifa_re = 2 * mean((v(if_out)) * mfw * cos(mfph)) * mfs
let mf_flifa_im = 2 * mean((v(if_out)) * mfw * sin(mfph)) * mfs
let mfph = 2 * pi * 1050000000.0 * (time - 2e-08)
let mf_flifb_re = 2 * mean((v(if_out)) * mfw * cos(mfph)) * mfs
let mf_flifb_im = 2 * mean((v(if_out)) * mfw * sin(mfph)) * mfs
let mfph = 2 * pi * 16750000000.0 * (time - 2e-08)
let mf_fllorf_re = 2 * mean((v(rf_port)) * mfw * cos(mfph)) * mfs
let mf_fllorf_im = 2 * mean((v(rf_port)) * mfw * sin(mfph)) * mfs
let mfph = 2 * pi * 16750000000.0 * (time - 2e-08)
let mf_flloif_re = 2 * mean((v(if_out)) * mfw * cos(mfph)) * mfs
let mf_flloif_im = 2 * mean((v(if_out)) * mfw * sin(mfph)) * mfs
print mf_l
print mf_n
print mf_prail
print mf_lodiff_re
print mf_lodiff_im
print mf_if_re
print mf_if_im
print mf_loif_re
print mf_loif_im
print mf_lorf_re
print mf_lorf_im
print mf_flifa_re
print mf_flifa_im
print mf_flifb_re
print mf_flifb_im
print mf_fllorf_re
print mf_fllorf_im
print mf_flloif_re
print mf_flloif_im
destroy all
echo "MFEND ls_f17p70_m12_rf66"
echo "MFRUN ls_f17p70_m9_rf60"
alterparam f1 = 17700000000.0
alterparam f2 = 17700000000.0
alterparam flo = 16700000000.0
alterparam vrf1 = 0.0006324555320336759
alterparam vrf2 = 0.0
alterparam vlo = 0.31735474306134676
reset
op
let mf_dcirail = 0 - i(vdd)
let mf_dc_vce_q1 = v(c_q1)-v(e_q1)
let mf_dc_vbe_q1 = v(b_q1)-v(e_q1)
let mf_dc_ic_q1 = i(vic_q1)
let mf_dc_vce_q2 = v(c_q2)-v(e_q2)
let mf_dc_vbe_q2 = v(b_q2)-v(e_q2)
let mf_dc_ic_q2 = i(vic_q2)
let mf_dc_vce_q3 = v(c_q3)-v(x1)
let mf_dc_vbe_q3 = v(lo_p)-v(x1)
let mf_dc_ic_q3 = i(vic_q3)
let mf_dc_vce_q4 = v(c_q4)-v(x1)
let mf_dc_vbe_q4 = v(lo_n)-v(x1)
let mf_dc_ic_q4 = i(vic_q4)
let mf_dc_vce_q5 = v(c_q5)-v(x2)
let mf_dc_vbe_q5 = v(lo_p)-v(x2)
let mf_dc_ic_q5 = i(vic_q5)
let mf_dc_vce_q6 = v(c_q6)-v(x2)
let mf_dc_vbe_q6 = v(lo_n)-v(x2)
let mf_dc_ic_q6 = i(vic_q6)
let mf_dc_sink_tail = v(tail)
print mf_dcirail
print mf_dc_vce_q1
print mf_dc_vbe_q1
print mf_dc_ic_q1
print mf_dc_vce_q2
print mf_dc_vbe_q2
print mf_dc_ic_q2
print mf_dc_vce_q3
print mf_dc_vbe_q3
print mf_dc_ic_q3
print mf_dc_vce_q4
print mf_dc_vbe_q4
print mf_dc_ic_q4
print mf_dc_vce_q5
print mf_dc_vbe_q5
print mf_dc_ic_q5
print mf_dc_vce_q6
print mf_dc_vbe_q6
print mf_dc_ic_q6
print mf_dc_sink_tail
tran 1e-12 4e-08 0 1e-12
let mfq_vce_q1 = v(c_q1)-v(e_q1)
meas tran mf_su_vcemax_q1 MAX mfq_vce_q1 from=0.0 to=2e-08
meas tran mf_su_vcemin_q1 MIN mfq_vce_q1 from=0.0 to=2e-08
meas tran mf_ss_vcemax_q1 MAX mfq_vce_q1 from=2e-08 to=4e-08
meas tran mf_ss_vcemin_q1 MIN mfq_vce_q1 from=2e-08 to=4e-08
let mfq_vbe_q1 = v(b_q1)-v(e_q1)
meas tran mf_su_vbemax_q1 MAX mfq_vbe_q1 from=0.0 to=2e-08
meas tran mf_su_vbemin_q1 MIN mfq_vbe_q1 from=0.0 to=2e-08
meas tran mf_ss_vbemax_q1 MAX mfq_vbe_q1 from=2e-08 to=4e-08
meas tran mf_ss_vbemin_q1 MIN mfq_vbe_q1 from=2e-08 to=4e-08
let mfq_ic_q1 = i(vic_q1)
meas tran mf_su_icmax_q1 MAX mfq_ic_q1 from=0.0 to=2e-08
meas tran mf_su_icmin_q1 MIN mfq_ic_q1 from=0.0 to=2e-08
meas tran mf_ss_icmax_q1 MAX mfq_ic_q1 from=2e-08 to=4e-08
meas tran mf_ss_icmin_q1 MIN mfq_ic_q1 from=2e-08 to=4e-08
let mfq_vce_q2 = v(c_q2)-v(e_q2)
meas tran mf_su_vcemax_q2 MAX mfq_vce_q2 from=0.0 to=2e-08
meas tran mf_su_vcemin_q2 MIN mfq_vce_q2 from=0.0 to=2e-08
meas tran mf_ss_vcemax_q2 MAX mfq_vce_q2 from=2e-08 to=4e-08
meas tran mf_ss_vcemin_q2 MIN mfq_vce_q2 from=2e-08 to=4e-08
let mfq_vbe_q2 = v(b_q2)-v(e_q2)
meas tran mf_su_vbemax_q2 MAX mfq_vbe_q2 from=0.0 to=2e-08
meas tran mf_su_vbemin_q2 MIN mfq_vbe_q2 from=0.0 to=2e-08
meas tran mf_ss_vbemax_q2 MAX mfq_vbe_q2 from=2e-08 to=4e-08
meas tran mf_ss_vbemin_q2 MIN mfq_vbe_q2 from=2e-08 to=4e-08
let mfq_ic_q2 = i(vic_q2)
meas tran mf_su_icmax_q2 MAX mfq_ic_q2 from=0.0 to=2e-08
meas tran mf_su_icmin_q2 MIN mfq_ic_q2 from=0.0 to=2e-08
meas tran mf_ss_icmax_q2 MAX mfq_ic_q2 from=2e-08 to=4e-08
meas tran mf_ss_icmin_q2 MIN mfq_ic_q2 from=2e-08 to=4e-08
let mfq_vce_q3 = v(c_q3)-v(x1)
meas tran mf_su_vcemax_q3 MAX mfq_vce_q3 from=0.0 to=2e-08
meas tran mf_su_vcemin_q3 MIN mfq_vce_q3 from=0.0 to=2e-08
meas tran mf_ss_vcemax_q3 MAX mfq_vce_q3 from=2e-08 to=4e-08
meas tran mf_ss_vcemin_q3 MIN mfq_vce_q3 from=2e-08 to=4e-08
let mfq_vbe_q3 = v(lo_p)-v(x1)
meas tran mf_su_vbemax_q3 MAX mfq_vbe_q3 from=0.0 to=2e-08
meas tran mf_su_vbemin_q3 MIN mfq_vbe_q3 from=0.0 to=2e-08
meas tran mf_ss_vbemax_q3 MAX mfq_vbe_q3 from=2e-08 to=4e-08
meas tran mf_ss_vbemin_q3 MIN mfq_vbe_q3 from=2e-08 to=4e-08
let mfq_ic_q3 = i(vic_q3)
meas tran mf_su_icmax_q3 MAX mfq_ic_q3 from=0.0 to=2e-08
meas tran mf_su_icmin_q3 MIN mfq_ic_q3 from=0.0 to=2e-08
meas tran mf_ss_icmax_q3 MAX mfq_ic_q3 from=2e-08 to=4e-08
meas tran mf_ss_icmin_q3 MIN mfq_ic_q3 from=2e-08 to=4e-08
let mfq_vce_q4 = v(c_q4)-v(x1)
meas tran mf_su_vcemax_q4 MAX mfq_vce_q4 from=0.0 to=2e-08
meas tran mf_su_vcemin_q4 MIN mfq_vce_q4 from=0.0 to=2e-08
meas tran mf_ss_vcemax_q4 MAX mfq_vce_q4 from=2e-08 to=4e-08
meas tran mf_ss_vcemin_q4 MIN mfq_vce_q4 from=2e-08 to=4e-08
let mfq_vbe_q4 = v(lo_n)-v(x1)
meas tran mf_su_vbemax_q4 MAX mfq_vbe_q4 from=0.0 to=2e-08
meas tran mf_su_vbemin_q4 MIN mfq_vbe_q4 from=0.0 to=2e-08
meas tran mf_ss_vbemax_q4 MAX mfq_vbe_q4 from=2e-08 to=4e-08
meas tran mf_ss_vbemin_q4 MIN mfq_vbe_q4 from=2e-08 to=4e-08
let mfq_ic_q4 = i(vic_q4)
meas tran mf_su_icmax_q4 MAX mfq_ic_q4 from=0.0 to=2e-08
meas tran mf_su_icmin_q4 MIN mfq_ic_q4 from=0.0 to=2e-08
meas tran mf_ss_icmax_q4 MAX mfq_ic_q4 from=2e-08 to=4e-08
meas tran mf_ss_icmin_q4 MIN mfq_ic_q4 from=2e-08 to=4e-08
let mfq_vce_q5 = v(c_q5)-v(x2)
meas tran mf_su_vcemax_q5 MAX mfq_vce_q5 from=0.0 to=2e-08
meas tran mf_su_vcemin_q5 MIN mfq_vce_q5 from=0.0 to=2e-08
meas tran mf_ss_vcemax_q5 MAX mfq_vce_q5 from=2e-08 to=4e-08
meas tran mf_ss_vcemin_q5 MIN mfq_vce_q5 from=2e-08 to=4e-08
let mfq_vbe_q5 = v(lo_p)-v(x2)
meas tran mf_su_vbemax_q5 MAX mfq_vbe_q5 from=0.0 to=2e-08
meas tran mf_su_vbemin_q5 MIN mfq_vbe_q5 from=0.0 to=2e-08
meas tran mf_ss_vbemax_q5 MAX mfq_vbe_q5 from=2e-08 to=4e-08
meas tran mf_ss_vbemin_q5 MIN mfq_vbe_q5 from=2e-08 to=4e-08
let mfq_ic_q5 = i(vic_q5)
meas tran mf_su_icmax_q5 MAX mfq_ic_q5 from=0.0 to=2e-08
meas tran mf_su_icmin_q5 MIN mfq_ic_q5 from=0.0 to=2e-08
meas tran mf_ss_icmax_q5 MAX mfq_ic_q5 from=2e-08 to=4e-08
meas tran mf_ss_icmin_q5 MIN mfq_ic_q5 from=2e-08 to=4e-08
let mfq_vce_q6 = v(c_q6)-v(x2)
meas tran mf_su_vcemax_q6 MAX mfq_vce_q6 from=0.0 to=2e-08
meas tran mf_su_vcemin_q6 MIN mfq_vce_q6 from=0.0 to=2e-08
meas tran mf_ss_vcemax_q6 MAX mfq_vce_q6 from=2e-08 to=4e-08
meas tran mf_ss_vcemin_q6 MIN mfq_vce_q6 from=2e-08 to=4e-08
let mfq_vbe_q6 = v(lo_n)-v(x2)
meas tran mf_su_vbemax_q6 MAX mfq_vbe_q6 from=0.0 to=2e-08
meas tran mf_su_vbemin_q6 MIN mfq_vbe_q6 from=0.0 to=2e-08
meas tran mf_ss_vbemax_q6 MAX mfq_vbe_q6 from=2e-08 to=4e-08
meas tran mf_ss_vbemin_q6 MIN mfq_vbe_q6 from=2e-08 to=4e-08
let mfq_ic_q6 = i(vic_q6)
meas tran mf_su_icmax_q6 MAX mfq_ic_q6 from=0.0 to=2e-08
meas tran mf_su_icmin_q6 MIN mfq_ic_q6 from=0.0 to=2e-08
meas tran mf_ss_icmax_q6 MAX mfq_ic_q6 from=2e-08 to=4e-08
meas tran mf_ss_icmin_q6 MIN mfq_ic_q6 from=2e-08 to=4e-08
meas tran mf_su_sinkmin_tail MIN v(tail) from=0.0 to=2e-08
meas tran mf_ss_sinkmin_tail MIN v(tail) from=2e-08 to=4e-08
print mf_su_vcemax_q1
print mf_su_vcemin_q1
print mf_ss_vcemax_q1
print mf_ss_vcemin_q1
print mf_su_vbemax_q1
print mf_su_vbemin_q1
print mf_ss_vbemax_q1
print mf_ss_vbemin_q1
print mf_su_icmax_q1
print mf_su_icmin_q1
print mf_ss_icmax_q1
print mf_ss_icmin_q1
print mf_su_vcemax_q2
print mf_su_vcemin_q2
print mf_ss_vcemax_q2
print mf_ss_vcemin_q2
print mf_su_vbemax_q2
print mf_su_vbemin_q2
print mf_ss_vbemax_q2
print mf_ss_vbemin_q2
print mf_su_icmax_q2
print mf_su_icmin_q2
print mf_ss_icmax_q2
print mf_ss_icmin_q2
print mf_su_vcemax_q3
print mf_su_vcemin_q3
print mf_ss_vcemax_q3
print mf_ss_vcemin_q3
print mf_su_vbemax_q3
print mf_su_vbemin_q3
print mf_ss_vbemax_q3
print mf_ss_vbemin_q3
print mf_su_icmax_q3
print mf_su_icmin_q3
print mf_ss_icmax_q3
print mf_ss_icmin_q3
print mf_su_vcemax_q4
print mf_su_vcemin_q4
print mf_ss_vcemax_q4
print mf_ss_vcemin_q4
print mf_su_vbemax_q4
print mf_su_vbemin_q4
print mf_ss_vbemax_q4
print mf_ss_vbemin_q4
print mf_su_icmax_q4
print mf_su_icmin_q4
print mf_ss_icmax_q4
print mf_ss_icmin_q4
print mf_su_vcemax_q5
print mf_su_vcemin_q5
print mf_ss_vcemax_q5
print mf_ss_vcemin_q5
print mf_su_vbemax_q5
print mf_su_vbemin_q5
print mf_ss_vbemax_q5
print mf_ss_vbemin_q5
print mf_su_icmax_q5
print mf_su_icmin_q5
print mf_ss_icmax_q5
print mf_ss_icmin_q5
print mf_su_vcemax_q6
print mf_su_vcemin_q6
print mf_ss_vcemax_q6
print mf_ss_vcemin_q6
print mf_su_vbemax_q6
print mf_su_vbemin_q6
print mf_ss_vbemax_q6
print mf_ss_vbemin_q6
print mf_su_icmax_q6
print mf_su_icmin_q6
print mf_ss_icmax_q6
print mf_ss_icmin_q6
print mf_su_sinkmin_tail
print mf_ss_sinkmin_tail
linearize
let mf_l = length(time)
let mfw = (time ge 1.99995e-08) * (time lt 3.99995e-08)
let mf_n = mean(mfw) * mf_l
let mfs = mf_l / mf_n
let mf_prail = mean(v(vdd) * (0 - i(vdd)) * mfw) * mfs
let mfph = 2 * pi * 16700000000.0 * (time - 2e-08)
let mf_lodiff_re = 2 * mean((v(lo_p)-v(lo_n)) * mfw * cos(mfph)) * mfs
let mf_lodiff_im = 2 * mean((v(lo_p)-v(lo_n)) * mfw * sin(mfph)) * mfs
let mfph = 2 * pi * 1000000000.0 * (time - 2e-08)
let mf_if_re = 2 * mean((v(if_out)) * mfw * cos(mfph)) * mfs
let mf_if_im = 2 * mean((v(if_out)) * mfw * sin(mfph)) * mfs
let mfph = 2 * pi * 16700000000.0 * (time - 2e-08)
let mf_loif_re = 2 * mean((v(if_out)) * mfw * cos(mfph)) * mfs
let mf_loif_im = 2 * mean((v(if_out)) * mfw * sin(mfph)) * mfs
let mfph = 2 * pi * 16700000000.0 * (time - 2e-08)
let mf_lorf_re = 2 * mean((v(rf_port)) * mfw * cos(mfph)) * mfs
let mf_lorf_im = 2 * mean((v(rf_port)) * mfw * sin(mfph)) * mfs
let mfph = 2 * pi * 950000000.0 * (time - 2e-08)
let mf_flifa_re = 2 * mean((v(if_out)) * mfw * cos(mfph)) * mfs
let mf_flifa_im = 2 * mean((v(if_out)) * mfw * sin(mfph)) * mfs
let mfph = 2 * pi * 1050000000.0 * (time - 2e-08)
let mf_flifb_re = 2 * mean((v(if_out)) * mfw * cos(mfph)) * mfs
let mf_flifb_im = 2 * mean((v(if_out)) * mfw * sin(mfph)) * mfs
let mfph = 2 * pi * 16750000000.0 * (time - 2e-08)
let mf_fllorf_re = 2 * mean((v(rf_port)) * mfw * cos(mfph)) * mfs
let mf_fllorf_im = 2 * mean((v(rf_port)) * mfw * sin(mfph)) * mfs
let mfph = 2 * pi * 16750000000.0 * (time - 2e-08)
let mf_flloif_re = 2 * mean((v(if_out)) * mfw * cos(mfph)) * mfs
let mf_flloif_im = 2 * mean((v(if_out)) * mfw * sin(mfph)) * mfs
print mf_l
print mf_n
print mf_prail
print mf_lodiff_re
print mf_lodiff_im
print mf_if_re
print mf_if_im
print mf_loif_re
print mf_loif_im
print mf_lorf_re
print mf_lorf_im
print mf_flifa_re
print mf_flifa_im
print mf_flifb_re
print mf_flifb_im
print mf_fllorf_re
print mf_fllorf_im
print mf_flloif_re
print mf_flloif_im
destroy all
echo "MFEND ls_f17p70_m9_rf60"
echo "MFRUN ls_f17p70_m9_rf66"
alterparam f1 = 17700000000.0
alterparam f2 = 17700000000.0
alterparam flo = 16700000000.0
alterparam vrf1 = 0.00031697863849222284
alterparam vrf2 = 0.0
alterparam vlo = 0.31735474306134676
reset
op
let mf_dcirail = 0 - i(vdd)
let mf_dc_vce_q1 = v(c_q1)-v(e_q1)
let mf_dc_vbe_q1 = v(b_q1)-v(e_q1)
let mf_dc_ic_q1 = i(vic_q1)
let mf_dc_vce_q2 = v(c_q2)-v(e_q2)
let mf_dc_vbe_q2 = v(b_q2)-v(e_q2)
let mf_dc_ic_q2 = i(vic_q2)
let mf_dc_vce_q3 = v(c_q3)-v(x1)
let mf_dc_vbe_q3 = v(lo_p)-v(x1)
let mf_dc_ic_q3 = i(vic_q3)
let mf_dc_vce_q4 = v(c_q4)-v(x1)
let mf_dc_vbe_q4 = v(lo_n)-v(x1)
let mf_dc_ic_q4 = i(vic_q4)
let mf_dc_vce_q5 = v(c_q5)-v(x2)
let mf_dc_vbe_q5 = v(lo_p)-v(x2)
let mf_dc_ic_q5 = i(vic_q5)
let mf_dc_vce_q6 = v(c_q6)-v(x2)
let mf_dc_vbe_q6 = v(lo_n)-v(x2)
let mf_dc_ic_q6 = i(vic_q6)
let mf_dc_sink_tail = v(tail)
print mf_dcirail
print mf_dc_vce_q1
print mf_dc_vbe_q1
print mf_dc_ic_q1
print mf_dc_vce_q2
print mf_dc_vbe_q2
print mf_dc_ic_q2
print mf_dc_vce_q3
print mf_dc_vbe_q3
print mf_dc_ic_q3
print mf_dc_vce_q4
print mf_dc_vbe_q4
print mf_dc_ic_q4
print mf_dc_vce_q5
print mf_dc_vbe_q5
print mf_dc_ic_q5
print mf_dc_vce_q6
print mf_dc_vbe_q6
print mf_dc_ic_q6
print mf_dc_sink_tail
tran 1e-12 4e-08 0 1e-12
let mfq_vce_q1 = v(c_q1)-v(e_q1)
meas tran mf_su_vcemax_q1 MAX mfq_vce_q1 from=0.0 to=2e-08
meas tran mf_su_vcemin_q1 MIN mfq_vce_q1 from=0.0 to=2e-08
meas tran mf_ss_vcemax_q1 MAX mfq_vce_q1 from=2e-08 to=4e-08
meas tran mf_ss_vcemin_q1 MIN mfq_vce_q1 from=2e-08 to=4e-08
let mfq_vbe_q1 = v(b_q1)-v(e_q1)
meas tran mf_su_vbemax_q1 MAX mfq_vbe_q1 from=0.0 to=2e-08
meas tran mf_su_vbemin_q1 MIN mfq_vbe_q1 from=0.0 to=2e-08
meas tran mf_ss_vbemax_q1 MAX mfq_vbe_q1 from=2e-08 to=4e-08
meas tran mf_ss_vbemin_q1 MIN mfq_vbe_q1 from=2e-08 to=4e-08
let mfq_ic_q1 = i(vic_q1)
meas tran mf_su_icmax_q1 MAX mfq_ic_q1 from=0.0 to=2e-08
meas tran mf_su_icmin_q1 MIN mfq_ic_q1 from=0.0 to=2e-08
meas tran mf_ss_icmax_q1 MAX mfq_ic_q1 from=2e-08 to=4e-08
meas tran mf_ss_icmin_q1 MIN mfq_ic_q1 from=2e-08 to=4e-08
let mfq_vce_q2 = v(c_q2)-v(e_q2)
meas tran mf_su_vcemax_q2 MAX mfq_vce_q2 from=0.0 to=2e-08
meas tran mf_su_vcemin_q2 MIN mfq_vce_q2 from=0.0 to=2e-08
meas tran mf_ss_vcemax_q2 MAX mfq_vce_q2 from=2e-08 to=4e-08
meas tran mf_ss_vcemin_q2 MIN mfq_vce_q2 from=2e-08 to=4e-08
let mfq_vbe_q2 = v(b_q2)-v(e_q2)
meas tran mf_su_vbemax_q2 MAX mfq_vbe_q2 from=0.0 to=2e-08
meas tran mf_su_vbemin_q2 MIN mfq_vbe_q2 from=0.0 to=2e-08
meas tran mf_ss_vbemax_q2 MAX mfq_vbe_q2 from=2e-08 to=4e-08
meas tran mf_ss_vbemin_q2 MIN mfq_vbe_q2 from=2e-08 to=4e-08
let mfq_ic_q2 = i(vic_q2)
meas tran mf_su_icmax_q2 MAX mfq_ic_q2 from=0.0 to=2e-08
meas tran mf_su_icmin_q2 MIN mfq_ic_q2 from=0.0 to=2e-08
meas tran mf_ss_icmax_q2 MAX mfq_ic_q2 from=2e-08 to=4e-08
meas tran mf_ss_icmin_q2 MIN mfq_ic_q2 from=2e-08 to=4e-08
let mfq_vce_q3 = v(c_q3)-v(x1)
meas tran mf_su_vcemax_q3 MAX mfq_vce_q3 from=0.0 to=2e-08
meas tran mf_su_vcemin_q3 MIN mfq_vce_q3 from=0.0 to=2e-08
meas tran mf_ss_vcemax_q3 MAX mfq_vce_q3 from=2e-08 to=4e-08
meas tran mf_ss_vcemin_q3 MIN mfq_vce_q3 from=2e-08 to=4e-08
let mfq_vbe_q3 = v(lo_p)-v(x1)
meas tran mf_su_vbemax_q3 MAX mfq_vbe_q3 from=0.0 to=2e-08
meas tran mf_su_vbemin_q3 MIN mfq_vbe_q3 from=0.0 to=2e-08
meas tran mf_ss_vbemax_q3 MAX mfq_vbe_q3 from=2e-08 to=4e-08
meas tran mf_ss_vbemin_q3 MIN mfq_vbe_q3 from=2e-08 to=4e-08
let mfq_ic_q3 = i(vic_q3)
meas tran mf_su_icmax_q3 MAX mfq_ic_q3 from=0.0 to=2e-08
meas tran mf_su_icmin_q3 MIN mfq_ic_q3 from=0.0 to=2e-08
meas tran mf_ss_icmax_q3 MAX mfq_ic_q3 from=2e-08 to=4e-08
meas tran mf_ss_icmin_q3 MIN mfq_ic_q3 from=2e-08 to=4e-08
let mfq_vce_q4 = v(c_q4)-v(x1)
meas tran mf_su_vcemax_q4 MAX mfq_vce_q4 from=0.0 to=2e-08
meas tran mf_su_vcemin_q4 MIN mfq_vce_q4 from=0.0 to=2e-08
meas tran mf_ss_vcemax_q4 MAX mfq_vce_q4 from=2e-08 to=4e-08
meas tran mf_ss_vcemin_q4 MIN mfq_vce_q4 from=2e-08 to=4e-08
let mfq_vbe_q4 = v(lo_n)-v(x1)
meas tran mf_su_vbemax_q4 MAX mfq_vbe_q4 from=0.0 to=2e-08
meas tran mf_su_vbemin_q4 MIN mfq_vbe_q4 from=0.0 to=2e-08
meas tran mf_ss_vbemax_q4 MAX mfq_vbe_q4 from=2e-08 to=4e-08
meas tran mf_ss_vbemin_q4 MIN mfq_vbe_q4 from=2e-08 to=4e-08
let mfq_ic_q4 = i(vic_q4)
meas tran mf_su_icmax_q4 MAX mfq_ic_q4 from=0.0 to=2e-08
meas tran mf_su_icmin_q4 MIN mfq_ic_q4 from=0.0 to=2e-08
meas tran mf_ss_icmax_q4 MAX mfq_ic_q4 from=2e-08 to=4e-08
meas tran mf_ss_icmin_q4 MIN mfq_ic_q4 from=2e-08 to=4e-08
let mfq_vce_q5 = v(c_q5)-v(x2)
meas tran mf_su_vcemax_q5 MAX mfq_vce_q5 from=0.0 to=2e-08
meas tran mf_su_vcemin_q5 MIN mfq_vce_q5 from=0.0 to=2e-08
meas tran mf_ss_vcemax_q5 MAX mfq_vce_q5 from=2e-08 to=4e-08
meas tran mf_ss_vcemin_q5 MIN mfq_vce_q5 from=2e-08 to=4e-08
let mfq_vbe_q5 = v(lo_p)-v(x2)
meas tran mf_su_vbemax_q5 MAX mfq_vbe_q5 from=0.0 to=2e-08
meas tran mf_su_vbemin_q5 MIN mfq_vbe_q5 from=0.0 to=2e-08
meas tran mf_ss_vbemax_q5 MAX mfq_vbe_q5 from=2e-08 to=4e-08
meas tran mf_ss_vbemin_q5 MIN mfq_vbe_q5 from=2e-08 to=4e-08
let mfq_ic_q5 = i(vic_q5)
meas tran mf_su_icmax_q5 MAX mfq_ic_q5 from=0.0 to=2e-08
meas tran mf_su_icmin_q5 MIN mfq_ic_q5 from=0.0 to=2e-08
meas tran mf_ss_icmax_q5 MAX mfq_ic_q5 from=2e-08 to=4e-08
meas tran mf_ss_icmin_q5 MIN mfq_ic_q5 from=2e-08 to=4e-08
let mfq_vce_q6 = v(c_q6)-v(x2)
meas tran mf_su_vcemax_q6 MAX mfq_vce_q6 from=0.0 to=2e-08
meas tran mf_su_vcemin_q6 MIN mfq_vce_q6 from=0.0 to=2e-08
meas tran mf_ss_vcemax_q6 MAX mfq_vce_q6 from=2e-08 to=4e-08
meas tran mf_ss_vcemin_q6 MIN mfq_vce_q6 from=2e-08 to=4e-08
let mfq_vbe_q6 = v(lo_n)-v(x2)
meas tran mf_su_vbemax_q6 MAX mfq_vbe_q6 from=0.0 to=2e-08
meas tran mf_su_vbemin_q6 MIN mfq_vbe_q6 from=0.0 to=2e-08
meas tran mf_ss_vbemax_q6 MAX mfq_vbe_q6 from=2e-08 to=4e-08
meas tran mf_ss_vbemin_q6 MIN mfq_vbe_q6 from=2e-08 to=4e-08
let mfq_ic_q6 = i(vic_q6)
meas tran mf_su_icmax_q6 MAX mfq_ic_q6 from=0.0 to=2e-08
meas tran mf_su_icmin_q6 MIN mfq_ic_q6 from=0.0 to=2e-08
meas tran mf_ss_icmax_q6 MAX mfq_ic_q6 from=2e-08 to=4e-08
meas tran mf_ss_icmin_q6 MIN mfq_ic_q6 from=2e-08 to=4e-08
meas tran mf_su_sinkmin_tail MIN v(tail) from=0.0 to=2e-08
meas tran mf_ss_sinkmin_tail MIN v(tail) from=2e-08 to=4e-08
print mf_su_vcemax_q1
print mf_su_vcemin_q1
print mf_ss_vcemax_q1
print mf_ss_vcemin_q1
print mf_su_vbemax_q1
print mf_su_vbemin_q1
print mf_ss_vbemax_q1
print mf_ss_vbemin_q1
print mf_su_icmax_q1
print mf_su_icmin_q1
print mf_ss_icmax_q1
print mf_ss_icmin_q1
print mf_su_vcemax_q2
print mf_su_vcemin_q2
print mf_ss_vcemax_q2
print mf_ss_vcemin_q2
print mf_su_vbemax_q2
print mf_su_vbemin_q2
print mf_ss_vbemax_q2
print mf_ss_vbemin_q2
print mf_su_icmax_q2
print mf_su_icmin_q2
print mf_ss_icmax_q2
print mf_ss_icmin_q2
print mf_su_vcemax_q3
print mf_su_vcemin_q3
print mf_ss_vcemax_q3
print mf_ss_vcemin_q3
print mf_su_vbemax_q3
print mf_su_vbemin_q3
print mf_ss_vbemax_q3
print mf_ss_vbemin_q3
print mf_su_icmax_q3
print mf_su_icmin_q3
print mf_ss_icmax_q3
print mf_ss_icmin_q3
print mf_su_vcemax_q4
print mf_su_vcemin_q4
print mf_ss_vcemax_q4
print mf_ss_vcemin_q4
print mf_su_vbemax_q4
print mf_su_vbemin_q4
print mf_ss_vbemax_q4
print mf_ss_vbemin_q4
print mf_su_icmax_q4
print mf_su_icmin_q4
print mf_ss_icmax_q4
print mf_ss_icmin_q4
print mf_su_vcemax_q5
print mf_su_vcemin_q5
print mf_ss_vcemax_q5
print mf_ss_vcemin_q5
print mf_su_vbemax_q5
print mf_su_vbemin_q5
print mf_ss_vbemax_q5
print mf_ss_vbemin_q5
print mf_su_icmax_q5
print mf_su_icmin_q5
print mf_ss_icmax_q5
print mf_ss_icmin_q5
print mf_su_vcemax_q6
print mf_su_vcemin_q6
print mf_ss_vcemax_q6
print mf_ss_vcemin_q6
print mf_su_vbemax_q6
print mf_su_vbemin_q6
print mf_ss_vbemax_q6
print mf_ss_vbemin_q6
print mf_su_icmax_q6
print mf_su_icmin_q6
print mf_ss_icmax_q6
print mf_ss_icmin_q6
print mf_su_sinkmin_tail
print mf_ss_sinkmin_tail
linearize
let mf_l = length(time)
let mfw = (time ge 1.99995e-08) * (time lt 3.99995e-08)
let mf_n = mean(mfw) * mf_l
let mfs = mf_l / mf_n
let mf_prail = mean(v(vdd) * (0 - i(vdd)) * mfw) * mfs
let mfph = 2 * pi * 16700000000.0 * (time - 2e-08)
let mf_lodiff_re = 2 * mean((v(lo_p)-v(lo_n)) * mfw * cos(mfph)) * mfs
let mf_lodiff_im = 2 * mean((v(lo_p)-v(lo_n)) * mfw * sin(mfph)) * mfs
let mfph = 2 * pi * 1000000000.0 * (time - 2e-08)
let mf_if_re = 2 * mean((v(if_out)) * mfw * cos(mfph)) * mfs
let mf_if_im = 2 * mean((v(if_out)) * mfw * sin(mfph)) * mfs
let mfph = 2 * pi * 16700000000.0 * (time - 2e-08)
let mf_loif_re = 2 * mean((v(if_out)) * mfw * cos(mfph)) * mfs
let mf_loif_im = 2 * mean((v(if_out)) * mfw * sin(mfph)) * mfs
let mfph = 2 * pi * 16700000000.0 * (time - 2e-08)
let mf_lorf_re = 2 * mean((v(rf_port)) * mfw * cos(mfph)) * mfs
let mf_lorf_im = 2 * mean((v(rf_port)) * mfw * sin(mfph)) * mfs
let mfph = 2 * pi * 950000000.0 * (time - 2e-08)
let mf_flifa_re = 2 * mean((v(if_out)) * mfw * cos(mfph)) * mfs
let mf_flifa_im = 2 * mean((v(if_out)) * mfw * sin(mfph)) * mfs
let mfph = 2 * pi * 1050000000.0 * (time - 2e-08)
let mf_flifb_re = 2 * mean((v(if_out)) * mfw * cos(mfph)) * mfs
let mf_flifb_im = 2 * mean((v(if_out)) * mfw * sin(mfph)) * mfs
let mfph = 2 * pi * 16750000000.0 * (time - 2e-08)
let mf_fllorf_re = 2 * mean((v(rf_port)) * mfw * cos(mfph)) * mfs
let mf_fllorf_im = 2 * mean((v(rf_port)) * mfw * sin(mfph)) * mfs
let mfph = 2 * pi * 16750000000.0 * (time - 2e-08)
let mf_flloif_re = 2 * mean((v(if_out)) * mfw * cos(mfph)) * mfs
let mf_flloif_im = 2 * mean((v(if_out)) * mfw * sin(mfph)) * mfs
print mf_l
print mf_n
print mf_prail
print mf_lodiff_re
print mf_lodiff_im
print mf_if_re
print mf_if_im
print mf_loif_re
print mf_loif_im
print mf_lorf_re
print mf_lorf_im
print mf_flifa_re
print mf_flifa_im
print mf_flifb_re
print mf_flifb_im
print mf_fllorf_re
print mf_fllorf_im
print mf_flloif_re
print mf_flloif_im
destroy all
echo "MFEND ls_f17p70_m9_rf66"
echo "MFRUN ls_f17p70_m6_rf60"
alterparam f1 = 17700000000.0
alterparam f2 = 17700000000.0
alterparam flo = 16700000000.0
alterparam vrf1 = 0.0006324555320336759
alterparam vrf2 = 0.0
alterparam vlo = 0.44827548953825974
reset
op
let mf_dcirail = 0 - i(vdd)
let mf_dc_vce_q1 = v(c_q1)-v(e_q1)
let mf_dc_vbe_q1 = v(b_q1)-v(e_q1)
let mf_dc_ic_q1 = i(vic_q1)
let mf_dc_vce_q2 = v(c_q2)-v(e_q2)
let mf_dc_vbe_q2 = v(b_q2)-v(e_q2)
let mf_dc_ic_q2 = i(vic_q2)
let mf_dc_vce_q3 = v(c_q3)-v(x1)
let mf_dc_vbe_q3 = v(lo_p)-v(x1)
let mf_dc_ic_q3 = i(vic_q3)
let mf_dc_vce_q4 = v(c_q4)-v(x1)
let mf_dc_vbe_q4 = v(lo_n)-v(x1)
let mf_dc_ic_q4 = i(vic_q4)
let mf_dc_vce_q5 = v(c_q5)-v(x2)
let mf_dc_vbe_q5 = v(lo_p)-v(x2)
let mf_dc_ic_q5 = i(vic_q5)
let mf_dc_vce_q6 = v(c_q6)-v(x2)
let mf_dc_vbe_q6 = v(lo_n)-v(x2)
let mf_dc_ic_q6 = i(vic_q6)
let mf_dc_sink_tail = v(tail)
print mf_dcirail
print mf_dc_vce_q1
print mf_dc_vbe_q1
print mf_dc_ic_q1
print mf_dc_vce_q2
print mf_dc_vbe_q2
print mf_dc_ic_q2
print mf_dc_vce_q3
print mf_dc_vbe_q3
print mf_dc_ic_q3
print mf_dc_vce_q4
print mf_dc_vbe_q4
print mf_dc_ic_q4
print mf_dc_vce_q5
print mf_dc_vbe_q5
print mf_dc_ic_q5
print mf_dc_vce_q6
print mf_dc_vbe_q6
print mf_dc_ic_q6
print mf_dc_sink_tail
tran 1e-12 4e-08 0 1e-12
let mfq_vce_q1 = v(c_q1)-v(e_q1)
meas tran mf_su_vcemax_q1 MAX mfq_vce_q1 from=0.0 to=2e-08
meas tran mf_su_vcemin_q1 MIN mfq_vce_q1 from=0.0 to=2e-08
meas tran mf_ss_vcemax_q1 MAX mfq_vce_q1 from=2e-08 to=4e-08
meas tran mf_ss_vcemin_q1 MIN mfq_vce_q1 from=2e-08 to=4e-08
let mfq_vbe_q1 = v(b_q1)-v(e_q1)
meas tran mf_su_vbemax_q1 MAX mfq_vbe_q1 from=0.0 to=2e-08
meas tran mf_su_vbemin_q1 MIN mfq_vbe_q1 from=0.0 to=2e-08
meas tran mf_ss_vbemax_q1 MAX mfq_vbe_q1 from=2e-08 to=4e-08
meas tran mf_ss_vbemin_q1 MIN mfq_vbe_q1 from=2e-08 to=4e-08
let mfq_ic_q1 = i(vic_q1)
meas tran mf_su_icmax_q1 MAX mfq_ic_q1 from=0.0 to=2e-08
meas tran mf_su_icmin_q1 MIN mfq_ic_q1 from=0.0 to=2e-08
meas tran mf_ss_icmax_q1 MAX mfq_ic_q1 from=2e-08 to=4e-08
meas tran mf_ss_icmin_q1 MIN mfq_ic_q1 from=2e-08 to=4e-08
let mfq_vce_q2 = v(c_q2)-v(e_q2)
meas tran mf_su_vcemax_q2 MAX mfq_vce_q2 from=0.0 to=2e-08
meas tran mf_su_vcemin_q2 MIN mfq_vce_q2 from=0.0 to=2e-08
meas tran mf_ss_vcemax_q2 MAX mfq_vce_q2 from=2e-08 to=4e-08
meas tran mf_ss_vcemin_q2 MIN mfq_vce_q2 from=2e-08 to=4e-08
let mfq_vbe_q2 = v(b_q2)-v(e_q2)
meas tran mf_su_vbemax_q2 MAX mfq_vbe_q2 from=0.0 to=2e-08
meas tran mf_su_vbemin_q2 MIN mfq_vbe_q2 from=0.0 to=2e-08
meas tran mf_ss_vbemax_q2 MAX mfq_vbe_q2 from=2e-08 to=4e-08
meas tran mf_ss_vbemin_q2 MIN mfq_vbe_q2 from=2e-08 to=4e-08
let mfq_ic_q2 = i(vic_q2)
meas tran mf_su_icmax_q2 MAX mfq_ic_q2 from=0.0 to=2e-08
meas tran mf_su_icmin_q2 MIN mfq_ic_q2 from=0.0 to=2e-08
meas tran mf_ss_icmax_q2 MAX mfq_ic_q2 from=2e-08 to=4e-08
meas tran mf_ss_icmin_q2 MIN mfq_ic_q2 from=2e-08 to=4e-08
let mfq_vce_q3 = v(c_q3)-v(x1)
meas tran mf_su_vcemax_q3 MAX mfq_vce_q3 from=0.0 to=2e-08
meas tran mf_su_vcemin_q3 MIN mfq_vce_q3 from=0.0 to=2e-08
meas tran mf_ss_vcemax_q3 MAX mfq_vce_q3 from=2e-08 to=4e-08
meas tran mf_ss_vcemin_q3 MIN mfq_vce_q3 from=2e-08 to=4e-08
let mfq_vbe_q3 = v(lo_p)-v(x1)
meas tran mf_su_vbemax_q3 MAX mfq_vbe_q3 from=0.0 to=2e-08
meas tran mf_su_vbemin_q3 MIN mfq_vbe_q3 from=0.0 to=2e-08
meas tran mf_ss_vbemax_q3 MAX mfq_vbe_q3 from=2e-08 to=4e-08
meas tran mf_ss_vbemin_q3 MIN mfq_vbe_q3 from=2e-08 to=4e-08
let mfq_ic_q3 = i(vic_q3)
meas tran mf_su_icmax_q3 MAX mfq_ic_q3 from=0.0 to=2e-08
meas tran mf_su_icmin_q3 MIN mfq_ic_q3 from=0.0 to=2e-08
meas tran mf_ss_icmax_q3 MAX mfq_ic_q3 from=2e-08 to=4e-08
meas tran mf_ss_icmin_q3 MIN mfq_ic_q3 from=2e-08 to=4e-08
let mfq_vce_q4 = v(c_q4)-v(x1)
meas tran mf_su_vcemax_q4 MAX mfq_vce_q4 from=0.0 to=2e-08
meas tran mf_su_vcemin_q4 MIN mfq_vce_q4 from=0.0 to=2e-08
meas tran mf_ss_vcemax_q4 MAX mfq_vce_q4 from=2e-08 to=4e-08
meas tran mf_ss_vcemin_q4 MIN mfq_vce_q4 from=2e-08 to=4e-08
let mfq_vbe_q4 = v(lo_n)-v(x1)
meas tran mf_su_vbemax_q4 MAX mfq_vbe_q4 from=0.0 to=2e-08
meas tran mf_su_vbemin_q4 MIN mfq_vbe_q4 from=0.0 to=2e-08
meas tran mf_ss_vbemax_q4 MAX mfq_vbe_q4 from=2e-08 to=4e-08
meas tran mf_ss_vbemin_q4 MIN mfq_vbe_q4 from=2e-08 to=4e-08
let mfq_ic_q4 = i(vic_q4)
meas tran mf_su_icmax_q4 MAX mfq_ic_q4 from=0.0 to=2e-08
meas tran mf_su_icmin_q4 MIN mfq_ic_q4 from=0.0 to=2e-08
meas tran mf_ss_icmax_q4 MAX mfq_ic_q4 from=2e-08 to=4e-08
meas tran mf_ss_icmin_q4 MIN mfq_ic_q4 from=2e-08 to=4e-08
let mfq_vce_q5 = v(c_q5)-v(x2)
meas tran mf_su_vcemax_q5 MAX mfq_vce_q5 from=0.0 to=2e-08
meas tran mf_su_vcemin_q5 MIN mfq_vce_q5 from=0.0 to=2e-08
meas tran mf_ss_vcemax_q5 MAX mfq_vce_q5 from=2e-08 to=4e-08
meas tran mf_ss_vcemin_q5 MIN mfq_vce_q5 from=2e-08 to=4e-08
let mfq_vbe_q5 = v(lo_p)-v(x2)
meas tran mf_su_vbemax_q5 MAX mfq_vbe_q5 from=0.0 to=2e-08
meas tran mf_su_vbemin_q5 MIN mfq_vbe_q5 from=0.0 to=2e-08
meas tran mf_ss_vbemax_q5 MAX mfq_vbe_q5 from=2e-08 to=4e-08
meas tran mf_ss_vbemin_q5 MIN mfq_vbe_q5 from=2e-08 to=4e-08
let mfq_ic_q5 = i(vic_q5)
meas tran mf_su_icmax_q5 MAX mfq_ic_q5 from=0.0 to=2e-08
meas tran mf_su_icmin_q5 MIN mfq_ic_q5 from=0.0 to=2e-08
meas tran mf_ss_icmax_q5 MAX mfq_ic_q5 from=2e-08 to=4e-08
meas tran mf_ss_icmin_q5 MIN mfq_ic_q5 from=2e-08 to=4e-08
let mfq_vce_q6 = v(c_q6)-v(x2)
meas tran mf_su_vcemax_q6 MAX mfq_vce_q6 from=0.0 to=2e-08
meas tran mf_su_vcemin_q6 MIN mfq_vce_q6 from=0.0 to=2e-08
meas tran mf_ss_vcemax_q6 MAX mfq_vce_q6 from=2e-08 to=4e-08
meas tran mf_ss_vcemin_q6 MIN mfq_vce_q6 from=2e-08 to=4e-08
let mfq_vbe_q6 = v(lo_n)-v(x2)
meas tran mf_su_vbemax_q6 MAX mfq_vbe_q6 from=0.0 to=2e-08
meas tran mf_su_vbemin_q6 MIN mfq_vbe_q6 from=0.0 to=2e-08
meas tran mf_ss_vbemax_q6 MAX mfq_vbe_q6 from=2e-08 to=4e-08
meas tran mf_ss_vbemin_q6 MIN mfq_vbe_q6 from=2e-08 to=4e-08
let mfq_ic_q6 = i(vic_q6)
meas tran mf_su_icmax_q6 MAX mfq_ic_q6 from=0.0 to=2e-08
meas tran mf_su_icmin_q6 MIN mfq_ic_q6 from=0.0 to=2e-08
meas tran mf_ss_icmax_q6 MAX mfq_ic_q6 from=2e-08 to=4e-08
meas tran mf_ss_icmin_q6 MIN mfq_ic_q6 from=2e-08 to=4e-08
meas tran mf_su_sinkmin_tail MIN v(tail) from=0.0 to=2e-08
meas tran mf_ss_sinkmin_tail MIN v(tail) from=2e-08 to=4e-08
print mf_su_vcemax_q1
print mf_su_vcemin_q1
print mf_ss_vcemax_q1
print mf_ss_vcemin_q1
print mf_su_vbemax_q1
print mf_su_vbemin_q1
print mf_ss_vbemax_q1
print mf_ss_vbemin_q1
print mf_su_icmax_q1
print mf_su_icmin_q1
print mf_ss_icmax_q1
print mf_ss_icmin_q1
print mf_su_vcemax_q2
print mf_su_vcemin_q2
print mf_ss_vcemax_q2
print mf_ss_vcemin_q2
print mf_su_vbemax_q2
print mf_su_vbemin_q2
print mf_ss_vbemax_q2
print mf_ss_vbemin_q2
print mf_su_icmax_q2
print mf_su_icmin_q2
print mf_ss_icmax_q2
print mf_ss_icmin_q2
print mf_su_vcemax_q3
print mf_su_vcemin_q3
print mf_ss_vcemax_q3
print mf_ss_vcemin_q3
print mf_su_vbemax_q3
print mf_su_vbemin_q3
print mf_ss_vbemax_q3
print mf_ss_vbemin_q3
print mf_su_icmax_q3
print mf_su_icmin_q3
print mf_ss_icmax_q3
print mf_ss_icmin_q3
print mf_su_vcemax_q4
print mf_su_vcemin_q4
print mf_ss_vcemax_q4
print mf_ss_vcemin_q4
print mf_su_vbemax_q4
print mf_su_vbemin_q4
print mf_ss_vbemax_q4
print mf_ss_vbemin_q4
print mf_su_icmax_q4
print mf_su_icmin_q4
print mf_ss_icmax_q4
print mf_ss_icmin_q4
print mf_su_vcemax_q5
print mf_su_vcemin_q5
print mf_ss_vcemax_q5
print mf_ss_vcemin_q5
print mf_su_vbemax_q5
print mf_su_vbemin_q5
print mf_ss_vbemax_q5
print mf_ss_vbemin_q5
print mf_su_icmax_q5
print mf_su_icmin_q5
print mf_ss_icmax_q5
print mf_ss_icmin_q5
print mf_su_vcemax_q6
print mf_su_vcemin_q6
print mf_ss_vcemax_q6
print mf_ss_vcemin_q6
print mf_su_vbemax_q6
print mf_su_vbemin_q6
print mf_ss_vbemax_q6
print mf_ss_vbemin_q6
print mf_su_icmax_q6
print mf_su_icmin_q6
print mf_ss_icmax_q6
print mf_ss_icmin_q6
print mf_su_sinkmin_tail
print mf_ss_sinkmin_tail
linearize
let mf_l = length(time)
let mfw = (time ge 1.99995e-08) * (time lt 3.99995e-08)
let mf_n = mean(mfw) * mf_l
let mfs = mf_l / mf_n
let mf_prail = mean(v(vdd) * (0 - i(vdd)) * mfw) * mfs
let mfph = 2 * pi * 16700000000.0 * (time - 2e-08)
let mf_lodiff_re = 2 * mean((v(lo_p)-v(lo_n)) * mfw * cos(mfph)) * mfs
let mf_lodiff_im = 2 * mean((v(lo_p)-v(lo_n)) * mfw * sin(mfph)) * mfs
let mfph = 2 * pi * 1000000000.0 * (time - 2e-08)
let mf_if_re = 2 * mean((v(if_out)) * mfw * cos(mfph)) * mfs
let mf_if_im = 2 * mean((v(if_out)) * mfw * sin(mfph)) * mfs
let mfph = 2 * pi * 16700000000.0 * (time - 2e-08)
let mf_loif_re = 2 * mean((v(if_out)) * mfw * cos(mfph)) * mfs
let mf_loif_im = 2 * mean((v(if_out)) * mfw * sin(mfph)) * mfs
let mfph = 2 * pi * 16700000000.0 * (time - 2e-08)
let mf_lorf_re = 2 * mean((v(rf_port)) * mfw * cos(mfph)) * mfs
let mf_lorf_im = 2 * mean((v(rf_port)) * mfw * sin(mfph)) * mfs
let mfph = 2 * pi * 950000000.0 * (time - 2e-08)
let mf_flifa_re = 2 * mean((v(if_out)) * mfw * cos(mfph)) * mfs
let mf_flifa_im = 2 * mean((v(if_out)) * mfw * sin(mfph)) * mfs
let mfph = 2 * pi * 1050000000.0 * (time - 2e-08)
let mf_flifb_re = 2 * mean((v(if_out)) * mfw * cos(mfph)) * mfs
let mf_flifb_im = 2 * mean((v(if_out)) * mfw * sin(mfph)) * mfs
let mfph = 2 * pi * 16750000000.0 * (time - 2e-08)
let mf_fllorf_re = 2 * mean((v(rf_port)) * mfw * cos(mfph)) * mfs
let mf_fllorf_im = 2 * mean((v(rf_port)) * mfw * sin(mfph)) * mfs
let mfph = 2 * pi * 16750000000.0 * (time - 2e-08)
let mf_flloif_re = 2 * mean((v(if_out)) * mfw * cos(mfph)) * mfs
let mf_flloif_im = 2 * mean((v(if_out)) * mfw * sin(mfph)) * mfs
print mf_l
print mf_n
print mf_prail
print mf_lodiff_re
print mf_lodiff_im
print mf_if_re
print mf_if_im
print mf_loif_re
print mf_loif_im
print mf_lorf_re
print mf_lorf_im
print mf_flifa_re
print mf_flifa_im
print mf_flifb_re
print mf_flifb_im
print mf_fllorf_re
print mf_fllorf_im
print mf_flloif_re
print mf_flloif_im
destroy all
echo "MFEND ls_f17p70_m6_rf60"
echo "MFRUN ls_f17p70_m6_rf66"
alterparam f1 = 17700000000.0
alterparam f2 = 17700000000.0
alterparam flo = 16700000000.0
alterparam vrf1 = 0.00031697863849222284
alterparam vrf2 = 0.0
alterparam vlo = 0.44827548953825974
reset
op
let mf_dcirail = 0 - i(vdd)
let mf_dc_vce_q1 = v(c_q1)-v(e_q1)
let mf_dc_vbe_q1 = v(b_q1)-v(e_q1)
let mf_dc_ic_q1 = i(vic_q1)
let mf_dc_vce_q2 = v(c_q2)-v(e_q2)
let mf_dc_vbe_q2 = v(b_q2)-v(e_q2)
let mf_dc_ic_q2 = i(vic_q2)
let mf_dc_vce_q3 = v(c_q3)-v(x1)
let mf_dc_vbe_q3 = v(lo_p)-v(x1)
let mf_dc_ic_q3 = i(vic_q3)
let mf_dc_vce_q4 = v(c_q4)-v(x1)
let mf_dc_vbe_q4 = v(lo_n)-v(x1)
let mf_dc_ic_q4 = i(vic_q4)
let mf_dc_vce_q5 = v(c_q5)-v(x2)
let mf_dc_vbe_q5 = v(lo_p)-v(x2)
let mf_dc_ic_q5 = i(vic_q5)
let mf_dc_vce_q6 = v(c_q6)-v(x2)
let mf_dc_vbe_q6 = v(lo_n)-v(x2)
let mf_dc_ic_q6 = i(vic_q6)
let mf_dc_sink_tail = v(tail)
print mf_dcirail
print mf_dc_vce_q1
print mf_dc_vbe_q1
print mf_dc_ic_q1
print mf_dc_vce_q2
print mf_dc_vbe_q2
print mf_dc_ic_q2
print mf_dc_vce_q3
print mf_dc_vbe_q3
print mf_dc_ic_q3
print mf_dc_vce_q4
print mf_dc_vbe_q4
print mf_dc_ic_q4
print mf_dc_vce_q5
print mf_dc_vbe_q5
print mf_dc_ic_q5
print mf_dc_vce_q6
print mf_dc_vbe_q6
print mf_dc_ic_q6
print mf_dc_sink_tail
tran 1e-12 4e-08 0 1e-12
let mfq_vce_q1 = v(c_q1)-v(e_q1)
meas tran mf_su_vcemax_q1 MAX mfq_vce_q1 from=0.0 to=2e-08
meas tran mf_su_vcemin_q1 MIN mfq_vce_q1 from=0.0 to=2e-08
meas tran mf_ss_vcemax_q1 MAX mfq_vce_q1 from=2e-08 to=4e-08
meas tran mf_ss_vcemin_q1 MIN mfq_vce_q1 from=2e-08 to=4e-08
let mfq_vbe_q1 = v(b_q1)-v(e_q1)
meas tran mf_su_vbemax_q1 MAX mfq_vbe_q1 from=0.0 to=2e-08
meas tran mf_su_vbemin_q1 MIN mfq_vbe_q1 from=0.0 to=2e-08
meas tran mf_ss_vbemax_q1 MAX mfq_vbe_q1 from=2e-08 to=4e-08
meas tran mf_ss_vbemin_q1 MIN mfq_vbe_q1 from=2e-08 to=4e-08
let mfq_ic_q1 = i(vic_q1)
meas tran mf_su_icmax_q1 MAX mfq_ic_q1 from=0.0 to=2e-08
meas tran mf_su_icmin_q1 MIN mfq_ic_q1 from=0.0 to=2e-08
meas tran mf_ss_icmax_q1 MAX mfq_ic_q1 from=2e-08 to=4e-08
meas tran mf_ss_icmin_q1 MIN mfq_ic_q1 from=2e-08 to=4e-08
let mfq_vce_q2 = v(c_q2)-v(e_q2)
meas tran mf_su_vcemax_q2 MAX mfq_vce_q2 from=0.0 to=2e-08
meas tran mf_su_vcemin_q2 MIN mfq_vce_q2 from=0.0 to=2e-08
meas tran mf_ss_vcemax_q2 MAX mfq_vce_q2 from=2e-08 to=4e-08
meas tran mf_ss_vcemin_q2 MIN mfq_vce_q2 from=2e-08 to=4e-08
let mfq_vbe_q2 = v(b_q2)-v(e_q2)
meas tran mf_su_vbemax_q2 MAX mfq_vbe_q2 from=0.0 to=2e-08
meas tran mf_su_vbemin_q2 MIN mfq_vbe_q2 from=0.0 to=2e-08
meas tran mf_ss_vbemax_q2 MAX mfq_vbe_q2 from=2e-08 to=4e-08
meas tran mf_ss_vbemin_q2 MIN mfq_vbe_q2 from=2e-08 to=4e-08
let mfq_ic_q2 = i(vic_q2)
meas tran mf_su_icmax_q2 MAX mfq_ic_q2 from=0.0 to=2e-08
meas tran mf_su_icmin_q2 MIN mfq_ic_q2 from=0.0 to=2e-08
meas tran mf_ss_icmax_q2 MAX mfq_ic_q2 from=2e-08 to=4e-08
meas tran mf_ss_icmin_q2 MIN mfq_ic_q2 from=2e-08 to=4e-08
let mfq_vce_q3 = v(c_q3)-v(x1)
meas tran mf_su_vcemax_q3 MAX mfq_vce_q3 from=0.0 to=2e-08
meas tran mf_su_vcemin_q3 MIN mfq_vce_q3 from=0.0 to=2e-08
meas tran mf_ss_vcemax_q3 MAX mfq_vce_q3 from=2e-08 to=4e-08
meas tran mf_ss_vcemin_q3 MIN mfq_vce_q3 from=2e-08 to=4e-08
let mfq_vbe_q3 = v(lo_p)-v(x1)
meas tran mf_su_vbemax_q3 MAX mfq_vbe_q3 from=0.0 to=2e-08
meas tran mf_su_vbemin_q3 MIN mfq_vbe_q3 from=0.0 to=2e-08
meas tran mf_ss_vbemax_q3 MAX mfq_vbe_q3 from=2e-08 to=4e-08
meas tran mf_ss_vbemin_q3 MIN mfq_vbe_q3 from=2e-08 to=4e-08
let mfq_ic_q3 = i(vic_q3)
meas tran mf_su_icmax_q3 MAX mfq_ic_q3 from=0.0 to=2e-08
meas tran mf_su_icmin_q3 MIN mfq_ic_q3 from=0.0 to=2e-08
meas tran mf_ss_icmax_q3 MAX mfq_ic_q3 from=2e-08 to=4e-08
meas tran mf_ss_icmin_q3 MIN mfq_ic_q3 from=2e-08 to=4e-08
let mfq_vce_q4 = v(c_q4)-v(x1)
meas tran mf_su_vcemax_q4 MAX mfq_vce_q4 from=0.0 to=2e-08
meas tran mf_su_vcemin_q4 MIN mfq_vce_q4 from=0.0 to=2e-08
meas tran mf_ss_vcemax_q4 MAX mfq_vce_q4 from=2e-08 to=4e-08
meas tran mf_ss_vcemin_q4 MIN mfq_vce_q4 from=2e-08 to=4e-08
let mfq_vbe_q4 = v(lo_n)-v(x1)
meas tran mf_su_vbemax_q4 MAX mfq_vbe_q4 from=0.0 to=2e-08
meas tran mf_su_vbemin_q4 MIN mfq_vbe_q4 from=0.0 to=2e-08
meas tran mf_ss_vbemax_q4 MAX mfq_vbe_q4 from=2e-08 to=4e-08
meas tran mf_ss_vbemin_q4 MIN mfq_vbe_q4 from=2e-08 to=4e-08
let mfq_ic_q4 = i(vic_q4)
meas tran mf_su_icmax_q4 MAX mfq_ic_q4 from=0.0 to=2e-08
meas tran mf_su_icmin_q4 MIN mfq_ic_q4 from=0.0 to=2e-08
meas tran mf_ss_icmax_q4 MAX mfq_ic_q4 from=2e-08 to=4e-08
meas tran mf_ss_icmin_q4 MIN mfq_ic_q4 from=2e-08 to=4e-08
let mfq_vce_q5 = v(c_q5)-v(x2)
meas tran mf_su_vcemax_q5 MAX mfq_vce_q5 from=0.0 to=2e-08
meas tran mf_su_vcemin_q5 MIN mfq_vce_q5 from=0.0 to=2e-08
meas tran mf_ss_vcemax_q5 MAX mfq_vce_q5 from=2e-08 to=4e-08
meas tran mf_ss_vcemin_q5 MIN mfq_vce_q5 from=2e-08 to=4e-08
let mfq_vbe_q5 = v(lo_p)-v(x2)
meas tran mf_su_vbemax_q5 MAX mfq_vbe_q5 from=0.0 to=2e-08
meas tran mf_su_vbemin_q5 MIN mfq_vbe_q5 from=0.0 to=2e-08
meas tran mf_ss_vbemax_q5 MAX mfq_vbe_q5 from=2e-08 to=4e-08
meas tran mf_ss_vbemin_q5 MIN mfq_vbe_q5 from=2e-08 to=4e-08
let mfq_ic_q5 = i(vic_q5)
meas tran mf_su_icmax_q5 MAX mfq_ic_q5 from=0.0 to=2e-08
meas tran mf_su_icmin_q5 MIN mfq_ic_q5 from=0.0 to=2e-08
meas tran mf_ss_icmax_q5 MAX mfq_ic_q5 from=2e-08 to=4e-08
meas tran mf_ss_icmin_q5 MIN mfq_ic_q5 from=2e-08 to=4e-08
let mfq_vce_q6 = v(c_q6)-v(x2)
meas tran mf_su_vcemax_q6 MAX mfq_vce_q6 from=0.0 to=2e-08
meas tran mf_su_vcemin_q6 MIN mfq_vce_q6 from=0.0 to=2e-08
meas tran mf_ss_vcemax_q6 MAX mfq_vce_q6 from=2e-08 to=4e-08
meas tran mf_ss_vcemin_q6 MIN mfq_vce_q6 from=2e-08 to=4e-08
let mfq_vbe_q6 = v(lo_n)-v(x2)
meas tran mf_su_vbemax_q6 MAX mfq_vbe_q6 from=0.0 to=2e-08
meas tran mf_su_vbemin_q6 MIN mfq_vbe_q6 from=0.0 to=2e-08
meas tran mf_ss_vbemax_q6 MAX mfq_vbe_q6 from=2e-08 to=4e-08
meas tran mf_ss_vbemin_q6 MIN mfq_vbe_q6 from=2e-08 to=4e-08
let mfq_ic_q6 = i(vic_q6)
meas tran mf_su_icmax_q6 MAX mfq_ic_q6 from=0.0 to=2e-08
meas tran mf_su_icmin_q6 MIN mfq_ic_q6 from=0.0 to=2e-08
meas tran mf_ss_icmax_q6 MAX mfq_ic_q6 from=2e-08 to=4e-08
meas tran mf_ss_icmin_q6 MIN mfq_ic_q6 from=2e-08 to=4e-08
meas tran mf_su_sinkmin_tail MIN v(tail) from=0.0 to=2e-08
meas tran mf_ss_sinkmin_tail MIN v(tail) from=2e-08 to=4e-08
print mf_su_vcemax_q1
print mf_su_vcemin_q1
print mf_ss_vcemax_q1
print mf_ss_vcemin_q1
print mf_su_vbemax_q1
print mf_su_vbemin_q1
print mf_ss_vbemax_q1
print mf_ss_vbemin_q1
print mf_su_icmax_q1
print mf_su_icmin_q1
print mf_ss_icmax_q1
print mf_ss_icmin_q1
print mf_su_vcemax_q2
print mf_su_vcemin_q2
print mf_ss_vcemax_q2
print mf_ss_vcemin_q2
print mf_su_vbemax_q2
print mf_su_vbemin_q2
print mf_ss_vbemax_q2
print mf_ss_vbemin_q2
print mf_su_icmax_q2
print mf_su_icmin_q2
print mf_ss_icmax_q2
print mf_ss_icmin_q2
print mf_su_vcemax_q3
print mf_su_vcemin_q3
print mf_ss_vcemax_q3
print mf_ss_vcemin_q3
print mf_su_vbemax_q3
print mf_su_vbemin_q3
print mf_ss_vbemax_q3
print mf_ss_vbemin_q3
print mf_su_icmax_q3
print mf_su_icmin_q3
print mf_ss_icmax_q3
print mf_ss_icmin_q3
print mf_su_vcemax_q4
print mf_su_vcemin_q4
print mf_ss_vcemax_q4
print mf_ss_vcemin_q4
print mf_su_vbemax_q4
print mf_su_vbemin_q4
print mf_ss_vbemax_q4
print mf_ss_vbemin_q4
print mf_su_icmax_q4
print mf_su_icmin_q4
print mf_ss_icmax_q4
print mf_ss_icmin_q4
print mf_su_vcemax_q5
print mf_su_vcemin_q5
print mf_ss_vcemax_q5
print mf_ss_vcemin_q5
print mf_su_vbemax_q5
print mf_su_vbemin_q5
print mf_ss_vbemax_q5
print mf_ss_vbemin_q5
print mf_su_icmax_q5
print mf_su_icmin_q5
print mf_ss_icmax_q5
print mf_ss_icmin_q5
print mf_su_vcemax_q6
print mf_su_vcemin_q6
print mf_ss_vcemax_q6
print mf_ss_vcemin_q6
print mf_su_vbemax_q6
print mf_su_vbemin_q6
print mf_ss_vbemax_q6
print mf_ss_vbemin_q6
print mf_su_icmax_q6
print mf_su_icmin_q6
print mf_ss_icmax_q6
print mf_ss_icmin_q6
print mf_su_sinkmin_tail
print mf_ss_sinkmin_tail
linearize
let mf_l = length(time)
let mfw = (time ge 1.99995e-08) * (time lt 3.99995e-08)
let mf_n = mean(mfw) * mf_l
let mfs = mf_l / mf_n
let mf_prail = mean(v(vdd) * (0 - i(vdd)) * mfw) * mfs
let mfph = 2 * pi * 16700000000.0 * (time - 2e-08)
let mf_lodiff_re = 2 * mean((v(lo_p)-v(lo_n)) * mfw * cos(mfph)) * mfs
let mf_lodiff_im = 2 * mean((v(lo_p)-v(lo_n)) * mfw * sin(mfph)) * mfs
let mfph = 2 * pi * 1000000000.0 * (time - 2e-08)
let mf_if_re = 2 * mean((v(if_out)) * mfw * cos(mfph)) * mfs
let mf_if_im = 2 * mean((v(if_out)) * mfw * sin(mfph)) * mfs
let mfph = 2 * pi * 16700000000.0 * (time - 2e-08)
let mf_loif_re = 2 * mean((v(if_out)) * mfw * cos(mfph)) * mfs
let mf_loif_im = 2 * mean((v(if_out)) * mfw * sin(mfph)) * mfs
let mfph = 2 * pi * 16700000000.0 * (time - 2e-08)
let mf_lorf_re = 2 * mean((v(rf_port)) * mfw * cos(mfph)) * mfs
let mf_lorf_im = 2 * mean((v(rf_port)) * mfw * sin(mfph)) * mfs
let mfph = 2 * pi * 950000000.0 * (time - 2e-08)
let mf_flifa_re = 2 * mean((v(if_out)) * mfw * cos(mfph)) * mfs
let mf_flifa_im = 2 * mean((v(if_out)) * mfw * sin(mfph)) * mfs
let mfph = 2 * pi * 1050000000.0 * (time - 2e-08)
let mf_flifb_re = 2 * mean((v(if_out)) * mfw * cos(mfph)) * mfs
let mf_flifb_im = 2 * mean((v(if_out)) * mfw * sin(mfph)) * mfs
let mfph = 2 * pi * 16750000000.0 * (time - 2e-08)
let mf_fllorf_re = 2 * mean((v(rf_port)) * mfw * cos(mfph)) * mfs
let mf_fllorf_im = 2 * mean((v(rf_port)) * mfw * sin(mfph)) * mfs
let mfph = 2 * pi * 16750000000.0 * (time - 2e-08)
let mf_flloif_re = 2 * mean((v(if_out)) * mfw * cos(mfph)) * mfs
let mf_flloif_im = 2 * mean((v(if_out)) * mfw * sin(mfph)) * mfs
print mf_l
print mf_n
print mf_prail
print mf_lodiff_re
print mf_lodiff_im
print mf_if_re
print mf_if_im
print mf_loif_re
print mf_loif_im
print mf_lorf_re
print mf_lorf_im
print mf_flifa_re
print mf_flifa_im
print mf_flifb_re
print mf_flifb_im
print mf_fllorf_re
print mf_fllorf_im
print mf_flloif_re
print mf_flloif_im
destroy all
echo "MFEND ls_f17p70_m6_rf66"
echo "MFRUN ls_f17p70_m3_rf60"
alterparam f1 = 17700000000.0
alterparam f2 = 17700000000.0
alterparam flo = 16700000000.0
alterparam vrf1 = 0.0006324555320336759
alterparam vrf2 = 0.0
alterparam vlo = 0.6332059593069366
reset
op
let mf_dcirail = 0 - i(vdd)
let mf_dc_vce_q1 = v(c_q1)-v(e_q1)
let mf_dc_vbe_q1 = v(b_q1)-v(e_q1)
let mf_dc_ic_q1 = i(vic_q1)
let mf_dc_vce_q2 = v(c_q2)-v(e_q2)
let mf_dc_vbe_q2 = v(b_q2)-v(e_q2)
let mf_dc_ic_q2 = i(vic_q2)
let mf_dc_vce_q3 = v(c_q3)-v(x1)
let mf_dc_vbe_q3 = v(lo_p)-v(x1)
let mf_dc_ic_q3 = i(vic_q3)
let mf_dc_vce_q4 = v(c_q4)-v(x1)
let mf_dc_vbe_q4 = v(lo_n)-v(x1)
let mf_dc_ic_q4 = i(vic_q4)
let mf_dc_vce_q5 = v(c_q5)-v(x2)
let mf_dc_vbe_q5 = v(lo_p)-v(x2)
let mf_dc_ic_q5 = i(vic_q5)
let mf_dc_vce_q6 = v(c_q6)-v(x2)
let mf_dc_vbe_q6 = v(lo_n)-v(x2)
let mf_dc_ic_q6 = i(vic_q6)
let mf_dc_sink_tail = v(tail)
print mf_dcirail
print mf_dc_vce_q1
print mf_dc_vbe_q1
print mf_dc_ic_q1
print mf_dc_vce_q2
print mf_dc_vbe_q2
print mf_dc_ic_q2
print mf_dc_vce_q3
print mf_dc_vbe_q3
print mf_dc_ic_q3
print mf_dc_vce_q4
print mf_dc_vbe_q4
print mf_dc_ic_q4
print mf_dc_vce_q5
print mf_dc_vbe_q5
print mf_dc_ic_q5
print mf_dc_vce_q6
print mf_dc_vbe_q6
print mf_dc_ic_q6
print mf_dc_sink_tail
tran 1e-12 4e-08 0 1e-12
let mfq_vce_q1 = v(c_q1)-v(e_q1)
meas tran mf_su_vcemax_q1 MAX mfq_vce_q1 from=0.0 to=2e-08
meas tran mf_su_vcemin_q1 MIN mfq_vce_q1 from=0.0 to=2e-08
meas tran mf_ss_vcemax_q1 MAX mfq_vce_q1 from=2e-08 to=4e-08
meas tran mf_ss_vcemin_q1 MIN mfq_vce_q1 from=2e-08 to=4e-08
let mfq_vbe_q1 = v(b_q1)-v(e_q1)
meas tran mf_su_vbemax_q1 MAX mfq_vbe_q1 from=0.0 to=2e-08
meas tran mf_su_vbemin_q1 MIN mfq_vbe_q1 from=0.0 to=2e-08
meas tran mf_ss_vbemax_q1 MAX mfq_vbe_q1 from=2e-08 to=4e-08
meas tran mf_ss_vbemin_q1 MIN mfq_vbe_q1 from=2e-08 to=4e-08
let mfq_ic_q1 = i(vic_q1)
meas tran mf_su_icmax_q1 MAX mfq_ic_q1 from=0.0 to=2e-08
meas tran mf_su_icmin_q1 MIN mfq_ic_q1 from=0.0 to=2e-08
meas tran mf_ss_icmax_q1 MAX mfq_ic_q1 from=2e-08 to=4e-08
meas tran mf_ss_icmin_q1 MIN mfq_ic_q1 from=2e-08 to=4e-08
let mfq_vce_q2 = v(c_q2)-v(e_q2)
meas tran mf_su_vcemax_q2 MAX mfq_vce_q2 from=0.0 to=2e-08
meas tran mf_su_vcemin_q2 MIN mfq_vce_q2 from=0.0 to=2e-08
meas tran mf_ss_vcemax_q2 MAX mfq_vce_q2 from=2e-08 to=4e-08
meas tran mf_ss_vcemin_q2 MIN mfq_vce_q2 from=2e-08 to=4e-08
let mfq_vbe_q2 = v(b_q2)-v(e_q2)
meas tran mf_su_vbemax_q2 MAX mfq_vbe_q2 from=0.0 to=2e-08
meas tran mf_su_vbemin_q2 MIN mfq_vbe_q2 from=0.0 to=2e-08
meas tran mf_ss_vbemax_q2 MAX mfq_vbe_q2 from=2e-08 to=4e-08
meas tran mf_ss_vbemin_q2 MIN mfq_vbe_q2 from=2e-08 to=4e-08
let mfq_ic_q2 = i(vic_q2)
meas tran mf_su_icmax_q2 MAX mfq_ic_q2 from=0.0 to=2e-08
meas tran mf_su_icmin_q2 MIN mfq_ic_q2 from=0.0 to=2e-08
meas tran mf_ss_icmax_q2 MAX mfq_ic_q2 from=2e-08 to=4e-08
meas tran mf_ss_icmin_q2 MIN mfq_ic_q2 from=2e-08 to=4e-08
let mfq_vce_q3 = v(c_q3)-v(x1)
meas tran mf_su_vcemax_q3 MAX mfq_vce_q3 from=0.0 to=2e-08
meas tran mf_su_vcemin_q3 MIN mfq_vce_q3 from=0.0 to=2e-08
meas tran mf_ss_vcemax_q3 MAX mfq_vce_q3 from=2e-08 to=4e-08
meas tran mf_ss_vcemin_q3 MIN mfq_vce_q3 from=2e-08 to=4e-08
let mfq_vbe_q3 = v(lo_p)-v(x1)
meas tran mf_su_vbemax_q3 MAX mfq_vbe_q3 from=0.0 to=2e-08
meas tran mf_su_vbemin_q3 MIN mfq_vbe_q3 from=0.0 to=2e-08
meas tran mf_ss_vbemax_q3 MAX mfq_vbe_q3 from=2e-08 to=4e-08
meas tran mf_ss_vbemin_q3 MIN mfq_vbe_q3 from=2e-08 to=4e-08
let mfq_ic_q3 = i(vic_q3)
meas tran mf_su_icmax_q3 MAX mfq_ic_q3 from=0.0 to=2e-08
meas tran mf_su_icmin_q3 MIN mfq_ic_q3 from=0.0 to=2e-08
meas tran mf_ss_icmax_q3 MAX mfq_ic_q3 from=2e-08 to=4e-08
meas tran mf_ss_icmin_q3 MIN mfq_ic_q3 from=2e-08 to=4e-08
let mfq_vce_q4 = v(c_q4)-v(x1)
meas tran mf_su_vcemax_q4 MAX mfq_vce_q4 from=0.0 to=2e-08
meas tran mf_su_vcemin_q4 MIN mfq_vce_q4 from=0.0 to=2e-08
meas tran mf_ss_vcemax_q4 MAX mfq_vce_q4 from=2e-08 to=4e-08
meas tran mf_ss_vcemin_q4 MIN mfq_vce_q4 from=2e-08 to=4e-08
let mfq_vbe_q4 = v(lo_n)-v(x1)
meas tran mf_su_vbemax_q4 MAX mfq_vbe_q4 from=0.0 to=2e-08
meas tran mf_su_vbemin_q4 MIN mfq_vbe_q4 from=0.0 to=2e-08
meas tran mf_ss_vbemax_q4 MAX mfq_vbe_q4 from=2e-08 to=4e-08
meas tran mf_ss_vbemin_q4 MIN mfq_vbe_q4 from=2e-08 to=4e-08
let mfq_ic_q4 = i(vic_q4)
meas tran mf_su_icmax_q4 MAX mfq_ic_q4 from=0.0 to=2e-08
meas tran mf_su_icmin_q4 MIN mfq_ic_q4 from=0.0 to=2e-08
meas tran mf_ss_icmax_q4 MAX mfq_ic_q4 from=2e-08 to=4e-08
meas tran mf_ss_icmin_q4 MIN mfq_ic_q4 from=2e-08 to=4e-08
let mfq_vce_q5 = v(c_q5)-v(x2)
meas tran mf_su_vcemax_q5 MAX mfq_vce_q5 from=0.0 to=2e-08
meas tran mf_su_vcemin_q5 MIN mfq_vce_q5 from=0.0 to=2e-08
meas tran mf_ss_vcemax_q5 MAX mfq_vce_q5 from=2e-08 to=4e-08
meas tran mf_ss_vcemin_q5 MIN mfq_vce_q5 from=2e-08 to=4e-08
let mfq_vbe_q5 = v(lo_p)-v(x2)
meas tran mf_su_vbemax_q5 MAX mfq_vbe_q5 from=0.0 to=2e-08
meas tran mf_su_vbemin_q5 MIN mfq_vbe_q5 from=0.0 to=2e-08
meas tran mf_ss_vbemax_q5 MAX mfq_vbe_q5 from=2e-08 to=4e-08
meas tran mf_ss_vbemin_q5 MIN mfq_vbe_q5 from=2e-08 to=4e-08
let mfq_ic_q5 = i(vic_q5)
meas tran mf_su_icmax_q5 MAX mfq_ic_q5 from=0.0 to=2e-08
meas tran mf_su_icmin_q5 MIN mfq_ic_q5 from=0.0 to=2e-08
meas tran mf_ss_icmax_q5 MAX mfq_ic_q5 from=2e-08 to=4e-08
meas tran mf_ss_icmin_q5 MIN mfq_ic_q5 from=2e-08 to=4e-08
let mfq_vce_q6 = v(c_q6)-v(x2)
meas tran mf_su_vcemax_q6 MAX mfq_vce_q6 from=0.0 to=2e-08
meas tran mf_su_vcemin_q6 MIN mfq_vce_q6 from=0.0 to=2e-08
meas tran mf_ss_vcemax_q6 MAX mfq_vce_q6 from=2e-08 to=4e-08
meas tran mf_ss_vcemin_q6 MIN mfq_vce_q6 from=2e-08 to=4e-08
let mfq_vbe_q6 = v(lo_n)-v(x2)
meas tran mf_su_vbemax_q6 MAX mfq_vbe_q6 from=0.0 to=2e-08
meas tran mf_su_vbemin_q6 MIN mfq_vbe_q6 from=0.0 to=2e-08
meas tran mf_ss_vbemax_q6 MAX mfq_vbe_q6 from=2e-08 to=4e-08
meas tran mf_ss_vbemin_q6 MIN mfq_vbe_q6 from=2e-08 to=4e-08
let mfq_ic_q6 = i(vic_q6)
meas tran mf_su_icmax_q6 MAX mfq_ic_q6 from=0.0 to=2e-08
meas tran mf_su_icmin_q6 MIN mfq_ic_q6 from=0.0 to=2e-08
meas tran mf_ss_icmax_q6 MAX mfq_ic_q6 from=2e-08 to=4e-08
meas tran mf_ss_icmin_q6 MIN mfq_ic_q6 from=2e-08 to=4e-08
meas tran mf_su_sinkmin_tail MIN v(tail) from=0.0 to=2e-08
meas tran mf_ss_sinkmin_tail MIN v(tail) from=2e-08 to=4e-08
print mf_su_vcemax_q1
print mf_su_vcemin_q1
print mf_ss_vcemax_q1
print mf_ss_vcemin_q1
print mf_su_vbemax_q1
print mf_su_vbemin_q1
print mf_ss_vbemax_q1
print mf_ss_vbemin_q1
print mf_su_icmax_q1
print mf_su_icmin_q1
print mf_ss_icmax_q1
print mf_ss_icmin_q1
print mf_su_vcemax_q2
print mf_su_vcemin_q2
print mf_ss_vcemax_q2
print mf_ss_vcemin_q2
print mf_su_vbemax_q2
print mf_su_vbemin_q2
print mf_ss_vbemax_q2
print mf_ss_vbemin_q2
print mf_su_icmax_q2
print mf_su_icmin_q2
print mf_ss_icmax_q2
print mf_ss_icmin_q2
print mf_su_vcemax_q3
print mf_su_vcemin_q3
print mf_ss_vcemax_q3
print mf_ss_vcemin_q3
print mf_su_vbemax_q3
print mf_su_vbemin_q3
print mf_ss_vbemax_q3
print mf_ss_vbemin_q3
print mf_su_icmax_q3
print mf_su_icmin_q3
print mf_ss_icmax_q3
print mf_ss_icmin_q3
print mf_su_vcemax_q4
print mf_su_vcemin_q4
print mf_ss_vcemax_q4
print mf_ss_vcemin_q4
print mf_su_vbemax_q4
print mf_su_vbemin_q4
print mf_ss_vbemax_q4
print mf_ss_vbemin_q4
print mf_su_icmax_q4
print mf_su_icmin_q4
print mf_ss_icmax_q4
print mf_ss_icmin_q4
print mf_su_vcemax_q5
print mf_su_vcemin_q5
print mf_ss_vcemax_q5
print mf_ss_vcemin_q5
print mf_su_vbemax_q5
print mf_su_vbemin_q5
print mf_ss_vbemax_q5
print mf_ss_vbemin_q5
print mf_su_icmax_q5
print mf_su_icmin_q5
print mf_ss_icmax_q5
print mf_ss_icmin_q5
print mf_su_vcemax_q6
print mf_su_vcemin_q6
print mf_ss_vcemax_q6
print mf_ss_vcemin_q6
print mf_su_vbemax_q6
print mf_su_vbemin_q6
print mf_ss_vbemax_q6
print mf_ss_vbemin_q6
print mf_su_icmax_q6
print mf_su_icmin_q6
print mf_ss_icmax_q6
print mf_ss_icmin_q6
print mf_su_sinkmin_tail
print mf_ss_sinkmin_tail
linearize
let mf_l = length(time)
let mfw = (time ge 1.99995e-08) * (time lt 3.99995e-08)
let mf_n = mean(mfw) * mf_l
let mfs = mf_l / mf_n
let mf_prail = mean(v(vdd) * (0 - i(vdd)) * mfw) * mfs
let mfph = 2 * pi * 16700000000.0 * (time - 2e-08)
let mf_lodiff_re = 2 * mean((v(lo_p)-v(lo_n)) * mfw * cos(mfph)) * mfs
let mf_lodiff_im = 2 * mean((v(lo_p)-v(lo_n)) * mfw * sin(mfph)) * mfs
let mfph = 2 * pi * 1000000000.0 * (time - 2e-08)
let mf_if_re = 2 * mean((v(if_out)) * mfw * cos(mfph)) * mfs
let mf_if_im = 2 * mean((v(if_out)) * mfw * sin(mfph)) * mfs
let mfph = 2 * pi * 16700000000.0 * (time - 2e-08)
let mf_loif_re = 2 * mean((v(if_out)) * mfw * cos(mfph)) * mfs
let mf_loif_im = 2 * mean((v(if_out)) * mfw * sin(mfph)) * mfs
let mfph = 2 * pi * 16700000000.0 * (time - 2e-08)
let mf_lorf_re = 2 * mean((v(rf_port)) * mfw * cos(mfph)) * mfs
let mf_lorf_im = 2 * mean((v(rf_port)) * mfw * sin(mfph)) * mfs
let mfph = 2 * pi * 950000000.0 * (time - 2e-08)
let mf_flifa_re = 2 * mean((v(if_out)) * mfw * cos(mfph)) * mfs
let mf_flifa_im = 2 * mean((v(if_out)) * mfw * sin(mfph)) * mfs
let mfph = 2 * pi * 1050000000.0 * (time - 2e-08)
let mf_flifb_re = 2 * mean((v(if_out)) * mfw * cos(mfph)) * mfs
let mf_flifb_im = 2 * mean((v(if_out)) * mfw * sin(mfph)) * mfs
let mfph = 2 * pi * 16750000000.0 * (time - 2e-08)
let mf_fllorf_re = 2 * mean((v(rf_port)) * mfw * cos(mfph)) * mfs
let mf_fllorf_im = 2 * mean((v(rf_port)) * mfw * sin(mfph)) * mfs
let mfph = 2 * pi * 16750000000.0 * (time - 2e-08)
let mf_flloif_re = 2 * mean((v(if_out)) * mfw * cos(mfph)) * mfs
let mf_flloif_im = 2 * mean((v(if_out)) * mfw * sin(mfph)) * mfs
print mf_l
print mf_n
print mf_prail
print mf_lodiff_re
print mf_lodiff_im
print mf_if_re
print mf_if_im
print mf_loif_re
print mf_loif_im
print mf_lorf_re
print mf_lorf_im
print mf_flifa_re
print mf_flifa_im
print mf_flifb_re
print mf_flifb_im
print mf_fllorf_re
print mf_fllorf_im
print mf_flloif_re
print mf_flloif_im
destroy all
echo "MFEND ls_f17p70_m3_rf60"
echo "MFRUN ls_f17p70_m3_rf66"
alterparam f1 = 17700000000.0
alterparam f2 = 17700000000.0
alterparam flo = 16700000000.0
alterparam vrf1 = 0.00031697863849222284
alterparam vrf2 = 0.0
alterparam vlo = 0.6332059593069366
reset
op
let mf_dcirail = 0 - i(vdd)
let mf_dc_vce_q1 = v(c_q1)-v(e_q1)
let mf_dc_vbe_q1 = v(b_q1)-v(e_q1)
let mf_dc_ic_q1 = i(vic_q1)
let mf_dc_vce_q2 = v(c_q2)-v(e_q2)
let mf_dc_vbe_q2 = v(b_q2)-v(e_q2)
let mf_dc_ic_q2 = i(vic_q2)
let mf_dc_vce_q3 = v(c_q3)-v(x1)
let mf_dc_vbe_q3 = v(lo_p)-v(x1)
let mf_dc_ic_q3 = i(vic_q3)
let mf_dc_vce_q4 = v(c_q4)-v(x1)
let mf_dc_vbe_q4 = v(lo_n)-v(x1)
let mf_dc_ic_q4 = i(vic_q4)
let mf_dc_vce_q5 = v(c_q5)-v(x2)
let mf_dc_vbe_q5 = v(lo_p)-v(x2)
let mf_dc_ic_q5 = i(vic_q5)
let mf_dc_vce_q6 = v(c_q6)-v(x2)
let mf_dc_vbe_q6 = v(lo_n)-v(x2)
let mf_dc_ic_q6 = i(vic_q6)
let mf_dc_sink_tail = v(tail)
print mf_dcirail
print mf_dc_vce_q1
print mf_dc_vbe_q1
print mf_dc_ic_q1
print mf_dc_vce_q2
print mf_dc_vbe_q2
print mf_dc_ic_q2
print mf_dc_vce_q3
print mf_dc_vbe_q3
print mf_dc_ic_q3
print mf_dc_vce_q4
print mf_dc_vbe_q4
print mf_dc_ic_q4
print mf_dc_vce_q5
print mf_dc_vbe_q5
print mf_dc_ic_q5
print mf_dc_vce_q6
print mf_dc_vbe_q6
print mf_dc_ic_q6
print mf_dc_sink_tail
tran 1e-12 4e-08 0 1e-12
let mfq_vce_q1 = v(c_q1)-v(e_q1)
meas tran mf_su_vcemax_q1 MAX mfq_vce_q1 from=0.0 to=2e-08
meas tran mf_su_vcemin_q1 MIN mfq_vce_q1 from=0.0 to=2e-08
meas tran mf_ss_vcemax_q1 MAX mfq_vce_q1 from=2e-08 to=4e-08
meas tran mf_ss_vcemin_q1 MIN mfq_vce_q1 from=2e-08 to=4e-08
let mfq_vbe_q1 = v(b_q1)-v(e_q1)
meas tran mf_su_vbemax_q1 MAX mfq_vbe_q1 from=0.0 to=2e-08
meas tran mf_su_vbemin_q1 MIN mfq_vbe_q1 from=0.0 to=2e-08
meas tran mf_ss_vbemax_q1 MAX mfq_vbe_q1 from=2e-08 to=4e-08
meas tran mf_ss_vbemin_q1 MIN mfq_vbe_q1 from=2e-08 to=4e-08
let mfq_ic_q1 = i(vic_q1)
meas tran mf_su_icmax_q1 MAX mfq_ic_q1 from=0.0 to=2e-08
meas tran mf_su_icmin_q1 MIN mfq_ic_q1 from=0.0 to=2e-08
meas tran mf_ss_icmax_q1 MAX mfq_ic_q1 from=2e-08 to=4e-08
meas tran mf_ss_icmin_q1 MIN mfq_ic_q1 from=2e-08 to=4e-08
let mfq_vce_q2 = v(c_q2)-v(e_q2)
meas tran mf_su_vcemax_q2 MAX mfq_vce_q2 from=0.0 to=2e-08
meas tran mf_su_vcemin_q2 MIN mfq_vce_q2 from=0.0 to=2e-08
meas tran mf_ss_vcemax_q2 MAX mfq_vce_q2 from=2e-08 to=4e-08
meas tran mf_ss_vcemin_q2 MIN mfq_vce_q2 from=2e-08 to=4e-08
let mfq_vbe_q2 = v(b_q2)-v(e_q2)
meas tran mf_su_vbemax_q2 MAX mfq_vbe_q2 from=0.0 to=2e-08
meas tran mf_su_vbemin_q2 MIN mfq_vbe_q2 from=0.0 to=2e-08
meas tran mf_ss_vbemax_q2 MAX mfq_vbe_q2 from=2e-08 to=4e-08
meas tran mf_ss_vbemin_q2 MIN mfq_vbe_q2 from=2e-08 to=4e-08
let mfq_ic_q2 = i(vic_q2)
meas tran mf_su_icmax_q2 MAX mfq_ic_q2 from=0.0 to=2e-08
meas tran mf_su_icmin_q2 MIN mfq_ic_q2 from=0.0 to=2e-08
meas tran mf_ss_icmax_q2 MAX mfq_ic_q2 from=2e-08 to=4e-08
meas tran mf_ss_icmin_q2 MIN mfq_ic_q2 from=2e-08 to=4e-08
let mfq_vce_q3 = v(c_q3)-v(x1)
meas tran mf_su_vcemax_q3 MAX mfq_vce_q3 from=0.0 to=2e-08
meas tran mf_su_vcemin_q3 MIN mfq_vce_q3 from=0.0 to=2e-08
meas tran mf_ss_vcemax_q3 MAX mfq_vce_q3 from=2e-08 to=4e-08
meas tran mf_ss_vcemin_q3 MIN mfq_vce_q3 from=2e-08 to=4e-08
let mfq_vbe_q3 = v(lo_p)-v(x1)
meas tran mf_su_vbemax_q3 MAX mfq_vbe_q3 from=0.0 to=2e-08
meas tran mf_su_vbemin_q3 MIN mfq_vbe_q3 from=0.0 to=2e-08
meas tran mf_ss_vbemax_q3 MAX mfq_vbe_q3 from=2e-08 to=4e-08
meas tran mf_ss_vbemin_q3 MIN mfq_vbe_q3 from=2e-08 to=4e-08
let mfq_ic_q3 = i(vic_q3)
meas tran mf_su_icmax_q3 MAX mfq_ic_q3 from=0.0 to=2e-08
meas tran mf_su_icmin_q3 MIN mfq_ic_q3 from=0.0 to=2e-08
meas tran mf_ss_icmax_q3 MAX mfq_ic_q3 from=2e-08 to=4e-08
meas tran mf_ss_icmin_q3 MIN mfq_ic_q3 from=2e-08 to=4e-08
let mfq_vce_q4 = v(c_q4)-v(x1)
meas tran mf_su_vcemax_q4 MAX mfq_vce_q4 from=0.0 to=2e-08
meas tran mf_su_vcemin_q4 MIN mfq_vce_q4 from=0.0 to=2e-08
meas tran mf_ss_vcemax_q4 MAX mfq_vce_q4 from=2e-08 to=4e-08
meas tran mf_ss_vcemin_q4 MIN mfq_vce_q4 from=2e-08 to=4e-08
let mfq_vbe_q4 = v(lo_n)-v(x1)
meas tran mf_su_vbemax_q4 MAX mfq_vbe_q4 from=0.0 to=2e-08
meas tran mf_su_vbemin_q4 MIN mfq_vbe_q4 from=0.0 to=2e-08
meas tran mf_ss_vbemax_q4 MAX mfq_vbe_q4 from=2e-08 to=4e-08
meas tran mf_ss_vbemin_q4 MIN mfq_vbe_q4 from=2e-08 to=4e-08
let mfq_ic_q4 = i(vic_q4)
meas tran mf_su_icmax_q4 MAX mfq_ic_q4 from=0.0 to=2e-08
meas tran mf_su_icmin_q4 MIN mfq_ic_q4 from=0.0 to=2e-08
meas tran mf_ss_icmax_q4 MAX mfq_ic_q4 from=2e-08 to=4e-08
meas tran mf_ss_icmin_q4 MIN mfq_ic_q4 from=2e-08 to=4e-08
let mfq_vce_q5 = v(c_q5)-v(x2)
meas tran mf_su_vcemax_q5 MAX mfq_vce_q5 from=0.0 to=2e-08
meas tran mf_su_vcemin_q5 MIN mfq_vce_q5 from=0.0 to=2e-08
meas tran mf_ss_vcemax_q5 MAX mfq_vce_q5 from=2e-08 to=4e-08
meas tran mf_ss_vcemin_q5 MIN mfq_vce_q5 from=2e-08 to=4e-08
let mfq_vbe_q5 = v(lo_p)-v(x2)
meas tran mf_su_vbemax_q5 MAX mfq_vbe_q5 from=0.0 to=2e-08
meas tran mf_su_vbemin_q5 MIN mfq_vbe_q5 from=0.0 to=2e-08
meas tran mf_ss_vbemax_q5 MAX mfq_vbe_q5 from=2e-08 to=4e-08
meas tran mf_ss_vbemin_q5 MIN mfq_vbe_q5 from=2e-08 to=4e-08
let mfq_ic_q5 = i(vic_q5)
meas tran mf_su_icmax_q5 MAX mfq_ic_q5 from=0.0 to=2e-08
meas tran mf_su_icmin_q5 MIN mfq_ic_q5 from=0.0 to=2e-08
meas tran mf_ss_icmax_q5 MAX mfq_ic_q5 from=2e-08 to=4e-08
meas tran mf_ss_icmin_q5 MIN mfq_ic_q5 from=2e-08 to=4e-08
let mfq_vce_q6 = v(c_q6)-v(x2)
meas tran mf_su_vcemax_q6 MAX mfq_vce_q6 from=0.0 to=2e-08
meas tran mf_su_vcemin_q6 MIN mfq_vce_q6 from=0.0 to=2e-08
meas tran mf_ss_vcemax_q6 MAX mfq_vce_q6 from=2e-08 to=4e-08
meas tran mf_ss_vcemin_q6 MIN mfq_vce_q6 from=2e-08 to=4e-08
let mfq_vbe_q6 = v(lo_n)-v(x2)
meas tran mf_su_vbemax_q6 MAX mfq_vbe_q6 from=0.0 to=2e-08
meas tran mf_su_vbemin_q6 MIN mfq_vbe_q6 from=0.0 to=2e-08
meas tran mf_ss_vbemax_q6 MAX mfq_vbe_q6 from=2e-08 to=4e-08
meas tran mf_ss_vbemin_q6 MIN mfq_vbe_q6 from=2e-08 to=4e-08
let mfq_ic_q6 = i(vic_q6)
meas tran mf_su_icmax_q6 MAX mfq_ic_q6 from=0.0 to=2e-08
meas tran mf_su_icmin_q6 MIN mfq_ic_q6 from=0.0 to=2e-08
meas tran mf_ss_icmax_q6 MAX mfq_ic_q6 from=2e-08 to=4e-08
meas tran mf_ss_icmin_q6 MIN mfq_ic_q6 from=2e-08 to=4e-08
meas tran mf_su_sinkmin_tail MIN v(tail) from=0.0 to=2e-08
meas tran mf_ss_sinkmin_tail MIN v(tail) from=2e-08 to=4e-08
print mf_su_vcemax_q1
print mf_su_vcemin_q1
print mf_ss_vcemax_q1
print mf_ss_vcemin_q1
print mf_su_vbemax_q1
print mf_su_vbemin_q1
print mf_ss_vbemax_q1
print mf_ss_vbemin_q1
print mf_su_icmax_q1
print mf_su_icmin_q1
print mf_ss_icmax_q1
print mf_ss_icmin_q1
print mf_su_vcemax_q2
print mf_su_vcemin_q2
print mf_ss_vcemax_q2
print mf_ss_vcemin_q2
print mf_su_vbemax_q2
print mf_su_vbemin_q2
print mf_ss_vbemax_q2
print mf_ss_vbemin_q2
print mf_su_icmax_q2
print mf_su_icmin_q2
print mf_ss_icmax_q2
print mf_ss_icmin_q2
print mf_su_vcemax_q3
print mf_su_vcemin_q3
print mf_ss_vcemax_q3
print mf_ss_vcemin_q3
print mf_su_vbemax_q3
print mf_su_vbemin_q3
print mf_ss_vbemax_q3
print mf_ss_vbemin_q3
print mf_su_icmax_q3
print mf_su_icmin_q3
print mf_ss_icmax_q3
print mf_ss_icmin_q3
print mf_su_vcemax_q4
print mf_su_vcemin_q4
print mf_ss_vcemax_q4
print mf_ss_vcemin_q4
print mf_su_vbemax_q4
print mf_su_vbemin_q4
print mf_ss_vbemax_q4
print mf_ss_vbemin_q4
print mf_su_icmax_q4
print mf_su_icmin_q4
print mf_ss_icmax_q4
print mf_ss_icmin_q4
print mf_su_vcemax_q5
print mf_su_vcemin_q5
print mf_ss_vcemax_q5
print mf_ss_vcemin_q5
print mf_su_vbemax_q5
print mf_su_vbemin_q5
print mf_ss_vbemax_q5
print mf_ss_vbemin_q5
print mf_su_icmax_q5
print mf_su_icmin_q5
print mf_ss_icmax_q5
print mf_ss_icmin_q5
print mf_su_vcemax_q6
print mf_su_vcemin_q6
print mf_ss_vcemax_q6
print mf_ss_vcemin_q6
print mf_su_vbemax_q6
print mf_su_vbemin_q6
print mf_ss_vbemax_q6
print mf_ss_vbemin_q6
print mf_su_icmax_q6
print mf_su_icmin_q6
print mf_ss_icmax_q6
print mf_ss_icmin_q6
print mf_su_sinkmin_tail
print mf_ss_sinkmin_tail
linearize
let mf_l = length(time)
let mfw = (time ge 1.99995e-08) * (time lt 3.99995e-08)
let mf_n = mean(mfw) * mf_l
let mfs = mf_l / mf_n
let mf_prail = mean(v(vdd) * (0 - i(vdd)) * mfw) * mfs
let mfph = 2 * pi * 16700000000.0 * (time - 2e-08)
let mf_lodiff_re = 2 * mean((v(lo_p)-v(lo_n)) * mfw * cos(mfph)) * mfs
let mf_lodiff_im = 2 * mean((v(lo_p)-v(lo_n)) * mfw * sin(mfph)) * mfs
let mfph = 2 * pi * 1000000000.0 * (time - 2e-08)
let mf_if_re = 2 * mean((v(if_out)) * mfw * cos(mfph)) * mfs
let mf_if_im = 2 * mean((v(if_out)) * mfw * sin(mfph)) * mfs
let mfph = 2 * pi * 16700000000.0 * (time - 2e-08)
let mf_loif_re = 2 * mean((v(if_out)) * mfw * cos(mfph)) * mfs
let mf_loif_im = 2 * mean((v(if_out)) * mfw * sin(mfph)) * mfs
let mfph = 2 * pi * 16700000000.0 * (time - 2e-08)
let mf_lorf_re = 2 * mean((v(rf_port)) * mfw * cos(mfph)) * mfs
let mf_lorf_im = 2 * mean((v(rf_port)) * mfw * sin(mfph)) * mfs
let mfph = 2 * pi * 950000000.0 * (time - 2e-08)
let mf_flifa_re = 2 * mean((v(if_out)) * mfw * cos(mfph)) * mfs
let mf_flifa_im = 2 * mean((v(if_out)) * mfw * sin(mfph)) * mfs
let mfph = 2 * pi * 1050000000.0 * (time - 2e-08)
let mf_flifb_re = 2 * mean((v(if_out)) * mfw * cos(mfph)) * mfs
let mf_flifb_im = 2 * mean((v(if_out)) * mfw * sin(mfph)) * mfs
let mfph = 2 * pi * 16750000000.0 * (time - 2e-08)
let mf_fllorf_re = 2 * mean((v(rf_port)) * mfw * cos(mfph)) * mfs
let mf_fllorf_im = 2 * mean((v(rf_port)) * mfw * sin(mfph)) * mfs
let mfph = 2 * pi * 16750000000.0 * (time - 2e-08)
let mf_flloif_re = 2 * mean((v(if_out)) * mfw * cos(mfph)) * mfs
let mf_flloif_im = 2 * mean((v(if_out)) * mfw * sin(mfph)) * mfs
print mf_l
print mf_n
print mf_prail
print mf_lodiff_re
print mf_lodiff_im
print mf_if_re
print mf_if_im
print mf_loif_re
print mf_loif_im
print mf_lorf_re
print mf_lorf_im
print mf_flifa_re
print mf_flifa_im
print mf_flifb_re
print mf_flifb_im
print mf_fllorf_re
print mf_fllorf_im
print mf_flloif_re
print mf_flloif_im
destroy all
echo "MFEND ls_f17p70_m3_rf66"
echo "MFRUN ls_f17p70_p0_rf60"
alterparam f1 = 17700000000.0
alterparam f2 = 17700000000.0
alterparam flo = 16700000000.0
alterparam vrf1 = 0.0006324555320336759
alterparam vrf2 = 0.0
alterparam vlo = 0.8944271909999159
reset
op
let mf_dcirail = 0 - i(vdd)
let mf_dc_vce_q1 = v(c_q1)-v(e_q1)
let mf_dc_vbe_q1 = v(b_q1)-v(e_q1)
let mf_dc_ic_q1 = i(vic_q1)
let mf_dc_vce_q2 = v(c_q2)-v(e_q2)
let mf_dc_vbe_q2 = v(b_q2)-v(e_q2)
let mf_dc_ic_q2 = i(vic_q2)
let mf_dc_vce_q3 = v(c_q3)-v(x1)
let mf_dc_vbe_q3 = v(lo_p)-v(x1)
let mf_dc_ic_q3 = i(vic_q3)
let mf_dc_vce_q4 = v(c_q4)-v(x1)
let mf_dc_vbe_q4 = v(lo_n)-v(x1)
let mf_dc_ic_q4 = i(vic_q4)
let mf_dc_vce_q5 = v(c_q5)-v(x2)
let mf_dc_vbe_q5 = v(lo_p)-v(x2)
let mf_dc_ic_q5 = i(vic_q5)
let mf_dc_vce_q6 = v(c_q6)-v(x2)
let mf_dc_vbe_q6 = v(lo_n)-v(x2)
let mf_dc_ic_q6 = i(vic_q6)
let mf_dc_sink_tail = v(tail)
print mf_dcirail
print mf_dc_vce_q1
print mf_dc_vbe_q1
print mf_dc_ic_q1
print mf_dc_vce_q2
print mf_dc_vbe_q2
print mf_dc_ic_q2
print mf_dc_vce_q3
print mf_dc_vbe_q3
print mf_dc_ic_q3
print mf_dc_vce_q4
print mf_dc_vbe_q4
print mf_dc_ic_q4
print mf_dc_vce_q5
print mf_dc_vbe_q5
print mf_dc_ic_q5
print mf_dc_vce_q6
print mf_dc_vbe_q6
print mf_dc_ic_q6
print mf_dc_sink_tail
tran 1e-12 4e-08 0 1e-12
let mfq_vce_q1 = v(c_q1)-v(e_q1)
meas tran mf_su_vcemax_q1 MAX mfq_vce_q1 from=0.0 to=2e-08
meas tran mf_su_vcemin_q1 MIN mfq_vce_q1 from=0.0 to=2e-08
meas tran mf_ss_vcemax_q1 MAX mfq_vce_q1 from=2e-08 to=4e-08
meas tran mf_ss_vcemin_q1 MIN mfq_vce_q1 from=2e-08 to=4e-08
let mfq_vbe_q1 = v(b_q1)-v(e_q1)
meas tran mf_su_vbemax_q1 MAX mfq_vbe_q1 from=0.0 to=2e-08
meas tran mf_su_vbemin_q1 MIN mfq_vbe_q1 from=0.0 to=2e-08
meas tran mf_ss_vbemax_q1 MAX mfq_vbe_q1 from=2e-08 to=4e-08
meas tran mf_ss_vbemin_q1 MIN mfq_vbe_q1 from=2e-08 to=4e-08
let mfq_ic_q1 = i(vic_q1)
meas tran mf_su_icmax_q1 MAX mfq_ic_q1 from=0.0 to=2e-08
meas tran mf_su_icmin_q1 MIN mfq_ic_q1 from=0.0 to=2e-08
meas tran mf_ss_icmax_q1 MAX mfq_ic_q1 from=2e-08 to=4e-08
meas tran mf_ss_icmin_q1 MIN mfq_ic_q1 from=2e-08 to=4e-08
let mfq_vce_q2 = v(c_q2)-v(e_q2)
meas tran mf_su_vcemax_q2 MAX mfq_vce_q2 from=0.0 to=2e-08
meas tran mf_su_vcemin_q2 MIN mfq_vce_q2 from=0.0 to=2e-08
meas tran mf_ss_vcemax_q2 MAX mfq_vce_q2 from=2e-08 to=4e-08
meas tran mf_ss_vcemin_q2 MIN mfq_vce_q2 from=2e-08 to=4e-08
let mfq_vbe_q2 = v(b_q2)-v(e_q2)
meas tran mf_su_vbemax_q2 MAX mfq_vbe_q2 from=0.0 to=2e-08
meas tran mf_su_vbemin_q2 MIN mfq_vbe_q2 from=0.0 to=2e-08
meas tran mf_ss_vbemax_q2 MAX mfq_vbe_q2 from=2e-08 to=4e-08
meas tran mf_ss_vbemin_q2 MIN mfq_vbe_q2 from=2e-08 to=4e-08
let mfq_ic_q2 = i(vic_q2)
meas tran mf_su_icmax_q2 MAX mfq_ic_q2 from=0.0 to=2e-08
meas tran mf_su_icmin_q2 MIN mfq_ic_q2 from=0.0 to=2e-08
meas tran mf_ss_icmax_q2 MAX mfq_ic_q2 from=2e-08 to=4e-08
meas tran mf_ss_icmin_q2 MIN mfq_ic_q2 from=2e-08 to=4e-08
let mfq_vce_q3 = v(c_q3)-v(x1)
meas tran mf_su_vcemax_q3 MAX mfq_vce_q3 from=0.0 to=2e-08
meas tran mf_su_vcemin_q3 MIN mfq_vce_q3 from=0.0 to=2e-08
meas tran mf_ss_vcemax_q3 MAX mfq_vce_q3 from=2e-08 to=4e-08
meas tran mf_ss_vcemin_q3 MIN mfq_vce_q3 from=2e-08 to=4e-08
let mfq_vbe_q3 = v(lo_p)-v(x1)
meas tran mf_su_vbemax_q3 MAX mfq_vbe_q3 from=0.0 to=2e-08
meas tran mf_su_vbemin_q3 MIN mfq_vbe_q3 from=0.0 to=2e-08
meas tran mf_ss_vbemax_q3 MAX mfq_vbe_q3 from=2e-08 to=4e-08
meas tran mf_ss_vbemin_q3 MIN mfq_vbe_q3 from=2e-08 to=4e-08
let mfq_ic_q3 = i(vic_q3)
meas tran mf_su_icmax_q3 MAX mfq_ic_q3 from=0.0 to=2e-08
meas tran mf_su_icmin_q3 MIN mfq_ic_q3 from=0.0 to=2e-08
meas tran mf_ss_icmax_q3 MAX mfq_ic_q3 from=2e-08 to=4e-08
meas tran mf_ss_icmin_q3 MIN mfq_ic_q3 from=2e-08 to=4e-08
let mfq_vce_q4 = v(c_q4)-v(x1)
meas tran mf_su_vcemax_q4 MAX mfq_vce_q4 from=0.0 to=2e-08
meas tran mf_su_vcemin_q4 MIN mfq_vce_q4 from=0.0 to=2e-08
meas tran mf_ss_vcemax_q4 MAX mfq_vce_q4 from=2e-08 to=4e-08
meas tran mf_ss_vcemin_q4 MIN mfq_vce_q4 from=2e-08 to=4e-08
let mfq_vbe_q4 = v(lo_n)-v(x1)
meas tran mf_su_vbemax_q4 MAX mfq_vbe_q4 from=0.0 to=2e-08
meas tran mf_su_vbemin_q4 MIN mfq_vbe_q4 from=0.0 to=2e-08
meas tran mf_ss_vbemax_q4 MAX mfq_vbe_q4 from=2e-08 to=4e-08
meas tran mf_ss_vbemin_q4 MIN mfq_vbe_q4 from=2e-08 to=4e-08
let mfq_ic_q4 = i(vic_q4)
meas tran mf_su_icmax_q4 MAX mfq_ic_q4 from=0.0 to=2e-08
meas tran mf_su_icmin_q4 MIN mfq_ic_q4 from=0.0 to=2e-08
meas tran mf_ss_icmax_q4 MAX mfq_ic_q4 from=2e-08 to=4e-08
meas tran mf_ss_icmin_q4 MIN mfq_ic_q4 from=2e-08 to=4e-08
let mfq_vce_q5 = v(c_q5)-v(x2)
meas tran mf_su_vcemax_q5 MAX mfq_vce_q5 from=0.0 to=2e-08
meas tran mf_su_vcemin_q5 MIN mfq_vce_q5 from=0.0 to=2e-08
meas tran mf_ss_vcemax_q5 MAX mfq_vce_q5 from=2e-08 to=4e-08
meas tran mf_ss_vcemin_q5 MIN mfq_vce_q5 from=2e-08 to=4e-08
let mfq_vbe_q5 = v(lo_p)-v(x2)
meas tran mf_su_vbemax_q5 MAX mfq_vbe_q5 from=0.0 to=2e-08
meas tran mf_su_vbemin_q5 MIN mfq_vbe_q5 from=0.0 to=2e-08
meas tran mf_ss_vbemax_q5 MAX mfq_vbe_q5 from=2e-08 to=4e-08
meas tran mf_ss_vbemin_q5 MIN mfq_vbe_q5 from=2e-08 to=4e-08
let mfq_ic_q5 = i(vic_q5)
meas tran mf_su_icmax_q5 MAX mfq_ic_q5 from=0.0 to=2e-08
meas tran mf_su_icmin_q5 MIN mfq_ic_q5 from=0.0 to=2e-08
meas tran mf_ss_icmax_q5 MAX mfq_ic_q5 from=2e-08 to=4e-08
meas tran mf_ss_icmin_q5 MIN mfq_ic_q5 from=2e-08 to=4e-08
let mfq_vce_q6 = v(c_q6)-v(x2)
meas tran mf_su_vcemax_q6 MAX mfq_vce_q6 from=0.0 to=2e-08
meas tran mf_su_vcemin_q6 MIN mfq_vce_q6 from=0.0 to=2e-08
meas tran mf_ss_vcemax_q6 MAX mfq_vce_q6 from=2e-08 to=4e-08
meas tran mf_ss_vcemin_q6 MIN mfq_vce_q6 from=2e-08 to=4e-08
let mfq_vbe_q6 = v(lo_n)-v(x2)
meas tran mf_su_vbemax_q6 MAX mfq_vbe_q6 from=0.0 to=2e-08
meas tran mf_su_vbemin_q6 MIN mfq_vbe_q6 from=0.0 to=2e-08
meas tran mf_ss_vbemax_q6 MAX mfq_vbe_q6 from=2e-08 to=4e-08
meas tran mf_ss_vbemin_q6 MIN mfq_vbe_q6 from=2e-08 to=4e-08
let mfq_ic_q6 = i(vic_q6)
meas tran mf_su_icmax_q6 MAX mfq_ic_q6 from=0.0 to=2e-08
meas tran mf_su_icmin_q6 MIN mfq_ic_q6 from=0.0 to=2e-08
meas tran mf_ss_icmax_q6 MAX mfq_ic_q6 from=2e-08 to=4e-08
meas tran mf_ss_icmin_q6 MIN mfq_ic_q6 from=2e-08 to=4e-08
meas tran mf_su_sinkmin_tail MIN v(tail) from=0.0 to=2e-08
meas tran mf_ss_sinkmin_tail MIN v(tail) from=2e-08 to=4e-08
print mf_su_vcemax_q1
print mf_su_vcemin_q1
print mf_ss_vcemax_q1
print mf_ss_vcemin_q1
print mf_su_vbemax_q1
print mf_su_vbemin_q1
print mf_ss_vbemax_q1
print mf_ss_vbemin_q1
print mf_su_icmax_q1
print mf_su_icmin_q1
print mf_ss_icmax_q1
print mf_ss_icmin_q1
print mf_su_vcemax_q2
print mf_su_vcemin_q2
print mf_ss_vcemax_q2
print mf_ss_vcemin_q2
print mf_su_vbemax_q2
print mf_su_vbemin_q2
print mf_ss_vbemax_q2
print mf_ss_vbemin_q2
print mf_su_icmax_q2
print mf_su_icmin_q2
print mf_ss_icmax_q2
print mf_ss_icmin_q2
print mf_su_vcemax_q3
print mf_su_vcemin_q3
print mf_ss_vcemax_q3
print mf_ss_vcemin_q3
print mf_su_vbemax_q3
print mf_su_vbemin_q3
print mf_ss_vbemax_q3
print mf_ss_vbemin_q3
print mf_su_icmax_q3
print mf_su_icmin_q3
print mf_ss_icmax_q3
print mf_ss_icmin_q3
print mf_su_vcemax_q4
print mf_su_vcemin_q4
print mf_ss_vcemax_q4
print mf_ss_vcemin_q4
print mf_su_vbemax_q4
print mf_su_vbemin_q4
print mf_ss_vbemax_q4
print mf_ss_vbemin_q4
print mf_su_icmax_q4
print mf_su_icmin_q4
print mf_ss_icmax_q4
print mf_ss_icmin_q4
print mf_su_vcemax_q5
print mf_su_vcemin_q5
print mf_ss_vcemax_q5
print mf_ss_vcemin_q5
print mf_su_vbemax_q5
print mf_su_vbemin_q5
print mf_ss_vbemax_q5
print mf_ss_vbemin_q5
print mf_su_icmax_q5
print mf_su_icmin_q5
print mf_ss_icmax_q5
print mf_ss_icmin_q5
print mf_su_vcemax_q6
print mf_su_vcemin_q6
print mf_ss_vcemax_q6
print mf_ss_vcemin_q6
print mf_su_vbemax_q6
print mf_su_vbemin_q6
print mf_ss_vbemax_q6
print mf_ss_vbemin_q6
print mf_su_icmax_q6
print mf_su_icmin_q6
print mf_ss_icmax_q6
print mf_ss_icmin_q6
print mf_su_sinkmin_tail
print mf_ss_sinkmin_tail
linearize
let mf_l = length(time)
let mfw = (time ge 1.99995e-08) * (time lt 3.99995e-08)
let mf_n = mean(mfw) * mf_l
let mfs = mf_l / mf_n
let mf_prail = mean(v(vdd) * (0 - i(vdd)) * mfw) * mfs
let mfph = 2 * pi * 16700000000.0 * (time - 2e-08)
let mf_lodiff_re = 2 * mean((v(lo_p)-v(lo_n)) * mfw * cos(mfph)) * mfs
let mf_lodiff_im = 2 * mean((v(lo_p)-v(lo_n)) * mfw * sin(mfph)) * mfs
let mfph = 2 * pi * 1000000000.0 * (time - 2e-08)
let mf_if_re = 2 * mean((v(if_out)) * mfw * cos(mfph)) * mfs
let mf_if_im = 2 * mean((v(if_out)) * mfw * sin(mfph)) * mfs
let mfph = 2 * pi * 16700000000.0 * (time - 2e-08)
let mf_loif_re = 2 * mean((v(if_out)) * mfw * cos(mfph)) * mfs
let mf_loif_im = 2 * mean((v(if_out)) * mfw * sin(mfph)) * mfs
let mfph = 2 * pi * 16700000000.0 * (time - 2e-08)
let mf_lorf_re = 2 * mean((v(rf_port)) * mfw * cos(mfph)) * mfs
let mf_lorf_im = 2 * mean((v(rf_port)) * mfw * sin(mfph)) * mfs
let mfph = 2 * pi * 950000000.0 * (time - 2e-08)
let mf_flifa_re = 2 * mean((v(if_out)) * mfw * cos(mfph)) * mfs
let mf_flifa_im = 2 * mean((v(if_out)) * mfw * sin(mfph)) * mfs
let mfph = 2 * pi * 1050000000.0 * (time - 2e-08)
let mf_flifb_re = 2 * mean((v(if_out)) * mfw * cos(mfph)) * mfs
let mf_flifb_im = 2 * mean((v(if_out)) * mfw * sin(mfph)) * mfs
let mfph = 2 * pi * 16750000000.0 * (time - 2e-08)
let mf_fllorf_re = 2 * mean((v(rf_port)) * mfw * cos(mfph)) * mfs
let mf_fllorf_im = 2 * mean((v(rf_port)) * mfw * sin(mfph)) * mfs
let mfph = 2 * pi * 16750000000.0 * (time - 2e-08)
let mf_flloif_re = 2 * mean((v(if_out)) * mfw * cos(mfph)) * mfs
let mf_flloif_im = 2 * mean((v(if_out)) * mfw * sin(mfph)) * mfs
print mf_l
print mf_n
print mf_prail
print mf_lodiff_re
print mf_lodiff_im
print mf_if_re
print mf_if_im
print mf_loif_re
print mf_loif_im
print mf_lorf_re
print mf_lorf_im
print mf_flifa_re
print mf_flifa_im
print mf_flifb_re
print mf_flifb_im
print mf_fllorf_re
print mf_fllorf_im
print mf_flloif_re
print mf_flloif_im
destroy all
echo "MFEND ls_f17p70_p0_rf60"
echo "MFRUN ls_f17p70_p0_rf66"
alterparam f1 = 17700000000.0
alterparam f2 = 17700000000.0
alterparam flo = 16700000000.0
alterparam vrf1 = 0.00031697863849222284
alterparam vrf2 = 0.0
alterparam vlo = 0.8944271909999159
reset
op
let mf_dcirail = 0 - i(vdd)
let mf_dc_vce_q1 = v(c_q1)-v(e_q1)
let mf_dc_vbe_q1 = v(b_q1)-v(e_q1)
let mf_dc_ic_q1 = i(vic_q1)
let mf_dc_vce_q2 = v(c_q2)-v(e_q2)
let mf_dc_vbe_q2 = v(b_q2)-v(e_q2)
let mf_dc_ic_q2 = i(vic_q2)
let mf_dc_vce_q3 = v(c_q3)-v(x1)
let mf_dc_vbe_q3 = v(lo_p)-v(x1)
let mf_dc_ic_q3 = i(vic_q3)
let mf_dc_vce_q4 = v(c_q4)-v(x1)
let mf_dc_vbe_q4 = v(lo_n)-v(x1)
let mf_dc_ic_q4 = i(vic_q4)
let mf_dc_vce_q5 = v(c_q5)-v(x2)
let mf_dc_vbe_q5 = v(lo_p)-v(x2)
let mf_dc_ic_q5 = i(vic_q5)
let mf_dc_vce_q6 = v(c_q6)-v(x2)
let mf_dc_vbe_q6 = v(lo_n)-v(x2)
let mf_dc_ic_q6 = i(vic_q6)
let mf_dc_sink_tail = v(tail)
print mf_dcirail
print mf_dc_vce_q1
print mf_dc_vbe_q1
print mf_dc_ic_q1
print mf_dc_vce_q2
print mf_dc_vbe_q2
print mf_dc_ic_q2
print mf_dc_vce_q3
print mf_dc_vbe_q3
print mf_dc_ic_q3
print mf_dc_vce_q4
print mf_dc_vbe_q4
print mf_dc_ic_q4
print mf_dc_vce_q5
print mf_dc_vbe_q5
print mf_dc_ic_q5
print mf_dc_vce_q6
print mf_dc_vbe_q6
print mf_dc_ic_q6
print mf_dc_sink_tail
tran 1e-12 4e-08 0 1e-12
let mfq_vce_q1 = v(c_q1)-v(e_q1)
meas tran mf_su_vcemax_q1 MAX mfq_vce_q1 from=0.0 to=2e-08
meas tran mf_su_vcemin_q1 MIN mfq_vce_q1 from=0.0 to=2e-08
meas tran mf_ss_vcemax_q1 MAX mfq_vce_q1 from=2e-08 to=4e-08
meas tran mf_ss_vcemin_q1 MIN mfq_vce_q1 from=2e-08 to=4e-08
let mfq_vbe_q1 = v(b_q1)-v(e_q1)
meas tran mf_su_vbemax_q1 MAX mfq_vbe_q1 from=0.0 to=2e-08
meas tran mf_su_vbemin_q1 MIN mfq_vbe_q1 from=0.0 to=2e-08
meas tran mf_ss_vbemax_q1 MAX mfq_vbe_q1 from=2e-08 to=4e-08
meas tran mf_ss_vbemin_q1 MIN mfq_vbe_q1 from=2e-08 to=4e-08
let mfq_ic_q1 = i(vic_q1)
meas tran mf_su_icmax_q1 MAX mfq_ic_q1 from=0.0 to=2e-08
meas tran mf_su_icmin_q1 MIN mfq_ic_q1 from=0.0 to=2e-08
meas tran mf_ss_icmax_q1 MAX mfq_ic_q1 from=2e-08 to=4e-08
meas tran mf_ss_icmin_q1 MIN mfq_ic_q1 from=2e-08 to=4e-08
let mfq_vce_q2 = v(c_q2)-v(e_q2)
meas tran mf_su_vcemax_q2 MAX mfq_vce_q2 from=0.0 to=2e-08
meas tran mf_su_vcemin_q2 MIN mfq_vce_q2 from=0.0 to=2e-08
meas tran mf_ss_vcemax_q2 MAX mfq_vce_q2 from=2e-08 to=4e-08
meas tran mf_ss_vcemin_q2 MIN mfq_vce_q2 from=2e-08 to=4e-08
let mfq_vbe_q2 = v(b_q2)-v(e_q2)
meas tran mf_su_vbemax_q2 MAX mfq_vbe_q2 from=0.0 to=2e-08
meas tran mf_su_vbemin_q2 MIN mfq_vbe_q2 from=0.0 to=2e-08
meas tran mf_ss_vbemax_q2 MAX mfq_vbe_q2 from=2e-08 to=4e-08
meas tran mf_ss_vbemin_q2 MIN mfq_vbe_q2 from=2e-08 to=4e-08
let mfq_ic_q2 = i(vic_q2)
meas tran mf_su_icmax_q2 MAX mfq_ic_q2 from=0.0 to=2e-08
meas tran mf_su_icmin_q2 MIN mfq_ic_q2 from=0.0 to=2e-08
meas tran mf_ss_icmax_q2 MAX mfq_ic_q2 from=2e-08 to=4e-08
meas tran mf_ss_icmin_q2 MIN mfq_ic_q2 from=2e-08 to=4e-08
let mfq_vce_q3 = v(c_q3)-v(x1)
meas tran mf_su_vcemax_q3 MAX mfq_vce_q3 from=0.0 to=2e-08
meas tran mf_su_vcemin_q3 MIN mfq_vce_q3 from=0.0 to=2e-08
meas tran mf_ss_vcemax_q3 MAX mfq_vce_q3 from=2e-08 to=4e-08
meas tran mf_ss_vcemin_q3 MIN mfq_vce_q3 from=2e-08 to=4e-08
let mfq_vbe_q3 = v(lo_p)-v(x1)
meas tran mf_su_vbemax_q3 MAX mfq_vbe_q3 from=0.0 to=2e-08
meas tran mf_su_vbemin_q3 MIN mfq_vbe_q3 from=0.0 to=2e-08
meas tran mf_ss_vbemax_q3 MAX mfq_vbe_q3 from=2e-08 to=4e-08
meas tran mf_ss_vbemin_q3 MIN mfq_vbe_q3 from=2e-08 to=4e-08
let mfq_ic_q3 = i(vic_q3)
meas tran mf_su_icmax_q3 MAX mfq_ic_q3 from=0.0 to=2e-08
meas tran mf_su_icmin_q3 MIN mfq_ic_q3 from=0.0 to=2e-08
meas tran mf_ss_icmax_q3 MAX mfq_ic_q3 from=2e-08 to=4e-08
meas tran mf_ss_icmin_q3 MIN mfq_ic_q3 from=2e-08 to=4e-08
let mfq_vce_q4 = v(c_q4)-v(x1)
meas tran mf_su_vcemax_q4 MAX mfq_vce_q4 from=0.0 to=2e-08
meas tran mf_su_vcemin_q4 MIN mfq_vce_q4 from=0.0 to=2e-08
meas tran mf_ss_vcemax_q4 MAX mfq_vce_q4 from=2e-08 to=4e-08
meas tran mf_ss_vcemin_q4 MIN mfq_vce_q4 from=2e-08 to=4e-08
let mfq_vbe_q4 = v(lo_n)-v(x1)
meas tran mf_su_vbemax_q4 MAX mfq_vbe_q4 from=0.0 to=2e-08
meas tran mf_su_vbemin_q4 MIN mfq_vbe_q4 from=0.0 to=2e-08
meas tran mf_ss_vbemax_q4 MAX mfq_vbe_q4 from=2e-08 to=4e-08
meas tran mf_ss_vbemin_q4 MIN mfq_vbe_q4 from=2e-08 to=4e-08
let mfq_ic_q4 = i(vic_q4)
meas tran mf_su_icmax_q4 MAX mfq_ic_q4 from=0.0 to=2e-08
meas tran mf_su_icmin_q4 MIN mfq_ic_q4 from=0.0 to=2e-08
meas tran mf_ss_icmax_q4 MAX mfq_ic_q4 from=2e-08 to=4e-08
meas tran mf_ss_icmin_q4 MIN mfq_ic_q4 from=2e-08 to=4e-08
let mfq_vce_q5 = v(c_q5)-v(x2)
meas tran mf_su_vcemax_q5 MAX mfq_vce_q5 from=0.0 to=2e-08
meas tran mf_su_vcemin_q5 MIN mfq_vce_q5 from=0.0 to=2e-08
meas tran mf_ss_vcemax_q5 MAX mfq_vce_q5 from=2e-08 to=4e-08
meas tran mf_ss_vcemin_q5 MIN mfq_vce_q5 from=2e-08 to=4e-08
let mfq_vbe_q5 = v(lo_p)-v(x2)
meas tran mf_su_vbemax_q5 MAX mfq_vbe_q5 from=0.0 to=2e-08
meas tran mf_su_vbemin_q5 MIN mfq_vbe_q5 from=0.0 to=2e-08
meas tran mf_ss_vbemax_q5 MAX mfq_vbe_q5 from=2e-08 to=4e-08
meas tran mf_ss_vbemin_q5 MIN mfq_vbe_q5 from=2e-08 to=4e-08
let mfq_ic_q5 = i(vic_q5)
meas tran mf_su_icmax_q5 MAX mfq_ic_q5 from=0.0 to=2e-08
meas tran mf_su_icmin_q5 MIN mfq_ic_q5 from=0.0 to=2e-08
meas tran mf_ss_icmax_q5 MAX mfq_ic_q5 from=2e-08 to=4e-08
meas tran mf_ss_icmin_q5 MIN mfq_ic_q5 from=2e-08 to=4e-08
let mfq_vce_q6 = v(c_q6)-v(x2)
meas tran mf_su_vcemax_q6 MAX mfq_vce_q6 from=0.0 to=2e-08
meas tran mf_su_vcemin_q6 MIN mfq_vce_q6 from=0.0 to=2e-08
meas tran mf_ss_vcemax_q6 MAX mfq_vce_q6 from=2e-08 to=4e-08
meas tran mf_ss_vcemin_q6 MIN mfq_vce_q6 from=2e-08 to=4e-08
let mfq_vbe_q6 = v(lo_n)-v(x2)
meas tran mf_su_vbemax_q6 MAX mfq_vbe_q6 from=0.0 to=2e-08
meas tran mf_su_vbemin_q6 MIN mfq_vbe_q6 from=0.0 to=2e-08
meas tran mf_ss_vbemax_q6 MAX mfq_vbe_q6 from=2e-08 to=4e-08
meas tran mf_ss_vbemin_q6 MIN mfq_vbe_q6 from=2e-08 to=4e-08
let mfq_ic_q6 = i(vic_q6)
meas tran mf_su_icmax_q6 MAX mfq_ic_q6 from=0.0 to=2e-08
meas tran mf_su_icmin_q6 MIN mfq_ic_q6 from=0.0 to=2e-08
meas tran mf_ss_icmax_q6 MAX mfq_ic_q6 from=2e-08 to=4e-08
meas tran mf_ss_icmin_q6 MIN mfq_ic_q6 from=2e-08 to=4e-08
meas tran mf_su_sinkmin_tail MIN v(tail) from=0.0 to=2e-08
meas tran mf_ss_sinkmin_tail MIN v(tail) from=2e-08 to=4e-08
print mf_su_vcemax_q1
print mf_su_vcemin_q1
print mf_ss_vcemax_q1
print mf_ss_vcemin_q1
print mf_su_vbemax_q1
print mf_su_vbemin_q1
print mf_ss_vbemax_q1
print mf_ss_vbemin_q1
print mf_su_icmax_q1
print mf_su_icmin_q1
print mf_ss_icmax_q1
print mf_ss_icmin_q1
print mf_su_vcemax_q2
print mf_su_vcemin_q2
print mf_ss_vcemax_q2
print mf_ss_vcemin_q2
print mf_su_vbemax_q2
print mf_su_vbemin_q2
print mf_ss_vbemax_q2
print mf_ss_vbemin_q2
print mf_su_icmax_q2
print mf_su_icmin_q2
print mf_ss_icmax_q2
print mf_ss_icmin_q2
print mf_su_vcemax_q3
print mf_su_vcemin_q3
print mf_ss_vcemax_q3
print mf_ss_vcemin_q3
print mf_su_vbemax_q3
print mf_su_vbemin_q3
print mf_ss_vbemax_q3
print mf_ss_vbemin_q3
print mf_su_icmax_q3
print mf_su_icmin_q3
print mf_ss_icmax_q3
print mf_ss_icmin_q3
print mf_su_vcemax_q4
print mf_su_vcemin_q4
print mf_ss_vcemax_q4
print mf_ss_vcemin_q4
print mf_su_vbemax_q4
print mf_su_vbemin_q4
print mf_ss_vbemax_q4
print mf_ss_vbemin_q4
print mf_su_icmax_q4
print mf_su_icmin_q4
print mf_ss_icmax_q4
print mf_ss_icmin_q4
print mf_su_vcemax_q5
print mf_su_vcemin_q5
print mf_ss_vcemax_q5
print mf_ss_vcemin_q5
print mf_su_vbemax_q5
print mf_su_vbemin_q5
print mf_ss_vbemax_q5
print mf_ss_vbemin_q5
print mf_su_icmax_q5
print mf_su_icmin_q5
print mf_ss_icmax_q5
print mf_ss_icmin_q5
print mf_su_vcemax_q6
print mf_su_vcemin_q6
print mf_ss_vcemax_q6
print mf_ss_vcemin_q6
print mf_su_vbemax_q6
print mf_su_vbemin_q6
print mf_ss_vbemax_q6
print mf_ss_vbemin_q6
print mf_su_icmax_q6
print mf_su_icmin_q6
print mf_ss_icmax_q6
print mf_ss_icmin_q6
print mf_su_sinkmin_tail
print mf_ss_sinkmin_tail
linearize
let mf_l = length(time)
let mfw = (time ge 1.99995e-08) * (time lt 3.99995e-08)
let mf_n = mean(mfw) * mf_l
let mfs = mf_l / mf_n
let mf_prail = mean(v(vdd) * (0 - i(vdd)) * mfw) * mfs
let mfph = 2 * pi * 16700000000.0 * (time - 2e-08)
let mf_lodiff_re = 2 * mean((v(lo_p)-v(lo_n)) * mfw * cos(mfph)) * mfs
let mf_lodiff_im = 2 * mean((v(lo_p)-v(lo_n)) * mfw * sin(mfph)) * mfs
let mfph = 2 * pi * 1000000000.0 * (time - 2e-08)
let mf_if_re = 2 * mean((v(if_out)) * mfw * cos(mfph)) * mfs
let mf_if_im = 2 * mean((v(if_out)) * mfw * sin(mfph)) * mfs
let mfph = 2 * pi * 16700000000.0 * (time - 2e-08)
let mf_loif_re = 2 * mean((v(if_out)) * mfw * cos(mfph)) * mfs
let mf_loif_im = 2 * mean((v(if_out)) * mfw * sin(mfph)) * mfs
let mfph = 2 * pi * 16700000000.0 * (time - 2e-08)
let mf_lorf_re = 2 * mean((v(rf_port)) * mfw * cos(mfph)) * mfs
let mf_lorf_im = 2 * mean((v(rf_port)) * mfw * sin(mfph)) * mfs
let mfph = 2 * pi * 950000000.0 * (time - 2e-08)
let mf_flifa_re = 2 * mean((v(if_out)) * mfw * cos(mfph)) * mfs
let mf_flifa_im = 2 * mean((v(if_out)) * mfw * sin(mfph)) * mfs
let mfph = 2 * pi * 1050000000.0 * (time - 2e-08)
let mf_flifb_re = 2 * mean((v(if_out)) * mfw * cos(mfph)) * mfs
let mf_flifb_im = 2 * mean((v(if_out)) * mfw * sin(mfph)) * mfs
let mfph = 2 * pi * 16750000000.0 * (time - 2e-08)
let mf_fllorf_re = 2 * mean((v(rf_port)) * mfw * cos(mfph)) * mfs
let mf_fllorf_im = 2 * mean((v(rf_port)) * mfw * sin(mfph)) * mfs
let mfph = 2 * pi * 16750000000.0 * (time - 2e-08)
let mf_flloif_re = 2 * mean((v(if_out)) * mfw * cos(mfph)) * mfs
let mf_flloif_im = 2 * mean((v(if_out)) * mfw * sin(mfph)) * mfs
print mf_l
print mf_n
print mf_prail
print mf_lodiff_re
print mf_lodiff_im
print mf_if_re
print mf_if_im
print mf_loif_re
print mf_loif_im
print mf_lorf_re
print mf_lorf_im
print mf_flifa_re
print mf_flifa_im
print mf_flifb_re
print mf_flifb_im
print mf_fllorf_re
print mf_fllorf_im
print mf_flloif_re
print mf_flloif_im
destroy all
echo "MFEND ls_f17p70_p0_rf66"
echo "MFRUN ls_f17p70_p3_rf60"
alterparam f1 = 17700000000.0
alterparam f2 = 17700000000.0
alterparam flo = 16700000000.0
alterparam vrf1 = 0.0006324555320336759
alterparam vrf2 = 0.0
alterparam vlo = 1.2634119882188484
reset
op
let mf_dcirail = 0 - i(vdd)
let mf_dc_vce_q1 = v(c_q1)-v(e_q1)
let mf_dc_vbe_q1 = v(b_q1)-v(e_q1)
let mf_dc_ic_q1 = i(vic_q1)
let mf_dc_vce_q2 = v(c_q2)-v(e_q2)
let mf_dc_vbe_q2 = v(b_q2)-v(e_q2)
let mf_dc_ic_q2 = i(vic_q2)
let mf_dc_vce_q3 = v(c_q3)-v(x1)
let mf_dc_vbe_q3 = v(lo_p)-v(x1)
let mf_dc_ic_q3 = i(vic_q3)
let mf_dc_vce_q4 = v(c_q4)-v(x1)
let mf_dc_vbe_q4 = v(lo_n)-v(x1)
let mf_dc_ic_q4 = i(vic_q4)
let mf_dc_vce_q5 = v(c_q5)-v(x2)
let mf_dc_vbe_q5 = v(lo_p)-v(x2)
let mf_dc_ic_q5 = i(vic_q5)
let mf_dc_vce_q6 = v(c_q6)-v(x2)
let mf_dc_vbe_q6 = v(lo_n)-v(x2)
let mf_dc_ic_q6 = i(vic_q6)
let mf_dc_sink_tail = v(tail)
print mf_dcirail
print mf_dc_vce_q1
print mf_dc_vbe_q1
print mf_dc_ic_q1
print mf_dc_vce_q2
print mf_dc_vbe_q2
print mf_dc_ic_q2
print mf_dc_vce_q3
print mf_dc_vbe_q3
print mf_dc_ic_q3
print mf_dc_vce_q4
print mf_dc_vbe_q4
print mf_dc_ic_q4
print mf_dc_vce_q5
print mf_dc_vbe_q5
print mf_dc_ic_q5
print mf_dc_vce_q6
print mf_dc_vbe_q6
print mf_dc_ic_q6
print mf_dc_sink_tail
tran 1e-12 4e-08 0 1e-12
let mfq_vce_q1 = v(c_q1)-v(e_q1)
meas tran mf_su_vcemax_q1 MAX mfq_vce_q1 from=0.0 to=2e-08
meas tran mf_su_vcemin_q1 MIN mfq_vce_q1 from=0.0 to=2e-08
meas tran mf_ss_vcemax_q1 MAX mfq_vce_q1 from=2e-08 to=4e-08
meas tran mf_ss_vcemin_q1 MIN mfq_vce_q1 from=2e-08 to=4e-08
let mfq_vbe_q1 = v(b_q1)-v(e_q1)
meas tran mf_su_vbemax_q1 MAX mfq_vbe_q1 from=0.0 to=2e-08
meas tran mf_su_vbemin_q1 MIN mfq_vbe_q1 from=0.0 to=2e-08
meas tran mf_ss_vbemax_q1 MAX mfq_vbe_q1 from=2e-08 to=4e-08
meas tran mf_ss_vbemin_q1 MIN mfq_vbe_q1 from=2e-08 to=4e-08
let mfq_ic_q1 = i(vic_q1)
meas tran mf_su_icmax_q1 MAX mfq_ic_q1 from=0.0 to=2e-08
meas tran mf_su_icmin_q1 MIN mfq_ic_q1 from=0.0 to=2e-08
meas tran mf_ss_icmax_q1 MAX mfq_ic_q1 from=2e-08 to=4e-08
meas tran mf_ss_icmin_q1 MIN mfq_ic_q1 from=2e-08 to=4e-08
let mfq_vce_q2 = v(c_q2)-v(e_q2)
meas tran mf_su_vcemax_q2 MAX mfq_vce_q2 from=0.0 to=2e-08
meas tran mf_su_vcemin_q2 MIN mfq_vce_q2 from=0.0 to=2e-08
meas tran mf_ss_vcemax_q2 MAX mfq_vce_q2 from=2e-08 to=4e-08
meas tran mf_ss_vcemin_q2 MIN mfq_vce_q2 from=2e-08 to=4e-08
let mfq_vbe_q2 = v(b_q2)-v(e_q2)
meas tran mf_su_vbemax_q2 MAX mfq_vbe_q2 from=0.0 to=2e-08
meas tran mf_su_vbemin_q2 MIN mfq_vbe_q2 from=0.0 to=2e-08
meas tran mf_ss_vbemax_q2 MAX mfq_vbe_q2 from=2e-08 to=4e-08
meas tran mf_ss_vbemin_q2 MIN mfq_vbe_q2 from=2e-08 to=4e-08
let mfq_ic_q2 = i(vic_q2)
meas tran mf_su_icmax_q2 MAX mfq_ic_q2 from=0.0 to=2e-08
meas tran mf_su_icmin_q2 MIN mfq_ic_q2 from=0.0 to=2e-08
meas tran mf_ss_icmax_q2 MAX mfq_ic_q2 from=2e-08 to=4e-08
meas tran mf_ss_icmin_q2 MIN mfq_ic_q2 from=2e-08 to=4e-08
let mfq_vce_q3 = v(c_q3)-v(x1)
meas tran mf_su_vcemax_q3 MAX mfq_vce_q3 from=0.0 to=2e-08
meas tran mf_su_vcemin_q3 MIN mfq_vce_q3 from=0.0 to=2e-08
meas tran mf_ss_vcemax_q3 MAX mfq_vce_q3 from=2e-08 to=4e-08
meas tran mf_ss_vcemin_q3 MIN mfq_vce_q3 from=2e-08 to=4e-08
let mfq_vbe_q3 = v(lo_p)-v(x1)
meas tran mf_su_vbemax_q3 MAX mfq_vbe_q3 from=0.0 to=2e-08
meas tran mf_su_vbemin_q3 MIN mfq_vbe_q3 from=0.0 to=2e-08
meas tran mf_ss_vbemax_q3 MAX mfq_vbe_q3 from=2e-08 to=4e-08
meas tran mf_ss_vbemin_q3 MIN mfq_vbe_q3 from=2e-08 to=4e-08
let mfq_ic_q3 = i(vic_q3)
meas tran mf_su_icmax_q3 MAX mfq_ic_q3 from=0.0 to=2e-08
meas tran mf_su_icmin_q3 MIN mfq_ic_q3 from=0.0 to=2e-08
meas tran mf_ss_icmax_q3 MAX mfq_ic_q3 from=2e-08 to=4e-08
meas tran mf_ss_icmin_q3 MIN mfq_ic_q3 from=2e-08 to=4e-08
let mfq_vce_q4 = v(c_q4)-v(x1)
meas tran mf_su_vcemax_q4 MAX mfq_vce_q4 from=0.0 to=2e-08
meas tran mf_su_vcemin_q4 MIN mfq_vce_q4 from=0.0 to=2e-08
meas tran mf_ss_vcemax_q4 MAX mfq_vce_q4 from=2e-08 to=4e-08
meas tran mf_ss_vcemin_q4 MIN mfq_vce_q4 from=2e-08 to=4e-08
let mfq_vbe_q4 = v(lo_n)-v(x1)
meas tran mf_su_vbemax_q4 MAX mfq_vbe_q4 from=0.0 to=2e-08
meas tran mf_su_vbemin_q4 MIN mfq_vbe_q4 from=0.0 to=2e-08
meas tran mf_ss_vbemax_q4 MAX mfq_vbe_q4 from=2e-08 to=4e-08
meas tran mf_ss_vbemin_q4 MIN mfq_vbe_q4 from=2e-08 to=4e-08
let mfq_ic_q4 = i(vic_q4)
meas tran mf_su_icmax_q4 MAX mfq_ic_q4 from=0.0 to=2e-08
meas tran mf_su_icmin_q4 MIN mfq_ic_q4 from=0.0 to=2e-08
meas tran mf_ss_icmax_q4 MAX mfq_ic_q4 from=2e-08 to=4e-08
meas tran mf_ss_icmin_q4 MIN mfq_ic_q4 from=2e-08 to=4e-08
let mfq_vce_q5 = v(c_q5)-v(x2)
meas tran mf_su_vcemax_q5 MAX mfq_vce_q5 from=0.0 to=2e-08
meas tran mf_su_vcemin_q5 MIN mfq_vce_q5 from=0.0 to=2e-08
meas tran mf_ss_vcemax_q5 MAX mfq_vce_q5 from=2e-08 to=4e-08
meas tran mf_ss_vcemin_q5 MIN mfq_vce_q5 from=2e-08 to=4e-08
let mfq_vbe_q5 = v(lo_p)-v(x2)
meas tran mf_su_vbemax_q5 MAX mfq_vbe_q5 from=0.0 to=2e-08
meas tran mf_su_vbemin_q5 MIN mfq_vbe_q5 from=0.0 to=2e-08
meas tran mf_ss_vbemax_q5 MAX mfq_vbe_q5 from=2e-08 to=4e-08
meas tran mf_ss_vbemin_q5 MIN mfq_vbe_q5 from=2e-08 to=4e-08
let mfq_ic_q5 = i(vic_q5)
meas tran mf_su_icmax_q5 MAX mfq_ic_q5 from=0.0 to=2e-08
meas tran mf_su_icmin_q5 MIN mfq_ic_q5 from=0.0 to=2e-08
meas tran mf_ss_icmax_q5 MAX mfq_ic_q5 from=2e-08 to=4e-08
meas tran mf_ss_icmin_q5 MIN mfq_ic_q5 from=2e-08 to=4e-08
let mfq_vce_q6 = v(c_q6)-v(x2)
meas tran mf_su_vcemax_q6 MAX mfq_vce_q6 from=0.0 to=2e-08
meas tran mf_su_vcemin_q6 MIN mfq_vce_q6 from=0.0 to=2e-08
meas tran mf_ss_vcemax_q6 MAX mfq_vce_q6 from=2e-08 to=4e-08
meas tran mf_ss_vcemin_q6 MIN mfq_vce_q6 from=2e-08 to=4e-08
let mfq_vbe_q6 = v(lo_n)-v(x2)
meas tran mf_su_vbemax_q6 MAX mfq_vbe_q6 from=0.0 to=2e-08
meas tran mf_su_vbemin_q6 MIN mfq_vbe_q6 from=0.0 to=2e-08
meas tran mf_ss_vbemax_q6 MAX mfq_vbe_q6 from=2e-08 to=4e-08
meas tran mf_ss_vbemin_q6 MIN mfq_vbe_q6 from=2e-08 to=4e-08
let mfq_ic_q6 = i(vic_q6)
meas tran mf_su_icmax_q6 MAX mfq_ic_q6 from=0.0 to=2e-08
meas tran mf_su_icmin_q6 MIN mfq_ic_q6 from=0.0 to=2e-08
meas tran mf_ss_icmax_q6 MAX mfq_ic_q6 from=2e-08 to=4e-08
meas tran mf_ss_icmin_q6 MIN mfq_ic_q6 from=2e-08 to=4e-08
meas tran mf_su_sinkmin_tail MIN v(tail) from=0.0 to=2e-08
meas tran mf_ss_sinkmin_tail MIN v(tail) from=2e-08 to=4e-08
print mf_su_vcemax_q1
print mf_su_vcemin_q1
print mf_ss_vcemax_q1
print mf_ss_vcemin_q1
print mf_su_vbemax_q1
print mf_su_vbemin_q1
print mf_ss_vbemax_q1
print mf_ss_vbemin_q1
print mf_su_icmax_q1
print mf_su_icmin_q1
print mf_ss_icmax_q1
print mf_ss_icmin_q1
print mf_su_vcemax_q2
print mf_su_vcemin_q2
print mf_ss_vcemax_q2
print mf_ss_vcemin_q2
print mf_su_vbemax_q2
print mf_su_vbemin_q2
print mf_ss_vbemax_q2
print mf_ss_vbemin_q2
print mf_su_icmax_q2
print mf_su_icmin_q2
print mf_ss_icmax_q2
print mf_ss_icmin_q2
print mf_su_vcemax_q3
print mf_su_vcemin_q3
print mf_ss_vcemax_q3
print mf_ss_vcemin_q3
print mf_su_vbemax_q3
print mf_su_vbemin_q3
print mf_ss_vbemax_q3
print mf_ss_vbemin_q3
print mf_su_icmax_q3
print mf_su_icmin_q3
print mf_ss_icmax_q3
print mf_ss_icmin_q3
print mf_su_vcemax_q4
print mf_su_vcemin_q4
print mf_ss_vcemax_q4
print mf_ss_vcemin_q4
print mf_su_vbemax_q4
print mf_su_vbemin_q4
print mf_ss_vbemax_q4
print mf_ss_vbemin_q4
print mf_su_icmax_q4
print mf_su_icmin_q4
print mf_ss_icmax_q4
print mf_ss_icmin_q4
print mf_su_vcemax_q5
print mf_su_vcemin_q5
print mf_ss_vcemax_q5
print mf_ss_vcemin_q5
print mf_su_vbemax_q5
print mf_su_vbemin_q5
print mf_ss_vbemax_q5
print mf_ss_vbemin_q5
print mf_su_icmax_q5
print mf_su_icmin_q5
print mf_ss_icmax_q5
print mf_ss_icmin_q5
print mf_su_vcemax_q6
print mf_su_vcemin_q6
print mf_ss_vcemax_q6
print mf_ss_vcemin_q6
print mf_su_vbemax_q6
print mf_su_vbemin_q6
print mf_ss_vbemax_q6
print mf_ss_vbemin_q6
print mf_su_icmax_q6
print mf_su_icmin_q6
print mf_ss_icmax_q6
print mf_ss_icmin_q6
print mf_su_sinkmin_tail
print mf_ss_sinkmin_tail
linearize
let mf_l = length(time)
let mfw = (time ge 1.99995e-08) * (time lt 3.99995e-08)
let mf_n = mean(mfw) * mf_l
let mfs = mf_l / mf_n
let mf_prail = mean(v(vdd) * (0 - i(vdd)) * mfw) * mfs
let mfph = 2 * pi * 16700000000.0 * (time - 2e-08)
let mf_lodiff_re = 2 * mean((v(lo_p)-v(lo_n)) * mfw * cos(mfph)) * mfs
let mf_lodiff_im = 2 * mean((v(lo_p)-v(lo_n)) * mfw * sin(mfph)) * mfs
let mfph = 2 * pi * 1000000000.0 * (time - 2e-08)
let mf_if_re = 2 * mean((v(if_out)) * mfw * cos(mfph)) * mfs
let mf_if_im = 2 * mean((v(if_out)) * mfw * sin(mfph)) * mfs
let mfph = 2 * pi * 16700000000.0 * (time - 2e-08)
let mf_loif_re = 2 * mean((v(if_out)) * mfw * cos(mfph)) * mfs
let mf_loif_im = 2 * mean((v(if_out)) * mfw * sin(mfph)) * mfs
let mfph = 2 * pi * 16700000000.0 * (time - 2e-08)
let mf_lorf_re = 2 * mean((v(rf_port)) * mfw * cos(mfph)) * mfs
let mf_lorf_im = 2 * mean((v(rf_port)) * mfw * sin(mfph)) * mfs
let mfph = 2 * pi * 950000000.0 * (time - 2e-08)
let mf_flifa_re = 2 * mean((v(if_out)) * mfw * cos(mfph)) * mfs
let mf_flifa_im = 2 * mean((v(if_out)) * mfw * sin(mfph)) * mfs
let mfph = 2 * pi * 1050000000.0 * (time - 2e-08)
let mf_flifb_re = 2 * mean((v(if_out)) * mfw * cos(mfph)) * mfs
let mf_flifb_im = 2 * mean((v(if_out)) * mfw * sin(mfph)) * mfs
let mfph = 2 * pi * 16750000000.0 * (time - 2e-08)
let mf_fllorf_re = 2 * mean((v(rf_port)) * mfw * cos(mfph)) * mfs
let mf_fllorf_im = 2 * mean((v(rf_port)) * mfw * sin(mfph)) * mfs
let mfph = 2 * pi * 16750000000.0 * (time - 2e-08)
let mf_flloif_re = 2 * mean((v(if_out)) * mfw * cos(mfph)) * mfs
let mf_flloif_im = 2 * mean((v(if_out)) * mfw * sin(mfph)) * mfs
print mf_l
print mf_n
print mf_prail
print mf_lodiff_re
print mf_lodiff_im
print mf_if_re
print mf_if_im
print mf_loif_re
print mf_loif_im
print mf_lorf_re
print mf_lorf_im
print mf_flifa_re
print mf_flifa_im
print mf_flifb_re
print mf_flifb_im
print mf_fllorf_re
print mf_fllorf_im
print mf_flloif_re
print mf_flloif_im
destroy all
echo "MFEND ls_f17p70_p3_rf60"
echo "MFRUN ls_f17p70_p3_rf66"
alterparam f1 = 17700000000.0
alterparam f2 = 17700000000.0
alterparam flo = 16700000000.0
alterparam vrf1 = 0.00031697863849222284
alterparam vrf2 = 0.0
alterparam vlo = 1.2634119882188484
reset
op
let mf_dcirail = 0 - i(vdd)
let mf_dc_vce_q1 = v(c_q1)-v(e_q1)
let mf_dc_vbe_q1 = v(b_q1)-v(e_q1)
let mf_dc_ic_q1 = i(vic_q1)
let mf_dc_vce_q2 = v(c_q2)-v(e_q2)
let mf_dc_vbe_q2 = v(b_q2)-v(e_q2)
let mf_dc_ic_q2 = i(vic_q2)
let mf_dc_vce_q3 = v(c_q3)-v(x1)
let mf_dc_vbe_q3 = v(lo_p)-v(x1)
let mf_dc_ic_q3 = i(vic_q3)
let mf_dc_vce_q4 = v(c_q4)-v(x1)
let mf_dc_vbe_q4 = v(lo_n)-v(x1)
let mf_dc_ic_q4 = i(vic_q4)
let mf_dc_vce_q5 = v(c_q5)-v(x2)
let mf_dc_vbe_q5 = v(lo_p)-v(x2)
let mf_dc_ic_q5 = i(vic_q5)
let mf_dc_vce_q6 = v(c_q6)-v(x2)
let mf_dc_vbe_q6 = v(lo_n)-v(x2)
let mf_dc_ic_q6 = i(vic_q6)
let mf_dc_sink_tail = v(tail)
print mf_dcirail
print mf_dc_vce_q1
print mf_dc_vbe_q1
print mf_dc_ic_q1
print mf_dc_vce_q2
print mf_dc_vbe_q2
print mf_dc_ic_q2
print mf_dc_vce_q3
print mf_dc_vbe_q3
print mf_dc_ic_q3
print mf_dc_vce_q4
print mf_dc_vbe_q4
print mf_dc_ic_q4
print mf_dc_vce_q5
print mf_dc_vbe_q5
print mf_dc_ic_q5
print mf_dc_vce_q6
print mf_dc_vbe_q6
print mf_dc_ic_q6
print mf_dc_sink_tail
tran 1e-12 4e-08 0 1e-12
let mfq_vce_q1 = v(c_q1)-v(e_q1)
meas tran mf_su_vcemax_q1 MAX mfq_vce_q1 from=0.0 to=2e-08
meas tran mf_su_vcemin_q1 MIN mfq_vce_q1 from=0.0 to=2e-08
meas tran mf_ss_vcemax_q1 MAX mfq_vce_q1 from=2e-08 to=4e-08
meas tran mf_ss_vcemin_q1 MIN mfq_vce_q1 from=2e-08 to=4e-08
let mfq_vbe_q1 = v(b_q1)-v(e_q1)
meas tran mf_su_vbemax_q1 MAX mfq_vbe_q1 from=0.0 to=2e-08
meas tran mf_su_vbemin_q1 MIN mfq_vbe_q1 from=0.0 to=2e-08
meas tran mf_ss_vbemax_q1 MAX mfq_vbe_q1 from=2e-08 to=4e-08
meas tran mf_ss_vbemin_q1 MIN mfq_vbe_q1 from=2e-08 to=4e-08
let mfq_ic_q1 = i(vic_q1)
meas tran mf_su_icmax_q1 MAX mfq_ic_q1 from=0.0 to=2e-08
meas tran mf_su_icmin_q1 MIN mfq_ic_q1 from=0.0 to=2e-08
meas tran mf_ss_icmax_q1 MAX mfq_ic_q1 from=2e-08 to=4e-08
meas tran mf_ss_icmin_q1 MIN mfq_ic_q1 from=2e-08 to=4e-08
let mfq_vce_q2 = v(c_q2)-v(e_q2)
meas tran mf_su_vcemax_q2 MAX mfq_vce_q2 from=0.0 to=2e-08
meas tran mf_su_vcemin_q2 MIN mfq_vce_q2 from=0.0 to=2e-08
meas tran mf_ss_vcemax_q2 MAX mfq_vce_q2 from=2e-08 to=4e-08
meas tran mf_ss_vcemin_q2 MIN mfq_vce_q2 from=2e-08 to=4e-08
let mfq_vbe_q2 = v(b_q2)-v(e_q2)
meas tran mf_su_vbemax_q2 MAX mfq_vbe_q2 from=0.0 to=2e-08
meas tran mf_su_vbemin_q2 MIN mfq_vbe_q2 from=0.0 to=2e-08
meas tran mf_ss_vbemax_q2 MAX mfq_vbe_q2 from=2e-08 to=4e-08
meas tran mf_ss_vbemin_q2 MIN mfq_vbe_q2 from=2e-08 to=4e-08
let mfq_ic_q2 = i(vic_q2)
meas tran mf_su_icmax_q2 MAX mfq_ic_q2 from=0.0 to=2e-08
meas tran mf_su_icmin_q2 MIN mfq_ic_q2 from=0.0 to=2e-08
meas tran mf_ss_icmax_q2 MAX mfq_ic_q2 from=2e-08 to=4e-08
meas tran mf_ss_icmin_q2 MIN mfq_ic_q2 from=2e-08 to=4e-08
let mfq_vce_q3 = v(c_q3)-v(x1)
meas tran mf_su_vcemax_q3 MAX mfq_vce_q3 from=0.0 to=2e-08
meas tran mf_su_vcemin_q3 MIN mfq_vce_q3 from=0.0 to=2e-08
meas tran mf_ss_vcemax_q3 MAX mfq_vce_q3 from=2e-08 to=4e-08
meas tran mf_ss_vcemin_q3 MIN mfq_vce_q3 from=2e-08 to=4e-08
let mfq_vbe_q3 = v(lo_p)-v(x1)
meas tran mf_su_vbemax_q3 MAX mfq_vbe_q3 from=0.0 to=2e-08
meas tran mf_su_vbemin_q3 MIN mfq_vbe_q3 from=0.0 to=2e-08
meas tran mf_ss_vbemax_q3 MAX mfq_vbe_q3 from=2e-08 to=4e-08
meas tran mf_ss_vbemin_q3 MIN mfq_vbe_q3 from=2e-08 to=4e-08
let mfq_ic_q3 = i(vic_q3)
meas tran mf_su_icmax_q3 MAX mfq_ic_q3 from=0.0 to=2e-08
meas tran mf_su_icmin_q3 MIN mfq_ic_q3 from=0.0 to=2e-08
meas tran mf_ss_icmax_q3 MAX mfq_ic_q3 from=2e-08 to=4e-08
meas tran mf_ss_icmin_q3 MIN mfq_ic_q3 from=2e-08 to=4e-08
let mfq_vce_q4 = v(c_q4)-v(x1)
meas tran mf_su_vcemax_q4 MAX mfq_vce_q4 from=0.0 to=2e-08
meas tran mf_su_vcemin_q4 MIN mfq_vce_q4 from=0.0 to=2e-08
meas tran mf_ss_vcemax_q4 MAX mfq_vce_q4 from=2e-08 to=4e-08
meas tran mf_ss_vcemin_q4 MIN mfq_vce_q4 from=2e-08 to=4e-08
let mfq_vbe_q4 = v(lo_n)-v(x1)
meas tran mf_su_vbemax_q4 MAX mfq_vbe_q4 from=0.0 to=2e-08
meas tran mf_su_vbemin_q4 MIN mfq_vbe_q4 from=0.0 to=2e-08
meas tran mf_ss_vbemax_q4 MAX mfq_vbe_q4 from=2e-08 to=4e-08
meas tran mf_ss_vbemin_q4 MIN mfq_vbe_q4 from=2e-08 to=4e-08
let mfq_ic_q4 = i(vic_q4)
meas tran mf_su_icmax_q4 MAX mfq_ic_q4 from=0.0 to=2e-08
meas tran mf_su_icmin_q4 MIN mfq_ic_q4 from=0.0 to=2e-08
meas tran mf_ss_icmax_q4 MAX mfq_ic_q4 from=2e-08 to=4e-08
meas tran mf_ss_icmin_q4 MIN mfq_ic_q4 from=2e-08 to=4e-08
let mfq_vce_q5 = v(c_q5)-v(x2)
meas tran mf_su_vcemax_q5 MAX mfq_vce_q5 from=0.0 to=2e-08
meas tran mf_su_vcemin_q5 MIN mfq_vce_q5 from=0.0 to=2e-08
meas tran mf_ss_vcemax_q5 MAX mfq_vce_q5 from=2e-08 to=4e-08
meas tran mf_ss_vcemin_q5 MIN mfq_vce_q5 from=2e-08 to=4e-08
let mfq_vbe_q5 = v(lo_p)-v(x2)
meas tran mf_su_vbemax_q5 MAX mfq_vbe_q5 from=0.0 to=2e-08
meas tran mf_su_vbemin_q5 MIN mfq_vbe_q5 from=0.0 to=2e-08
meas tran mf_ss_vbemax_q5 MAX mfq_vbe_q5 from=2e-08 to=4e-08
meas tran mf_ss_vbemin_q5 MIN mfq_vbe_q5 from=2e-08 to=4e-08
let mfq_ic_q5 = i(vic_q5)
meas tran mf_su_icmax_q5 MAX mfq_ic_q5 from=0.0 to=2e-08
meas tran mf_su_icmin_q5 MIN mfq_ic_q5 from=0.0 to=2e-08
meas tran mf_ss_icmax_q5 MAX mfq_ic_q5 from=2e-08 to=4e-08
meas tran mf_ss_icmin_q5 MIN mfq_ic_q5 from=2e-08 to=4e-08
let mfq_vce_q6 = v(c_q6)-v(x2)
meas tran mf_su_vcemax_q6 MAX mfq_vce_q6 from=0.0 to=2e-08
meas tran mf_su_vcemin_q6 MIN mfq_vce_q6 from=0.0 to=2e-08
meas tran mf_ss_vcemax_q6 MAX mfq_vce_q6 from=2e-08 to=4e-08
meas tran mf_ss_vcemin_q6 MIN mfq_vce_q6 from=2e-08 to=4e-08
let mfq_vbe_q6 = v(lo_n)-v(x2)
meas tran mf_su_vbemax_q6 MAX mfq_vbe_q6 from=0.0 to=2e-08
meas tran mf_su_vbemin_q6 MIN mfq_vbe_q6 from=0.0 to=2e-08
meas tran mf_ss_vbemax_q6 MAX mfq_vbe_q6 from=2e-08 to=4e-08
meas tran mf_ss_vbemin_q6 MIN mfq_vbe_q6 from=2e-08 to=4e-08
let mfq_ic_q6 = i(vic_q6)
meas tran mf_su_icmax_q6 MAX mfq_ic_q6 from=0.0 to=2e-08
meas tran mf_su_icmin_q6 MIN mfq_ic_q6 from=0.0 to=2e-08
meas tran mf_ss_icmax_q6 MAX mfq_ic_q6 from=2e-08 to=4e-08
meas tran mf_ss_icmin_q6 MIN mfq_ic_q6 from=2e-08 to=4e-08
meas tran mf_su_sinkmin_tail MIN v(tail) from=0.0 to=2e-08
meas tran mf_ss_sinkmin_tail MIN v(tail) from=2e-08 to=4e-08
print mf_su_vcemax_q1
print mf_su_vcemin_q1
print mf_ss_vcemax_q1
print mf_ss_vcemin_q1
print mf_su_vbemax_q1
print mf_su_vbemin_q1
print mf_ss_vbemax_q1
print mf_ss_vbemin_q1
print mf_su_icmax_q1
print mf_su_icmin_q1
print mf_ss_icmax_q1
print mf_ss_icmin_q1
print mf_su_vcemax_q2
print mf_su_vcemin_q2
print mf_ss_vcemax_q2
print mf_ss_vcemin_q2
print mf_su_vbemax_q2
print mf_su_vbemin_q2
print mf_ss_vbemax_q2
print mf_ss_vbemin_q2
print mf_su_icmax_q2
print mf_su_icmin_q2
print mf_ss_icmax_q2
print mf_ss_icmin_q2
print mf_su_vcemax_q3
print mf_su_vcemin_q3
print mf_ss_vcemax_q3
print mf_ss_vcemin_q3
print mf_su_vbemax_q3
print mf_su_vbemin_q3
print mf_ss_vbemax_q3
print mf_ss_vbemin_q3
print mf_su_icmax_q3
print mf_su_icmin_q3
print mf_ss_icmax_q3
print mf_ss_icmin_q3
print mf_su_vcemax_q4
print mf_su_vcemin_q4
print mf_ss_vcemax_q4
print mf_ss_vcemin_q4
print mf_su_vbemax_q4
print mf_su_vbemin_q4
print mf_ss_vbemax_q4
print mf_ss_vbemin_q4
print mf_su_icmax_q4
print mf_su_icmin_q4
print mf_ss_icmax_q4
print mf_ss_icmin_q4
print mf_su_vcemax_q5
print mf_su_vcemin_q5
print mf_ss_vcemax_q5
print mf_ss_vcemin_q5
print mf_su_vbemax_q5
print mf_su_vbemin_q5
print mf_ss_vbemax_q5
print mf_ss_vbemin_q5
print mf_su_icmax_q5
print mf_su_icmin_q5
print mf_ss_icmax_q5
print mf_ss_icmin_q5
print mf_su_vcemax_q6
print mf_su_vcemin_q6
print mf_ss_vcemax_q6
print mf_ss_vcemin_q6
print mf_su_vbemax_q6
print mf_su_vbemin_q6
print mf_ss_vbemax_q6
print mf_ss_vbemin_q6
print mf_su_icmax_q6
print mf_su_icmin_q6
print mf_ss_icmax_q6
print mf_ss_icmin_q6
print mf_su_sinkmin_tail
print mf_ss_sinkmin_tail
linearize
let mf_l = length(time)
let mfw = (time ge 1.99995e-08) * (time lt 3.99995e-08)
let mf_n = mean(mfw) * mf_l
let mfs = mf_l / mf_n
let mf_prail = mean(v(vdd) * (0 - i(vdd)) * mfw) * mfs
let mfph = 2 * pi * 16700000000.0 * (time - 2e-08)
let mf_lodiff_re = 2 * mean((v(lo_p)-v(lo_n)) * mfw * cos(mfph)) * mfs
let mf_lodiff_im = 2 * mean((v(lo_p)-v(lo_n)) * mfw * sin(mfph)) * mfs
let mfph = 2 * pi * 1000000000.0 * (time - 2e-08)
let mf_if_re = 2 * mean((v(if_out)) * mfw * cos(mfph)) * mfs
let mf_if_im = 2 * mean((v(if_out)) * mfw * sin(mfph)) * mfs
let mfph = 2 * pi * 16700000000.0 * (time - 2e-08)
let mf_loif_re = 2 * mean((v(if_out)) * mfw * cos(mfph)) * mfs
let mf_loif_im = 2 * mean((v(if_out)) * mfw * sin(mfph)) * mfs
let mfph = 2 * pi * 16700000000.0 * (time - 2e-08)
let mf_lorf_re = 2 * mean((v(rf_port)) * mfw * cos(mfph)) * mfs
let mf_lorf_im = 2 * mean((v(rf_port)) * mfw * sin(mfph)) * mfs
let mfph = 2 * pi * 950000000.0 * (time - 2e-08)
let mf_flifa_re = 2 * mean((v(if_out)) * mfw * cos(mfph)) * mfs
let mf_flifa_im = 2 * mean((v(if_out)) * mfw * sin(mfph)) * mfs
let mfph = 2 * pi * 1050000000.0 * (time - 2e-08)
let mf_flifb_re = 2 * mean((v(if_out)) * mfw * cos(mfph)) * mfs
let mf_flifb_im = 2 * mean((v(if_out)) * mfw * sin(mfph)) * mfs
let mfph = 2 * pi * 16750000000.0 * (time - 2e-08)
let mf_fllorf_re = 2 * mean((v(rf_port)) * mfw * cos(mfph)) * mfs
let mf_fllorf_im = 2 * mean((v(rf_port)) * mfw * sin(mfph)) * mfs
let mfph = 2 * pi * 16750000000.0 * (time - 2e-08)
let mf_flloif_re = 2 * mean((v(if_out)) * mfw * cos(mfph)) * mfs
let mf_flloif_im = 2 * mean((v(if_out)) * mfw * sin(mfph)) * mfs
print mf_l
print mf_n
print mf_prail
print mf_lodiff_re
print mf_lodiff_im
print mf_if_re
print mf_if_im
print mf_loif_re
print mf_loif_im
print mf_lorf_re
print mf_lorf_im
print mf_flifa_re
print mf_flifa_im
print mf_flifb_re
print mf_flifb_im
print mf_fllorf_re
print mf_fllorf_im
print mf_flloif_re
print mf_flloif_im
destroy all
echo "MFEND ls_f17p70_p3_rf66"
echo "MFRUN ls_f17p70_p6_rf60"
alterparam f1 = 17700000000.0
alterparam f2 = 17700000000.0
alterparam flo = 16700000000.0
alterparam vrf1 = 0.0006324555320336759
alterparam vrf2 = 0.0
alterparam vlo = 1.7846168676856045
reset
op
let mf_dcirail = 0 - i(vdd)
let mf_dc_vce_q1 = v(c_q1)-v(e_q1)
let mf_dc_vbe_q1 = v(b_q1)-v(e_q1)
let mf_dc_ic_q1 = i(vic_q1)
let mf_dc_vce_q2 = v(c_q2)-v(e_q2)
let mf_dc_vbe_q2 = v(b_q2)-v(e_q2)
let mf_dc_ic_q2 = i(vic_q2)
let mf_dc_vce_q3 = v(c_q3)-v(x1)
let mf_dc_vbe_q3 = v(lo_p)-v(x1)
let mf_dc_ic_q3 = i(vic_q3)
let mf_dc_vce_q4 = v(c_q4)-v(x1)
let mf_dc_vbe_q4 = v(lo_n)-v(x1)
let mf_dc_ic_q4 = i(vic_q4)
let mf_dc_vce_q5 = v(c_q5)-v(x2)
let mf_dc_vbe_q5 = v(lo_p)-v(x2)
let mf_dc_ic_q5 = i(vic_q5)
let mf_dc_vce_q6 = v(c_q6)-v(x2)
let mf_dc_vbe_q6 = v(lo_n)-v(x2)
let mf_dc_ic_q6 = i(vic_q6)
let mf_dc_sink_tail = v(tail)
print mf_dcirail
print mf_dc_vce_q1
print mf_dc_vbe_q1
print mf_dc_ic_q1
print mf_dc_vce_q2
print mf_dc_vbe_q2
print mf_dc_ic_q2
print mf_dc_vce_q3
print mf_dc_vbe_q3
print mf_dc_ic_q3
print mf_dc_vce_q4
print mf_dc_vbe_q4
print mf_dc_ic_q4
print mf_dc_vce_q5
print mf_dc_vbe_q5
print mf_dc_ic_q5
print mf_dc_vce_q6
print mf_dc_vbe_q6
print mf_dc_ic_q6
print mf_dc_sink_tail
tran 1e-12 4e-08 0 1e-12
let mfq_vce_q1 = v(c_q1)-v(e_q1)
meas tran mf_su_vcemax_q1 MAX mfq_vce_q1 from=0.0 to=2e-08
meas tran mf_su_vcemin_q1 MIN mfq_vce_q1 from=0.0 to=2e-08
meas tran mf_ss_vcemax_q1 MAX mfq_vce_q1 from=2e-08 to=4e-08
meas tran mf_ss_vcemin_q1 MIN mfq_vce_q1 from=2e-08 to=4e-08
let mfq_vbe_q1 = v(b_q1)-v(e_q1)
meas tran mf_su_vbemax_q1 MAX mfq_vbe_q1 from=0.0 to=2e-08
meas tran mf_su_vbemin_q1 MIN mfq_vbe_q1 from=0.0 to=2e-08
meas tran mf_ss_vbemax_q1 MAX mfq_vbe_q1 from=2e-08 to=4e-08
meas tran mf_ss_vbemin_q1 MIN mfq_vbe_q1 from=2e-08 to=4e-08
let mfq_ic_q1 = i(vic_q1)
meas tran mf_su_icmax_q1 MAX mfq_ic_q1 from=0.0 to=2e-08
meas tran mf_su_icmin_q1 MIN mfq_ic_q1 from=0.0 to=2e-08
meas tran mf_ss_icmax_q1 MAX mfq_ic_q1 from=2e-08 to=4e-08
meas tran mf_ss_icmin_q1 MIN mfq_ic_q1 from=2e-08 to=4e-08
let mfq_vce_q2 = v(c_q2)-v(e_q2)
meas tran mf_su_vcemax_q2 MAX mfq_vce_q2 from=0.0 to=2e-08
meas tran mf_su_vcemin_q2 MIN mfq_vce_q2 from=0.0 to=2e-08
meas tran mf_ss_vcemax_q2 MAX mfq_vce_q2 from=2e-08 to=4e-08
meas tran mf_ss_vcemin_q2 MIN mfq_vce_q2 from=2e-08 to=4e-08
let mfq_vbe_q2 = v(b_q2)-v(e_q2)
meas tran mf_su_vbemax_q2 MAX mfq_vbe_q2 from=0.0 to=2e-08
meas tran mf_su_vbemin_q2 MIN mfq_vbe_q2 from=0.0 to=2e-08
meas tran mf_ss_vbemax_q2 MAX mfq_vbe_q2 from=2e-08 to=4e-08
meas tran mf_ss_vbemin_q2 MIN mfq_vbe_q2 from=2e-08 to=4e-08
let mfq_ic_q2 = i(vic_q2)
meas tran mf_su_icmax_q2 MAX mfq_ic_q2 from=0.0 to=2e-08
meas tran mf_su_icmin_q2 MIN mfq_ic_q2 from=0.0 to=2e-08
meas tran mf_ss_icmax_q2 MAX mfq_ic_q2 from=2e-08 to=4e-08
meas tran mf_ss_icmin_q2 MIN mfq_ic_q2 from=2e-08 to=4e-08
let mfq_vce_q3 = v(c_q3)-v(x1)
meas tran mf_su_vcemax_q3 MAX mfq_vce_q3 from=0.0 to=2e-08
meas tran mf_su_vcemin_q3 MIN mfq_vce_q3 from=0.0 to=2e-08
meas tran mf_ss_vcemax_q3 MAX mfq_vce_q3 from=2e-08 to=4e-08
meas tran mf_ss_vcemin_q3 MIN mfq_vce_q3 from=2e-08 to=4e-08
let mfq_vbe_q3 = v(lo_p)-v(x1)
meas tran mf_su_vbemax_q3 MAX mfq_vbe_q3 from=0.0 to=2e-08
meas tran mf_su_vbemin_q3 MIN mfq_vbe_q3 from=0.0 to=2e-08
meas tran mf_ss_vbemax_q3 MAX mfq_vbe_q3 from=2e-08 to=4e-08
meas tran mf_ss_vbemin_q3 MIN mfq_vbe_q3 from=2e-08 to=4e-08
let mfq_ic_q3 = i(vic_q3)
meas tran mf_su_icmax_q3 MAX mfq_ic_q3 from=0.0 to=2e-08
meas tran mf_su_icmin_q3 MIN mfq_ic_q3 from=0.0 to=2e-08
meas tran mf_ss_icmax_q3 MAX mfq_ic_q3 from=2e-08 to=4e-08
meas tran mf_ss_icmin_q3 MIN mfq_ic_q3 from=2e-08 to=4e-08
let mfq_vce_q4 = v(c_q4)-v(x1)
meas tran mf_su_vcemax_q4 MAX mfq_vce_q4 from=0.0 to=2e-08
meas tran mf_su_vcemin_q4 MIN mfq_vce_q4 from=0.0 to=2e-08
meas tran mf_ss_vcemax_q4 MAX mfq_vce_q4 from=2e-08 to=4e-08
meas tran mf_ss_vcemin_q4 MIN mfq_vce_q4 from=2e-08 to=4e-08
let mfq_vbe_q4 = v(lo_n)-v(x1)
meas tran mf_su_vbemax_q4 MAX mfq_vbe_q4 from=0.0 to=2e-08
meas tran mf_su_vbemin_q4 MIN mfq_vbe_q4 from=0.0 to=2e-08
meas tran mf_ss_vbemax_q4 MAX mfq_vbe_q4 from=2e-08 to=4e-08
meas tran mf_ss_vbemin_q4 MIN mfq_vbe_q4 from=2e-08 to=4e-08
let mfq_ic_q4 = i(vic_q4)
meas tran mf_su_icmax_q4 MAX mfq_ic_q4 from=0.0 to=2e-08
meas tran mf_su_icmin_q4 MIN mfq_ic_q4 from=0.0 to=2e-08
meas tran mf_ss_icmax_q4 MAX mfq_ic_q4 from=2e-08 to=4e-08
meas tran mf_ss_icmin_q4 MIN mfq_ic_q4 from=2e-08 to=4e-08
let mfq_vce_q5 = v(c_q5)-v(x2)
meas tran mf_su_vcemax_q5 MAX mfq_vce_q5 from=0.0 to=2e-08
meas tran mf_su_vcemin_q5 MIN mfq_vce_q5 from=0.0 to=2e-08
meas tran mf_ss_vcemax_q5 MAX mfq_vce_q5 from=2e-08 to=4e-08
meas tran mf_ss_vcemin_q5 MIN mfq_vce_q5 from=2e-08 to=4e-08
let mfq_vbe_q5 = v(lo_p)-v(x2)
meas tran mf_su_vbemax_q5 MAX mfq_vbe_q5 from=0.0 to=2e-08
meas tran mf_su_vbemin_q5 MIN mfq_vbe_q5 from=0.0 to=2e-08
meas tran mf_ss_vbemax_q5 MAX mfq_vbe_q5 from=2e-08 to=4e-08
meas tran mf_ss_vbemin_q5 MIN mfq_vbe_q5 from=2e-08 to=4e-08
let mfq_ic_q5 = i(vic_q5)
meas tran mf_su_icmax_q5 MAX mfq_ic_q5 from=0.0 to=2e-08
meas tran mf_su_icmin_q5 MIN mfq_ic_q5 from=0.0 to=2e-08
meas tran mf_ss_icmax_q5 MAX mfq_ic_q5 from=2e-08 to=4e-08
meas tran mf_ss_icmin_q5 MIN mfq_ic_q5 from=2e-08 to=4e-08
let mfq_vce_q6 = v(c_q6)-v(x2)
meas tran mf_su_vcemax_q6 MAX mfq_vce_q6 from=0.0 to=2e-08
meas tran mf_su_vcemin_q6 MIN mfq_vce_q6 from=0.0 to=2e-08
meas tran mf_ss_vcemax_q6 MAX mfq_vce_q6 from=2e-08 to=4e-08
meas tran mf_ss_vcemin_q6 MIN mfq_vce_q6 from=2e-08 to=4e-08
let mfq_vbe_q6 = v(lo_n)-v(x2)
meas tran mf_su_vbemax_q6 MAX mfq_vbe_q6 from=0.0 to=2e-08
meas tran mf_su_vbemin_q6 MIN mfq_vbe_q6 from=0.0 to=2e-08
meas tran mf_ss_vbemax_q6 MAX mfq_vbe_q6 from=2e-08 to=4e-08
meas tran mf_ss_vbemin_q6 MIN mfq_vbe_q6 from=2e-08 to=4e-08
let mfq_ic_q6 = i(vic_q6)
meas tran mf_su_icmax_q6 MAX mfq_ic_q6 from=0.0 to=2e-08
meas tran mf_su_icmin_q6 MIN mfq_ic_q6 from=0.0 to=2e-08
meas tran mf_ss_icmax_q6 MAX mfq_ic_q6 from=2e-08 to=4e-08
meas tran mf_ss_icmin_q6 MIN mfq_ic_q6 from=2e-08 to=4e-08
meas tran mf_su_sinkmin_tail MIN v(tail) from=0.0 to=2e-08
meas tran mf_ss_sinkmin_tail MIN v(tail) from=2e-08 to=4e-08
print mf_su_vcemax_q1
print mf_su_vcemin_q1
print mf_ss_vcemax_q1
print mf_ss_vcemin_q1
print mf_su_vbemax_q1
print mf_su_vbemin_q1
print mf_ss_vbemax_q1
print mf_ss_vbemin_q1
print mf_su_icmax_q1
print mf_su_icmin_q1
print mf_ss_icmax_q1
print mf_ss_icmin_q1
print mf_su_vcemax_q2
print mf_su_vcemin_q2
print mf_ss_vcemax_q2
print mf_ss_vcemin_q2
print mf_su_vbemax_q2
print mf_su_vbemin_q2
print mf_ss_vbemax_q2
print mf_ss_vbemin_q2
print mf_su_icmax_q2
print mf_su_icmin_q2
print mf_ss_icmax_q2
print mf_ss_icmin_q2
print mf_su_vcemax_q3
print mf_su_vcemin_q3
print mf_ss_vcemax_q3
print mf_ss_vcemin_q3
print mf_su_vbemax_q3
print mf_su_vbemin_q3
print mf_ss_vbemax_q3
print mf_ss_vbemin_q3
print mf_su_icmax_q3
print mf_su_icmin_q3
print mf_ss_icmax_q3
print mf_ss_icmin_q3
print mf_su_vcemax_q4
print mf_su_vcemin_q4
print mf_ss_vcemax_q4
print mf_ss_vcemin_q4
print mf_su_vbemax_q4
print mf_su_vbemin_q4
print mf_ss_vbemax_q4
print mf_ss_vbemin_q4
print mf_su_icmax_q4
print mf_su_icmin_q4
print mf_ss_icmax_q4
print mf_ss_icmin_q4
print mf_su_vcemax_q5
print mf_su_vcemin_q5
print mf_ss_vcemax_q5
print mf_ss_vcemin_q5
print mf_su_vbemax_q5
print mf_su_vbemin_q5
print mf_ss_vbemax_q5
print mf_ss_vbemin_q5
print mf_su_icmax_q5
print mf_su_icmin_q5
print mf_ss_icmax_q5
print mf_ss_icmin_q5
print mf_su_vcemax_q6
print mf_su_vcemin_q6
print mf_ss_vcemax_q6
print mf_ss_vcemin_q6
print mf_su_vbemax_q6
print mf_su_vbemin_q6
print mf_ss_vbemax_q6
print mf_ss_vbemin_q6
print mf_su_icmax_q6
print mf_su_icmin_q6
print mf_ss_icmax_q6
print mf_ss_icmin_q6
print mf_su_sinkmin_tail
print mf_ss_sinkmin_tail
linearize
let mf_l = length(time)
let mfw = (time ge 1.99995e-08) * (time lt 3.99995e-08)
let mf_n = mean(mfw) * mf_l
let mfs = mf_l / mf_n
let mf_prail = mean(v(vdd) * (0 - i(vdd)) * mfw) * mfs
let mfph = 2 * pi * 16700000000.0 * (time - 2e-08)
let mf_lodiff_re = 2 * mean((v(lo_p)-v(lo_n)) * mfw * cos(mfph)) * mfs
let mf_lodiff_im = 2 * mean((v(lo_p)-v(lo_n)) * mfw * sin(mfph)) * mfs
let mfph = 2 * pi * 1000000000.0 * (time - 2e-08)
let mf_if_re = 2 * mean((v(if_out)) * mfw * cos(mfph)) * mfs
let mf_if_im = 2 * mean((v(if_out)) * mfw * sin(mfph)) * mfs
let mfph = 2 * pi * 16700000000.0 * (time - 2e-08)
let mf_loif_re = 2 * mean((v(if_out)) * mfw * cos(mfph)) * mfs
let mf_loif_im = 2 * mean((v(if_out)) * mfw * sin(mfph)) * mfs
let mfph = 2 * pi * 16700000000.0 * (time - 2e-08)
let mf_lorf_re = 2 * mean((v(rf_port)) * mfw * cos(mfph)) * mfs
let mf_lorf_im = 2 * mean((v(rf_port)) * mfw * sin(mfph)) * mfs
let mfph = 2 * pi * 950000000.0 * (time - 2e-08)
let mf_flifa_re = 2 * mean((v(if_out)) * mfw * cos(mfph)) * mfs
let mf_flifa_im = 2 * mean((v(if_out)) * mfw * sin(mfph)) * mfs
let mfph = 2 * pi * 1050000000.0 * (time - 2e-08)
let mf_flifb_re = 2 * mean((v(if_out)) * mfw * cos(mfph)) * mfs
let mf_flifb_im = 2 * mean((v(if_out)) * mfw * sin(mfph)) * mfs
let mfph = 2 * pi * 16750000000.0 * (time - 2e-08)
let mf_fllorf_re = 2 * mean((v(rf_port)) * mfw * cos(mfph)) * mfs
let mf_fllorf_im = 2 * mean((v(rf_port)) * mfw * sin(mfph)) * mfs
let mfph = 2 * pi * 16750000000.0 * (time - 2e-08)
let mf_flloif_re = 2 * mean((v(if_out)) * mfw * cos(mfph)) * mfs
let mf_flloif_im = 2 * mean((v(if_out)) * mfw * sin(mfph)) * mfs
print mf_l
print mf_n
print mf_prail
print mf_lodiff_re
print mf_lodiff_im
print mf_if_re
print mf_if_im
print mf_loif_re
print mf_loif_im
print mf_lorf_re
print mf_lorf_im
print mf_flifa_re
print mf_flifa_im
print mf_flifb_re
print mf_flifb_im
print mf_fllorf_re
print mf_fllorf_im
print mf_flloif_re
print mf_flloif_im
destroy all
echo "MFEND ls_f17p70_p6_rf60"
echo "MFRUN ls_f17p70_p6_rf66"
alterparam f1 = 17700000000.0
alterparam f2 = 17700000000.0
alterparam flo = 16700000000.0
alterparam vrf1 = 0.00031697863849222284
alterparam vrf2 = 0.0
alterparam vlo = 1.7846168676856045
reset
op
let mf_dcirail = 0 - i(vdd)
let mf_dc_vce_q1 = v(c_q1)-v(e_q1)
let mf_dc_vbe_q1 = v(b_q1)-v(e_q1)
let mf_dc_ic_q1 = i(vic_q1)
let mf_dc_vce_q2 = v(c_q2)-v(e_q2)
let mf_dc_vbe_q2 = v(b_q2)-v(e_q2)
let mf_dc_ic_q2 = i(vic_q2)
let mf_dc_vce_q3 = v(c_q3)-v(x1)
let mf_dc_vbe_q3 = v(lo_p)-v(x1)
let mf_dc_ic_q3 = i(vic_q3)
let mf_dc_vce_q4 = v(c_q4)-v(x1)
let mf_dc_vbe_q4 = v(lo_n)-v(x1)
let mf_dc_ic_q4 = i(vic_q4)
let mf_dc_vce_q5 = v(c_q5)-v(x2)
let mf_dc_vbe_q5 = v(lo_p)-v(x2)
let mf_dc_ic_q5 = i(vic_q5)
let mf_dc_vce_q6 = v(c_q6)-v(x2)
let mf_dc_vbe_q6 = v(lo_n)-v(x2)
let mf_dc_ic_q6 = i(vic_q6)
let mf_dc_sink_tail = v(tail)
print mf_dcirail
print mf_dc_vce_q1
print mf_dc_vbe_q1
print mf_dc_ic_q1
print mf_dc_vce_q2
print mf_dc_vbe_q2
print mf_dc_ic_q2
print mf_dc_vce_q3
print mf_dc_vbe_q3
print mf_dc_ic_q3
print mf_dc_vce_q4
print mf_dc_vbe_q4
print mf_dc_ic_q4
print mf_dc_vce_q5
print mf_dc_vbe_q5
print mf_dc_ic_q5
print mf_dc_vce_q6
print mf_dc_vbe_q6
print mf_dc_ic_q6
print mf_dc_sink_tail
tran 1e-12 4e-08 0 1e-12
let mfq_vce_q1 = v(c_q1)-v(e_q1)
meas tran mf_su_vcemax_q1 MAX mfq_vce_q1 from=0.0 to=2e-08
meas tran mf_su_vcemin_q1 MIN mfq_vce_q1 from=0.0 to=2e-08
meas tran mf_ss_vcemax_q1 MAX mfq_vce_q1 from=2e-08 to=4e-08
meas tran mf_ss_vcemin_q1 MIN mfq_vce_q1 from=2e-08 to=4e-08
let mfq_vbe_q1 = v(b_q1)-v(e_q1)
meas tran mf_su_vbemax_q1 MAX mfq_vbe_q1 from=0.0 to=2e-08
meas tran mf_su_vbemin_q1 MIN mfq_vbe_q1 from=0.0 to=2e-08
meas tran mf_ss_vbemax_q1 MAX mfq_vbe_q1 from=2e-08 to=4e-08
meas tran mf_ss_vbemin_q1 MIN mfq_vbe_q1 from=2e-08 to=4e-08
let mfq_ic_q1 = i(vic_q1)
meas tran mf_su_icmax_q1 MAX mfq_ic_q1 from=0.0 to=2e-08
meas tran mf_su_icmin_q1 MIN mfq_ic_q1 from=0.0 to=2e-08
meas tran mf_ss_icmax_q1 MAX mfq_ic_q1 from=2e-08 to=4e-08
meas tran mf_ss_icmin_q1 MIN mfq_ic_q1 from=2e-08 to=4e-08
let mfq_vce_q2 = v(c_q2)-v(e_q2)
meas tran mf_su_vcemax_q2 MAX mfq_vce_q2 from=0.0 to=2e-08
meas tran mf_su_vcemin_q2 MIN mfq_vce_q2 from=0.0 to=2e-08
meas tran mf_ss_vcemax_q2 MAX mfq_vce_q2 from=2e-08 to=4e-08
meas tran mf_ss_vcemin_q2 MIN mfq_vce_q2 from=2e-08 to=4e-08
let mfq_vbe_q2 = v(b_q2)-v(e_q2)
meas tran mf_su_vbemax_q2 MAX mfq_vbe_q2 from=0.0 to=2e-08
meas tran mf_su_vbemin_q2 MIN mfq_vbe_q2 from=0.0 to=2e-08
meas tran mf_ss_vbemax_q2 MAX mfq_vbe_q2 from=2e-08 to=4e-08
meas tran mf_ss_vbemin_q2 MIN mfq_vbe_q2 from=2e-08 to=4e-08
let mfq_ic_q2 = i(vic_q2)
meas tran mf_su_icmax_q2 MAX mfq_ic_q2 from=0.0 to=2e-08
meas tran mf_su_icmin_q2 MIN mfq_ic_q2 from=0.0 to=2e-08
meas tran mf_ss_icmax_q2 MAX mfq_ic_q2 from=2e-08 to=4e-08
meas tran mf_ss_icmin_q2 MIN mfq_ic_q2 from=2e-08 to=4e-08
let mfq_vce_q3 = v(c_q3)-v(x1)
meas tran mf_su_vcemax_q3 MAX mfq_vce_q3 from=0.0 to=2e-08
meas tran mf_su_vcemin_q3 MIN mfq_vce_q3 from=0.0 to=2e-08
meas tran mf_ss_vcemax_q3 MAX mfq_vce_q3 from=2e-08 to=4e-08
meas tran mf_ss_vcemin_q3 MIN mfq_vce_q3 from=2e-08 to=4e-08
let mfq_vbe_q3 = v(lo_p)-v(x1)
meas tran mf_su_vbemax_q3 MAX mfq_vbe_q3 from=0.0 to=2e-08
meas tran mf_su_vbemin_q3 MIN mfq_vbe_q3 from=0.0 to=2e-08
meas tran mf_ss_vbemax_q3 MAX mfq_vbe_q3 from=2e-08 to=4e-08
meas tran mf_ss_vbemin_q3 MIN mfq_vbe_q3 from=2e-08 to=4e-08
let mfq_ic_q3 = i(vic_q3)
meas tran mf_su_icmax_q3 MAX mfq_ic_q3 from=0.0 to=2e-08
meas tran mf_su_icmin_q3 MIN mfq_ic_q3 from=0.0 to=2e-08
meas tran mf_ss_icmax_q3 MAX mfq_ic_q3 from=2e-08 to=4e-08
meas tran mf_ss_icmin_q3 MIN mfq_ic_q3 from=2e-08 to=4e-08
let mfq_vce_q4 = v(c_q4)-v(x1)
meas tran mf_su_vcemax_q4 MAX mfq_vce_q4 from=0.0 to=2e-08
meas tran mf_su_vcemin_q4 MIN mfq_vce_q4 from=0.0 to=2e-08
meas tran mf_ss_vcemax_q4 MAX mfq_vce_q4 from=2e-08 to=4e-08
meas tran mf_ss_vcemin_q4 MIN mfq_vce_q4 from=2e-08 to=4e-08
let mfq_vbe_q4 = v(lo_n)-v(x1)
meas tran mf_su_vbemax_q4 MAX mfq_vbe_q4 from=0.0 to=2e-08
meas tran mf_su_vbemin_q4 MIN mfq_vbe_q4 from=0.0 to=2e-08
meas tran mf_ss_vbemax_q4 MAX mfq_vbe_q4 from=2e-08 to=4e-08
meas tran mf_ss_vbemin_q4 MIN mfq_vbe_q4 from=2e-08 to=4e-08
let mfq_ic_q4 = i(vic_q4)
meas tran mf_su_icmax_q4 MAX mfq_ic_q4 from=0.0 to=2e-08
meas tran mf_su_icmin_q4 MIN mfq_ic_q4 from=0.0 to=2e-08
meas tran mf_ss_icmax_q4 MAX mfq_ic_q4 from=2e-08 to=4e-08
meas tran mf_ss_icmin_q4 MIN mfq_ic_q4 from=2e-08 to=4e-08
let mfq_vce_q5 = v(c_q5)-v(x2)
meas tran mf_su_vcemax_q5 MAX mfq_vce_q5 from=0.0 to=2e-08
meas tran mf_su_vcemin_q5 MIN mfq_vce_q5 from=0.0 to=2e-08
meas tran mf_ss_vcemax_q5 MAX mfq_vce_q5 from=2e-08 to=4e-08
meas tran mf_ss_vcemin_q5 MIN mfq_vce_q5 from=2e-08 to=4e-08
let mfq_vbe_q5 = v(lo_p)-v(x2)
meas tran mf_su_vbemax_q5 MAX mfq_vbe_q5 from=0.0 to=2e-08
meas tran mf_su_vbemin_q5 MIN mfq_vbe_q5 from=0.0 to=2e-08
meas tran mf_ss_vbemax_q5 MAX mfq_vbe_q5 from=2e-08 to=4e-08
meas tran mf_ss_vbemin_q5 MIN mfq_vbe_q5 from=2e-08 to=4e-08
let mfq_ic_q5 = i(vic_q5)
meas tran mf_su_icmax_q5 MAX mfq_ic_q5 from=0.0 to=2e-08
meas tran mf_su_icmin_q5 MIN mfq_ic_q5 from=0.0 to=2e-08
meas tran mf_ss_icmax_q5 MAX mfq_ic_q5 from=2e-08 to=4e-08
meas tran mf_ss_icmin_q5 MIN mfq_ic_q5 from=2e-08 to=4e-08
let mfq_vce_q6 = v(c_q6)-v(x2)
meas tran mf_su_vcemax_q6 MAX mfq_vce_q6 from=0.0 to=2e-08
meas tran mf_su_vcemin_q6 MIN mfq_vce_q6 from=0.0 to=2e-08
meas tran mf_ss_vcemax_q6 MAX mfq_vce_q6 from=2e-08 to=4e-08
meas tran mf_ss_vcemin_q6 MIN mfq_vce_q6 from=2e-08 to=4e-08
let mfq_vbe_q6 = v(lo_n)-v(x2)
meas tran mf_su_vbemax_q6 MAX mfq_vbe_q6 from=0.0 to=2e-08
meas tran mf_su_vbemin_q6 MIN mfq_vbe_q6 from=0.0 to=2e-08
meas tran mf_ss_vbemax_q6 MAX mfq_vbe_q6 from=2e-08 to=4e-08
meas tran mf_ss_vbemin_q6 MIN mfq_vbe_q6 from=2e-08 to=4e-08
let mfq_ic_q6 = i(vic_q6)
meas tran mf_su_icmax_q6 MAX mfq_ic_q6 from=0.0 to=2e-08
meas tran mf_su_icmin_q6 MIN mfq_ic_q6 from=0.0 to=2e-08
meas tran mf_ss_icmax_q6 MAX mfq_ic_q6 from=2e-08 to=4e-08
meas tran mf_ss_icmin_q6 MIN mfq_ic_q6 from=2e-08 to=4e-08
meas tran mf_su_sinkmin_tail MIN v(tail) from=0.0 to=2e-08
meas tran mf_ss_sinkmin_tail MIN v(tail) from=2e-08 to=4e-08
print mf_su_vcemax_q1
print mf_su_vcemin_q1
print mf_ss_vcemax_q1
print mf_ss_vcemin_q1
print mf_su_vbemax_q1
print mf_su_vbemin_q1
print mf_ss_vbemax_q1
print mf_ss_vbemin_q1
print mf_su_icmax_q1
print mf_su_icmin_q1
print mf_ss_icmax_q1
print mf_ss_icmin_q1
print mf_su_vcemax_q2
print mf_su_vcemin_q2
print mf_ss_vcemax_q2
print mf_ss_vcemin_q2
print mf_su_vbemax_q2
print mf_su_vbemin_q2
print mf_ss_vbemax_q2
print mf_ss_vbemin_q2
print mf_su_icmax_q2
print mf_su_icmin_q2
print mf_ss_icmax_q2
print mf_ss_icmin_q2
print mf_su_vcemax_q3
print mf_su_vcemin_q3
print mf_ss_vcemax_q3
print mf_ss_vcemin_q3
print mf_su_vbemax_q3
print mf_su_vbemin_q3
print mf_ss_vbemax_q3
print mf_ss_vbemin_q3
print mf_su_icmax_q3
print mf_su_icmin_q3
print mf_ss_icmax_q3
print mf_ss_icmin_q3
print mf_su_vcemax_q4
print mf_su_vcemin_q4
print mf_ss_vcemax_q4
print mf_ss_vcemin_q4
print mf_su_vbemax_q4
print mf_su_vbemin_q4
print mf_ss_vbemax_q4
print mf_ss_vbemin_q4
print mf_su_icmax_q4
print mf_su_icmin_q4
print mf_ss_icmax_q4
print mf_ss_icmin_q4
print mf_su_vcemax_q5
print mf_su_vcemin_q5
print mf_ss_vcemax_q5
print mf_ss_vcemin_q5
print mf_su_vbemax_q5
print mf_su_vbemin_q5
print mf_ss_vbemax_q5
print mf_ss_vbemin_q5
print mf_su_icmax_q5
print mf_su_icmin_q5
print mf_ss_icmax_q5
print mf_ss_icmin_q5
print mf_su_vcemax_q6
print mf_su_vcemin_q6
print mf_ss_vcemax_q6
print mf_ss_vcemin_q6
print mf_su_vbemax_q6
print mf_su_vbemin_q6
print mf_ss_vbemax_q6
print mf_ss_vbemin_q6
print mf_su_icmax_q6
print mf_su_icmin_q6
print mf_ss_icmax_q6
print mf_ss_icmin_q6
print mf_su_sinkmin_tail
print mf_ss_sinkmin_tail
linearize
let mf_l = length(time)
let mfw = (time ge 1.99995e-08) * (time lt 3.99995e-08)
let mf_n = mean(mfw) * mf_l
let mfs = mf_l / mf_n
let mf_prail = mean(v(vdd) * (0 - i(vdd)) * mfw) * mfs
let mfph = 2 * pi * 16700000000.0 * (time - 2e-08)
let mf_lodiff_re = 2 * mean((v(lo_p)-v(lo_n)) * mfw * cos(mfph)) * mfs
let mf_lodiff_im = 2 * mean((v(lo_p)-v(lo_n)) * mfw * sin(mfph)) * mfs
let mfph = 2 * pi * 1000000000.0 * (time - 2e-08)
let mf_if_re = 2 * mean((v(if_out)) * mfw * cos(mfph)) * mfs
let mf_if_im = 2 * mean((v(if_out)) * mfw * sin(mfph)) * mfs
let mfph = 2 * pi * 16700000000.0 * (time - 2e-08)
let mf_loif_re = 2 * mean((v(if_out)) * mfw * cos(mfph)) * mfs
let mf_loif_im = 2 * mean((v(if_out)) * mfw * sin(mfph)) * mfs
let mfph = 2 * pi * 16700000000.0 * (time - 2e-08)
let mf_lorf_re = 2 * mean((v(rf_port)) * mfw * cos(mfph)) * mfs
let mf_lorf_im = 2 * mean((v(rf_port)) * mfw * sin(mfph)) * mfs
let mfph = 2 * pi * 950000000.0 * (time - 2e-08)
let mf_flifa_re = 2 * mean((v(if_out)) * mfw * cos(mfph)) * mfs
let mf_flifa_im = 2 * mean((v(if_out)) * mfw * sin(mfph)) * mfs
let mfph = 2 * pi * 1050000000.0 * (time - 2e-08)
let mf_flifb_re = 2 * mean((v(if_out)) * mfw * cos(mfph)) * mfs
let mf_flifb_im = 2 * mean((v(if_out)) * mfw * sin(mfph)) * mfs
let mfph = 2 * pi * 16750000000.0 * (time - 2e-08)
let mf_fllorf_re = 2 * mean((v(rf_port)) * mfw * cos(mfph)) * mfs
let mf_fllorf_im = 2 * mean((v(rf_port)) * mfw * sin(mfph)) * mfs
let mfph = 2 * pi * 16750000000.0 * (time - 2e-08)
let mf_flloif_re = 2 * mean((v(if_out)) * mfw * cos(mfph)) * mfs
let mf_flloif_im = 2 * mean((v(if_out)) * mfw * sin(mfph)) * mfs
print mf_l
print mf_n
print mf_prail
print mf_lodiff_re
print mf_lodiff_im
print mf_if_re
print mf_if_im
print mf_loif_re
print mf_loif_im
print mf_lorf_re
print mf_lorf_im
print mf_flifa_re
print mf_flifa_im
print mf_flifb_re
print mf_flifb_im
print mf_fllorf_re
print mf_fllorf_im
print mf_flloif_re
print mf_flloif_im
destroy all
echo "MFEND ls_f17p70_p6_rf66"
echo "MFRUN ls_f19p45_m30_rf60"
alterparam f1 = 19450000000.0
alterparam f2 = 19450000000.0
alterparam flo = 18450000000.0
alterparam vrf1 = 0.0006324555320336759
alterparam vrf2 = 0.0
alterparam vlo = 0.0282842712474619
reset
op
let mf_dcirail = 0 - i(vdd)
let mf_dc_vce_q1 = v(c_q1)-v(e_q1)
let mf_dc_vbe_q1 = v(b_q1)-v(e_q1)
let mf_dc_ic_q1 = i(vic_q1)
let mf_dc_vce_q2 = v(c_q2)-v(e_q2)
let mf_dc_vbe_q2 = v(b_q2)-v(e_q2)
let mf_dc_ic_q2 = i(vic_q2)
let mf_dc_vce_q3 = v(c_q3)-v(x1)
let mf_dc_vbe_q3 = v(lo_p)-v(x1)
let mf_dc_ic_q3 = i(vic_q3)
let mf_dc_vce_q4 = v(c_q4)-v(x1)
let mf_dc_vbe_q4 = v(lo_n)-v(x1)
let mf_dc_ic_q4 = i(vic_q4)
let mf_dc_vce_q5 = v(c_q5)-v(x2)
let mf_dc_vbe_q5 = v(lo_p)-v(x2)
let mf_dc_ic_q5 = i(vic_q5)
let mf_dc_vce_q6 = v(c_q6)-v(x2)
let mf_dc_vbe_q6 = v(lo_n)-v(x2)
let mf_dc_ic_q6 = i(vic_q6)
let mf_dc_sink_tail = v(tail)
print mf_dcirail
print mf_dc_vce_q1
print mf_dc_vbe_q1
print mf_dc_ic_q1
print mf_dc_vce_q2
print mf_dc_vbe_q2
print mf_dc_ic_q2
print mf_dc_vce_q3
print mf_dc_vbe_q3
print mf_dc_ic_q3
print mf_dc_vce_q4
print mf_dc_vbe_q4
print mf_dc_ic_q4
print mf_dc_vce_q5
print mf_dc_vbe_q5
print mf_dc_ic_q5
print mf_dc_vce_q6
print mf_dc_vbe_q6
print mf_dc_ic_q6
print mf_dc_sink_tail
tran 1e-12 4e-08 0 1e-12
let mfq_vce_q1 = v(c_q1)-v(e_q1)
meas tran mf_su_vcemax_q1 MAX mfq_vce_q1 from=0.0 to=2e-08
meas tran mf_su_vcemin_q1 MIN mfq_vce_q1 from=0.0 to=2e-08
meas tran mf_ss_vcemax_q1 MAX mfq_vce_q1 from=2e-08 to=4e-08
meas tran mf_ss_vcemin_q1 MIN mfq_vce_q1 from=2e-08 to=4e-08
let mfq_vbe_q1 = v(b_q1)-v(e_q1)
meas tran mf_su_vbemax_q1 MAX mfq_vbe_q1 from=0.0 to=2e-08
meas tran mf_su_vbemin_q1 MIN mfq_vbe_q1 from=0.0 to=2e-08
meas tran mf_ss_vbemax_q1 MAX mfq_vbe_q1 from=2e-08 to=4e-08
meas tran mf_ss_vbemin_q1 MIN mfq_vbe_q1 from=2e-08 to=4e-08
let mfq_ic_q1 = i(vic_q1)
meas tran mf_su_icmax_q1 MAX mfq_ic_q1 from=0.0 to=2e-08
meas tran mf_su_icmin_q1 MIN mfq_ic_q1 from=0.0 to=2e-08
meas tran mf_ss_icmax_q1 MAX mfq_ic_q1 from=2e-08 to=4e-08
meas tran mf_ss_icmin_q1 MIN mfq_ic_q1 from=2e-08 to=4e-08
let mfq_vce_q2 = v(c_q2)-v(e_q2)
meas tran mf_su_vcemax_q2 MAX mfq_vce_q2 from=0.0 to=2e-08
meas tran mf_su_vcemin_q2 MIN mfq_vce_q2 from=0.0 to=2e-08
meas tran mf_ss_vcemax_q2 MAX mfq_vce_q2 from=2e-08 to=4e-08
meas tran mf_ss_vcemin_q2 MIN mfq_vce_q2 from=2e-08 to=4e-08
let mfq_vbe_q2 = v(b_q2)-v(e_q2)
meas tran mf_su_vbemax_q2 MAX mfq_vbe_q2 from=0.0 to=2e-08
meas tran mf_su_vbemin_q2 MIN mfq_vbe_q2 from=0.0 to=2e-08
meas tran mf_ss_vbemax_q2 MAX mfq_vbe_q2 from=2e-08 to=4e-08
meas tran mf_ss_vbemin_q2 MIN mfq_vbe_q2 from=2e-08 to=4e-08
let mfq_ic_q2 = i(vic_q2)
meas tran mf_su_icmax_q2 MAX mfq_ic_q2 from=0.0 to=2e-08
meas tran mf_su_icmin_q2 MIN mfq_ic_q2 from=0.0 to=2e-08
meas tran mf_ss_icmax_q2 MAX mfq_ic_q2 from=2e-08 to=4e-08
meas tran mf_ss_icmin_q2 MIN mfq_ic_q2 from=2e-08 to=4e-08
let mfq_vce_q3 = v(c_q3)-v(x1)
meas tran mf_su_vcemax_q3 MAX mfq_vce_q3 from=0.0 to=2e-08
meas tran mf_su_vcemin_q3 MIN mfq_vce_q3 from=0.0 to=2e-08
meas tran mf_ss_vcemax_q3 MAX mfq_vce_q3 from=2e-08 to=4e-08
meas tran mf_ss_vcemin_q3 MIN mfq_vce_q3 from=2e-08 to=4e-08
let mfq_vbe_q3 = v(lo_p)-v(x1)
meas tran mf_su_vbemax_q3 MAX mfq_vbe_q3 from=0.0 to=2e-08
meas tran mf_su_vbemin_q3 MIN mfq_vbe_q3 from=0.0 to=2e-08
meas tran mf_ss_vbemax_q3 MAX mfq_vbe_q3 from=2e-08 to=4e-08
meas tran mf_ss_vbemin_q3 MIN mfq_vbe_q3 from=2e-08 to=4e-08
let mfq_ic_q3 = i(vic_q3)
meas tran mf_su_icmax_q3 MAX mfq_ic_q3 from=0.0 to=2e-08
meas tran mf_su_icmin_q3 MIN mfq_ic_q3 from=0.0 to=2e-08
meas tran mf_ss_icmax_q3 MAX mfq_ic_q3 from=2e-08 to=4e-08
meas tran mf_ss_icmin_q3 MIN mfq_ic_q3 from=2e-08 to=4e-08
let mfq_vce_q4 = v(c_q4)-v(x1)
meas tran mf_su_vcemax_q4 MAX mfq_vce_q4 from=0.0 to=2e-08
meas tran mf_su_vcemin_q4 MIN mfq_vce_q4 from=0.0 to=2e-08
meas tran mf_ss_vcemax_q4 MAX mfq_vce_q4 from=2e-08 to=4e-08
meas tran mf_ss_vcemin_q4 MIN mfq_vce_q4 from=2e-08 to=4e-08
let mfq_vbe_q4 = v(lo_n)-v(x1)
meas tran mf_su_vbemax_q4 MAX mfq_vbe_q4 from=0.0 to=2e-08
meas tran mf_su_vbemin_q4 MIN mfq_vbe_q4 from=0.0 to=2e-08
meas tran mf_ss_vbemax_q4 MAX mfq_vbe_q4 from=2e-08 to=4e-08
meas tran mf_ss_vbemin_q4 MIN mfq_vbe_q4 from=2e-08 to=4e-08
let mfq_ic_q4 = i(vic_q4)
meas tran mf_su_icmax_q4 MAX mfq_ic_q4 from=0.0 to=2e-08
meas tran mf_su_icmin_q4 MIN mfq_ic_q4 from=0.0 to=2e-08
meas tran mf_ss_icmax_q4 MAX mfq_ic_q4 from=2e-08 to=4e-08
meas tran mf_ss_icmin_q4 MIN mfq_ic_q4 from=2e-08 to=4e-08
let mfq_vce_q5 = v(c_q5)-v(x2)
meas tran mf_su_vcemax_q5 MAX mfq_vce_q5 from=0.0 to=2e-08
meas tran mf_su_vcemin_q5 MIN mfq_vce_q5 from=0.0 to=2e-08
meas tran mf_ss_vcemax_q5 MAX mfq_vce_q5 from=2e-08 to=4e-08
meas tran mf_ss_vcemin_q5 MIN mfq_vce_q5 from=2e-08 to=4e-08
let mfq_vbe_q5 = v(lo_p)-v(x2)
meas tran mf_su_vbemax_q5 MAX mfq_vbe_q5 from=0.0 to=2e-08
meas tran mf_su_vbemin_q5 MIN mfq_vbe_q5 from=0.0 to=2e-08
meas tran mf_ss_vbemax_q5 MAX mfq_vbe_q5 from=2e-08 to=4e-08
meas tran mf_ss_vbemin_q5 MIN mfq_vbe_q5 from=2e-08 to=4e-08
let mfq_ic_q5 = i(vic_q5)
meas tran mf_su_icmax_q5 MAX mfq_ic_q5 from=0.0 to=2e-08
meas tran mf_su_icmin_q5 MIN mfq_ic_q5 from=0.0 to=2e-08
meas tran mf_ss_icmax_q5 MAX mfq_ic_q5 from=2e-08 to=4e-08
meas tran mf_ss_icmin_q5 MIN mfq_ic_q5 from=2e-08 to=4e-08
let mfq_vce_q6 = v(c_q6)-v(x2)
meas tran mf_su_vcemax_q6 MAX mfq_vce_q6 from=0.0 to=2e-08
meas tran mf_su_vcemin_q6 MIN mfq_vce_q6 from=0.0 to=2e-08
meas tran mf_ss_vcemax_q6 MAX mfq_vce_q6 from=2e-08 to=4e-08
meas tran mf_ss_vcemin_q6 MIN mfq_vce_q6 from=2e-08 to=4e-08
let mfq_vbe_q6 = v(lo_n)-v(x2)
meas tran mf_su_vbemax_q6 MAX mfq_vbe_q6 from=0.0 to=2e-08
meas tran mf_su_vbemin_q6 MIN mfq_vbe_q6 from=0.0 to=2e-08
meas tran mf_ss_vbemax_q6 MAX mfq_vbe_q6 from=2e-08 to=4e-08
meas tran mf_ss_vbemin_q6 MIN mfq_vbe_q6 from=2e-08 to=4e-08
let mfq_ic_q6 = i(vic_q6)
meas tran mf_su_icmax_q6 MAX mfq_ic_q6 from=0.0 to=2e-08
meas tran mf_su_icmin_q6 MIN mfq_ic_q6 from=0.0 to=2e-08
meas tran mf_ss_icmax_q6 MAX mfq_ic_q6 from=2e-08 to=4e-08
meas tran mf_ss_icmin_q6 MIN mfq_ic_q6 from=2e-08 to=4e-08
meas tran mf_su_sinkmin_tail MIN v(tail) from=0.0 to=2e-08
meas tran mf_ss_sinkmin_tail MIN v(tail) from=2e-08 to=4e-08
print mf_su_vcemax_q1
print mf_su_vcemin_q1
print mf_ss_vcemax_q1
print mf_ss_vcemin_q1
print mf_su_vbemax_q1
print mf_su_vbemin_q1
print mf_ss_vbemax_q1
print mf_ss_vbemin_q1
print mf_su_icmax_q1
print mf_su_icmin_q1
print mf_ss_icmax_q1
print mf_ss_icmin_q1
print mf_su_vcemax_q2
print mf_su_vcemin_q2
print mf_ss_vcemax_q2
print mf_ss_vcemin_q2
print mf_su_vbemax_q2
print mf_su_vbemin_q2
print mf_ss_vbemax_q2
print mf_ss_vbemin_q2
print mf_su_icmax_q2
print mf_su_icmin_q2
print mf_ss_icmax_q2
print mf_ss_icmin_q2
print mf_su_vcemax_q3
print mf_su_vcemin_q3
print mf_ss_vcemax_q3
print mf_ss_vcemin_q3
print mf_su_vbemax_q3
print mf_su_vbemin_q3
print mf_ss_vbemax_q3
print mf_ss_vbemin_q3
print mf_su_icmax_q3
print mf_su_icmin_q3
print mf_ss_icmax_q3
print mf_ss_icmin_q3
print mf_su_vcemax_q4
print mf_su_vcemin_q4
print mf_ss_vcemax_q4
print mf_ss_vcemin_q4
print mf_su_vbemax_q4
print mf_su_vbemin_q4
print mf_ss_vbemax_q4
print mf_ss_vbemin_q4
print mf_su_icmax_q4
print mf_su_icmin_q4
print mf_ss_icmax_q4
print mf_ss_icmin_q4
print mf_su_vcemax_q5
print mf_su_vcemin_q5
print mf_ss_vcemax_q5
print mf_ss_vcemin_q5
print mf_su_vbemax_q5
print mf_su_vbemin_q5
print mf_ss_vbemax_q5
print mf_ss_vbemin_q5
print mf_su_icmax_q5
print mf_su_icmin_q5
print mf_ss_icmax_q5
print mf_ss_icmin_q5
print mf_su_vcemax_q6
print mf_su_vcemin_q6
print mf_ss_vcemax_q6
print mf_ss_vcemin_q6
print mf_su_vbemax_q6
print mf_su_vbemin_q6
print mf_ss_vbemax_q6
print mf_ss_vbemin_q6
print mf_su_icmax_q6
print mf_su_icmin_q6
print mf_ss_icmax_q6
print mf_ss_icmin_q6
print mf_su_sinkmin_tail
print mf_ss_sinkmin_tail
linearize
let mf_l = length(time)
let mfw = (time ge 1.99995e-08) * (time lt 3.99995e-08)
let mf_n = mean(mfw) * mf_l
let mfs = mf_l / mf_n
let mf_prail = mean(v(vdd) * (0 - i(vdd)) * mfw) * mfs
let mfph = 2 * pi * 18450000000.0 * (time - 2e-08)
let mf_lodiff_re = 2 * mean((v(lo_p)-v(lo_n)) * mfw * cos(mfph)) * mfs
let mf_lodiff_im = 2 * mean((v(lo_p)-v(lo_n)) * mfw * sin(mfph)) * mfs
let mfph = 2 * pi * 1000000000.0 * (time - 2e-08)
let mf_if_re = 2 * mean((v(if_out)) * mfw * cos(mfph)) * mfs
let mf_if_im = 2 * mean((v(if_out)) * mfw * sin(mfph)) * mfs
let mfph = 2 * pi * 18450000000.0 * (time - 2e-08)
let mf_loif_re = 2 * mean((v(if_out)) * mfw * cos(mfph)) * mfs
let mf_loif_im = 2 * mean((v(if_out)) * mfw * sin(mfph)) * mfs
let mfph = 2 * pi * 18450000000.0 * (time - 2e-08)
let mf_lorf_re = 2 * mean((v(rf_port)) * mfw * cos(mfph)) * mfs
let mf_lorf_im = 2 * mean((v(rf_port)) * mfw * sin(mfph)) * mfs
let mfph = 2 * pi * 950000000.0 * (time - 2e-08)
let mf_flifa_re = 2 * mean((v(if_out)) * mfw * cos(mfph)) * mfs
let mf_flifa_im = 2 * mean((v(if_out)) * mfw * sin(mfph)) * mfs
let mfph = 2 * pi * 1050000000.0 * (time - 2e-08)
let mf_flifb_re = 2 * mean((v(if_out)) * mfw * cos(mfph)) * mfs
let mf_flifb_im = 2 * mean((v(if_out)) * mfw * sin(mfph)) * mfs
let mfph = 2 * pi * 18500000000.0 * (time - 2e-08)
let mf_fllorf_re = 2 * mean((v(rf_port)) * mfw * cos(mfph)) * mfs
let mf_fllorf_im = 2 * mean((v(rf_port)) * mfw * sin(mfph)) * mfs
let mfph = 2 * pi * 18500000000.0 * (time - 2e-08)
let mf_flloif_re = 2 * mean((v(if_out)) * mfw * cos(mfph)) * mfs
let mf_flloif_im = 2 * mean((v(if_out)) * mfw * sin(mfph)) * mfs
print mf_l
print mf_n
print mf_prail
print mf_lodiff_re
print mf_lodiff_im
print mf_if_re
print mf_if_im
print mf_loif_re
print mf_loif_im
print mf_lorf_re
print mf_lorf_im
print mf_flifa_re
print mf_flifa_im
print mf_flifb_re
print mf_flifb_im
print mf_fllorf_re
print mf_fllorf_im
print mf_flloif_re
print mf_flloif_im
destroy all
echo "MFEND ls_f19p45_m30_rf60"
echo "MFRUN ls_f19p45_m30_rf66"
alterparam f1 = 19450000000.0
alterparam f2 = 19450000000.0
alterparam flo = 18450000000.0
alterparam vrf1 = 0.00031697863849222284
alterparam vrf2 = 0.0
alterparam vlo = 0.0282842712474619
reset
op
let mf_dcirail = 0 - i(vdd)
let mf_dc_vce_q1 = v(c_q1)-v(e_q1)
let mf_dc_vbe_q1 = v(b_q1)-v(e_q1)
let mf_dc_ic_q1 = i(vic_q1)
let mf_dc_vce_q2 = v(c_q2)-v(e_q2)
let mf_dc_vbe_q2 = v(b_q2)-v(e_q2)
let mf_dc_ic_q2 = i(vic_q2)
let mf_dc_vce_q3 = v(c_q3)-v(x1)
let mf_dc_vbe_q3 = v(lo_p)-v(x1)
let mf_dc_ic_q3 = i(vic_q3)
let mf_dc_vce_q4 = v(c_q4)-v(x1)
let mf_dc_vbe_q4 = v(lo_n)-v(x1)
let mf_dc_ic_q4 = i(vic_q4)
let mf_dc_vce_q5 = v(c_q5)-v(x2)
let mf_dc_vbe_q5 = v(lo_p)-v(x2)
let mf_dc_ic_q5 = i(vic_q5)
let mf_dc_vce_q6 = v(c_q6)-v(x2)
let mf_dc_vbe_q6 = v(lo_n)-v(x2)
let mf_dc_ic_q6 = i(vic_q6)
let mf_dc_sink_tail = v(tail)
print mf_dcirail
print mf_dc_vce_q1
print mf_dc_vbe_q1
print mf_dc_ic_q1
print mf_dc_vce_q2
print mf_dc_vbe_q2
print mf_dc_ic_q2
print mf_dc_vce_q3
print mf_dc_vbe_q3
print mf_dc_ic_q3
print mf_dc_vce_q4
print mf_dc_vbe_q4
print mf_dc_ic_q4
print mf_dc_vce_q5
print mf_dc_vbe_q5
print mf_dc_ic_q5
print mf_dc_vce_q6
print mf_dc_vbe_q6
print mf_dc_ic_q6
print mf_dc_sink_tail
tran 1e-12 4e-08 0 1e-12
let mfq_vce_q1 = v(c_q1)-v(e_q1)
meas tran mf_su_vcemax_q1 MAX mfq_vce_q1 from=0.0 to=2e-08
meas tran mf_su_vcemin_q1 MIN mfq_vce_q1 from=0.0 to=2e-08
meas tran mf_ss_vcemax_q1 MAX mfq_vce_q1 from=2e-08 to=4e-08
meas tran mf_ss_vcemin_q1 MIN mfq_vce_q1 from=2e-08 to=4e-08
let mfq_vbe_q1 = v(b_q1)-v(e_q1)
meas tran mf_su_vbemax_q1 MAX mfq_vbe_q1 from=0.0 to=2e-08
meas tran mf_su_vbemin_q1 MIN mfq_vbe_q1 from=0.0 to=2e-08
meas tran mf_ss_vbemax_q1 MAX mfq_vbe_q1 from=2e-08 to=4e-08
meas tran mf_ss_vbemin_q1 MIN mfq_vbe_q1 from=2e-08 to=4e-08
let mfq_ic_q1 = i(vic_q1)
meas tran mf_su_icmax_q1 MAX mfq_ic_q1 from=0.0 to=2e-08
meas tran mf_su_icmin_q1 MIN mfq_ic_q1 from=0.0 to=2e-08
meas tran mf_ss_icmax_q1 MAX mfq_ic_q1 from=2e-08 to=4e-08
meas tran mf_ss_icmin_q1 MIN mfq_ic_q1 from=2e-08 to=4e-08
let mfq_vce_q2 = v(c_q2)-v(e_q2)
meas tran mf_su_vcemax_q2 MAX mfq_vce_q2 from=0.0 to=2e-08
meas tran mf_su_vcemin_q2 MIN mfq_vce_q2 from=0.0 to=2e-08
meas tran mf_ss_vcemax_q2 MAX mfq_vce_q2 from=2e-08 to=4e-08
meas tran mf_ss_vcemin_q2 MIN mfq_vce_q2 from=2e-08 to=4e-08
let mfq_vbe_q2 = v(b_q2)-v(e_q2)
meas tran mf_su_vbemax_q2 MAX mfq_vbe_q2 from=0.0 to=2e-08
meas tran mf_su_vbemin_q2 MIN mfq_vbe_q2 from=0.0 to=2e-08
meas tran mf_ss_vbemax_q2 MAX mfq_vbe_q2 from=2e-08 to=4e-08
meas tran mf_ss_vbemin_q2 MIN mfq_vbe_q2 from=2e-08 to=4e-08
let mfq_ic_q2 = i(vic_q2)
meas tran mf_su_icmax_q2 MAX mfq_ic_q2 from=0.0 to=2e-08
meas tran mf_su_icmin_q2 MIN mfq_ic_q2 from=0.0 to=2e-08
meas tran mf_ss_icmax_q2 MAX mfq_ic_q2 from=2e-08 to=4e-08
meas tran mf_ss_icmin_q2 MIN mfq_ic_q2 from=2e-08 to=4e-08
let mfq_vce_q3 = v(c_q3)-v(x1)
meas tran mf_su_vcemax_q3 MAX mfq_vce_q3 from=0.0 to=2e-08
meas tran mf_su_vcemin_q3 MIN mfq_vce_q3 from=0.0 to=2e-08
meas tran mf_ss_vcemax_q3 MAX mfq_vce_q3 from=2e-08 to=4e-08
meas tran mf_ss_vcemin_q3 MIN mfq_vce_q3 from=2e-08 to=4e-08
let mfq_vbe_q3 = v(lo_p)-v(x1)
meas tran mf_su_vbemax_q3 MAX mfq_vbe_q3 from=0.0 to=2e-08
meas tran mf_su_vbemin_q3 MIN mfq_vbe_q3 from=0.0 to=2e-08
meas tran mf_ss_vbemax_q3 MAX mfq_vbe_q3 from=2e-08 to=4e-08
meas tran mf_ss_vbemin_q3 MIN mfq_vbe_q3 from=2e-08 to=4e-08
let mfq_ic_q3 = i(vic_q3)
meas tran mf_su_icmax_q3 MAX mfq_ic_q3 from=0.0 to=2e-08
meas tran mf_su_icmin_q3 MIN mfq_ic_q3 from=0.0 to=2e-08
meas tran mf_ss_icmax_q3 MAX mfq_ic_q3 from=2e-08 to=4e-08
meas tran mf_ss_icmin_q3 MIN mfq_ic_q3 from=2e-08 to=4e-08
let mfq_vce_q4 = v(c_q4)-v(x1)
meas tran mf_su_vcemax_q4 MAX mfq_vce_q4 from=0.0 to=2e-08
meas tran mf_su_vcemin_q4 MIN mfq_vce_q4 from=0.0 to=2e-08
meas tran mf_ss_vcemax_q4 MAX mfq_vce_q4 from=2e-08 to=4e-08
meas tran mf_ss_vcemin_q4 MIN mfq_vce_q4 from=2e-08 to=4e-08
let mfq_vbe_q4 = v(lo_n)-v(x1)
meas tran mf_su_vbemax_q4 MAX mfq_vbe_q4 from=0.0 to=2e-08
meas tran mf_su_vbemin_q4 MIN mfq_vbe_q4 from=0.0 to=2e-08
meas tran mf_ss_vbemax_q4 MAX mfq_vbe_q4 from=2e-08 to=4e-08
meas tran mf_ss_vbemin_q4 MIN mfq_vbe_q4 from=2e-08 to=4e-08
let mfq_ic_q4 = i(vic_q4)
meas tran mf_su_icmax_q4 MAX mfq_ic_q4 from=0.0 to=2e-08
meas tran mf_su_icmin_q4 MIN mfq_ic_q4 from=0.0 to=2e-08
meas tran mf_ss_icmax_q4 MAX mfq_ic_q4 from=2e-08 to=4e-08
meas tran mf_ss_icmin_q4 MIN mfq_ic_q4 from=2e-08 to=4e-08
let mfq_vce_q5 = v(c_q5)-v(x2)
meas tran mf_su_vcemax_q5 MAX mfq_vce_q5 from=0.0 to=2e-08
meas tran mf_su_vcemin_q5 MIN mfq_vce_q5 from=0.0 to=2e-08
meas tran mf_ss_vcemax_q5 MAX mfq_vce_q5 from=2e-08 to=4e-08
meas tran mf_ss_vcemin_q5 MIN mfq_vce_q5 from=2e-08 to=4e-08
let mfq_vbe_q5 = v(lo_p)-v(x2)
meas tran mf_su_vbemax_q5 MAX mfq_vbe_q5 from=0.0 to=2e-08
meas tran mf_su_vbemin_q5 MIN mfq_vbe_q5 from=0.0 to=2e-08
meas tran mf_ss_vbemax_q5 MAX mfq_vbe_q5 from=2e-08 to=4e-08
meas tran mf_ss_vbemin_q5 MIN mfq_vbe_q5 from=2e-08 to=4e-08
let mfq_ic_q5 = i(vic_q5)
meas tran mf_su_icmax_q5 MAX mfq_ic_q5 from=0.0 to=2e-08
meas tran mf_su_icmin_q5 MIN mfq_ic_q5 from=0.0 to=2e-08
meas tran mf_ss_icmax_q5 MAX mfq_ic_q5 from=2e-08 to=4e-08
meas tran mf_ss_icmin_q5 MIN mfq_ic_q5 from=2e-08 to=4e-08
let mfq_vce_q6 = v(c_q6)-v(x2)
meas tran mf_su_vcemax_q6 MAX mfq_vce_q6 from=0.0 to=2e-08
meas tran mf_su_vcemin_q6 MIN mfq_vce_q6 from=0.0 to=2e-08
meas tran mf_ss_vcemax_q6 MAX mfq_vce_q6 from=2e-08 to=4e-08
meas tran mf_ss_vcemin_q6 MIN mfq_vce_q6 from=2e-08 to=4e-08
let mfq_vbe_q6 = v(lo_n)-v(x2)
meas tran mf_su_vbemax_q6 MAX mfq_vbe_q6 from=0.0 to=2e-08
meas tran mf_su_vbemin_q6 MIN mfq_vbe_q6 from=0.0 to=2e-08
meas tran mf_ss_vbemax_q6 MAX mfq_vbe_q6 from=2e-08 to=4e-08
meas tran mf_ss_vbemin_q6 MIN mfq_vbe_q6 from=2e-08 to=4e-08
let mfq_ic_q6 = i(vic_q6)
meas tran mf_su_icmax_q6 MAX mfq_ic_q6 from=0.0 to=2e-08
meas tran mf_su_icmin_q6 MIN mfq_ic_q6 from=0.0 to=2e-08
meas tran mf_ss_icmax_q6 MAX mfq_ic_q6 from=2e-08 to=4e-08
meas tran mf_ss_icmin_q6 MIN mfq_ic_q6 from=2e-08 to=4e-08
meas tran mf_su_sinkmin_tail MIN v(tail) from=0.0 to=2e-08
meas tran mf_ss_sinkmin_tail MIN v(tail) from=2e-08 to=4e-08
print mf_su_vcemax_q1
print mf_su_vcemin_q1
print mf_ss_vcemax_q1
print mf_ss_vcemin_q1
print mf_su_vbemax_q1
print mf_su_vbemin_q1
print mf_ss_vbemax_q1
print mf_ss_vbemin_q1
print mf_su_icmax_q1
print mf_su_icmin_q1
print mf_ss_icmax_q1
print mf_ss_icmin_q1
print mf_su_vcemax_q2
print mf_su_vcemin_q2
print mf_ss_vcemax_q2
print mf_ss_vcemin_q2
print mf_su_vbemax_q2
print mf_su_vbemin_q2
print mf_ss_vbemax_q2
print mf_ss_vbemin_q2
print mf_su_icmax_q2
print mf_su_icmin_q2
print mf_ss_icmax_q2
print mf_ss_icmin_q2
print mf_su_vcemax_q3
print mf_su_vcemin_q3
print mf_ss_vcemax_q3
print mf_ss_vcemin_q3
print mf_su_vbemax_q3
print mf_su_vbemin_q3
print mf_ss_vbemax_q3
print mf_ss_vbemin_q3
print mf_su_icmax_q3
print mf_su_icmin_q3
print mf_ss_icmax_q3
print mf_ss_icmin_q3
print mf_su_vcemax_q4
print mf_su_vcemin_q4
print mf_ss_vcemax_q4
print mf_ss_vcemin_q4
print mf_su_vbemax_q4
print mf_su_vbemin_q4
print mf_ss_vbemax_q4
print mf_ss_vbemin_q4
print mf_su_icmax_q4
print mf_su_icmin_q4
print mf_ss_icmax_q4
print mf_ss_icmin_q4
print mf_su_vcemax_q5
print mf_su_vcemin_q5
print mf_ss_vcemax_q5
print mf_ss_vcemin_q5
print mf_su_vbemax_q5
print mf_su_vbemin_q5
print mf_ss_vbemax_q5
print mf_ss_vbemin_q5
print mf_su_icmax_q5
print mf_su_icmin_q5
print mf_ss_icmax_q5
print mf_ss_icmin_q5
print mf_su_vcemax_q6
print mf_su_vcemin_q6
print mf_ss_vcemax_q6
print mf_ss_vcemin_q6
print mf_su_vbemax_q6
print mf_su_vbemin_q6
print mf_ss_vbemax_q6
print mf_ss_vbemin_q6
print mf_su_icmax_q6
print mf_su_icmin_q6
print mf_ss_icmax_q6
print mf_ss_icmin_q6
print mf_su_sinkmin_tail
print mf_ss_sinkmin_tail
linearize
let mf_l = length(time)
let mfw = (time ge 1.99995e-08) * (time lt 3.99995e-08)
let mf_n = mean(mfw) * mf_l
let mfs = mf_l / mf_n
let mf_prail = mean(v(vdd) * (0 - i(vdd)) * mfw) * mfs
let mfph = 2 * pi * 18450000000.0 * (time - 2e-08)
let mf_lodiff_re = 2 * mean((v(lo_p)-v(lo_n)) * mfw * cos(mfph)) * mfs
let mf_lodiff_im = 2 * mean((v(lo_p)-v(lo_n)) * mfw * sin(mfph)) * mfs
let mfph = 2 * pi * 1000000000.0 * (time - 2e-08)
let mf_if_re = 2 * mean((v(if_out)) * mfw * cos(mfph)) * mfs
let mf_if_im = 2 * mean((v(if_out)) * mfw * sin(mfph)) * mfs
let mfph = 2 * pi * 18450000000.0 * (time - 2e-08)
let mf_loif_re = 2 * mean((v(if_out)) * mfw * cos(mfph)) * mfs
let mf_loif_im = 2 * mean((v(if_out)) * mfw * sin(mfph)) * mfs
let mfph = 2 * pi * 18450000000.0 * (time - 2e-08)
let mf_lorf_re = 2 * mean((v(rf_port)) * mfw * cos(mfph)) * mfs
let mf_lorf_im = 2 * mean((v(rf_port)) * mfw * sin(mfph)) * mfs
let mfph = 2 * pi * 950000000.0 * (time - 2e-08)
let mf_flifa_re = 2 * mean((v(if_out)) * mfw * cos(mfph)) * mfs
let mf_flifa_im = 2 * mean((v(if_out)) * mfw * sin(mfph)) * mfs
let mfph = 2 * pi * 1050000000.0 * (time - 2e-08)
let mf_flifb_re = 2 * mean((v(if_out)) * mfw * cos(mfph)) * mfs
let mf_flifb_im = 2 * mean((v(if_out)) * mfw * sin(mfph)) * mfs
let mfph = 2 * pi * 18500000000.0 * (time - 2e-08)
let mf_fllorf_re = 2 * mean((v(rf_port)) * mfw * cos(mfph)) * mfs
let mf_fllorf_im = 2 * mean((v(rf_port)) * mfw * sin(mfph)) * mfs
let mfph = 2 * pi * 18500000000.0 * (time - 2e-08)
let mf_flloif_re = 2 * mean((v(if_out)) * mfw * cos(mfph)) * mfs
let mf_flloif_im = 2 * mean((v(if_out)) * mfw * sin(mfph)) * mfs
print mf_l
print mf_n
print mf_prail
print mf_lodiff_re
print mf_lodiff_im
print mf_if_re
print mf_if_im
print mf_loif_re
print mf_loif_im
print mf_lorf_re
print mf_lorf_im
print mf_flifa_re
print mf_flifa_im
print mf_flifb_re
print mf_flifb_im
print mf_fllorf_re
print mf_fllorf_im
print mf_flloif_re
print mf_flloif_im
destroy all
echo "MFEND ls_f19p45_m30_rf66"
echo "MFRUN ls_f19p45_m27_rf60"
alterparam f1 = 19450000000.0
alterparam f2 = 19450000000.0
alterparam flo = 18450000000.0
alterparam vrf1 = 0.0006324555320336759
alterparam vrf2 = 0.0
alterparam vlo = 0.039952595059333795
reset
op
let mf_dcirail = 0 - i(vdd)
let mf_dc_vce_q1 = v(c_q1)-v(e_q1)
let mf_dc_vbe_q1 = v(b_q1)-v(e_q1)
let mf_dc_ic_q1 = i(vic_q1)
let mf_dc_vce_q2 = v(c_q2)-v(e_q2)
let mf_dc_vbe_q2 = v(b_q2)-v(e_q2)
let mf_dc_ic_q2 = i(vic_q2)
let mf_dc_vce_q3 = v(c_q3)-v(x1)
let mf_dc_vbe_q3 = v(lo_p)-v(x1)
let mf_dc_ic_q3 = i(vic_q3)
let mf_dc_vce_q4 = v(c_q4)-v(x1)
let mf_dc_vbe_q4 = v(lo_n)-v(x1)
let mf_dc_ic_q4 = i(vic_q4)
let mf_dc_vce_q5 = v(c_q5)-v(x2)
let mf_dc_vbe_q5 = v(lo_p)-v(x2)
let mf_dc_ic_q5 = i(vic_q5)
let mf_dc_vce_q6 = v(c_q6)-v(x2)
let mf_dc_vbe_q6 = v(lo_n)-v(x2)
let mf_dc_ic_q6 = i(vic_q6)
let mf_dc_sink_tail = v(tail)
print mf_dcirail
print mf_dc_vce_q1
print mf_dc_vbe_q1
print mf_dc_ic_q1
print mf_dc_vce_q2
print mf_dc_vbe_q2
print mf_dc_ic_q2
print mf_dc_vce_q3
print mf_dc_vbe_q3
print mf_dc_ic_q3
print mf_dc_vce_q4
print mf_dc_vbe_q4
print mf_dc_ic_q4
print mf_dc_vce_q5
print mf_dc_vbe_q5
print mf_dc_ic_q5
print mf_dc_vce_q6
print mf_dc_vbe_q6
print mf_dc_ic_q6
print mf_dc_sink_tail
tran 1e-12 4e-08 0 1e-12
let mfq_vce_q1 = v(c_q1)-v(e_q1)
meas tran mf_su_vcemax_q1 MAX mfq_vce_q1 from=0.0 to=2e-08
meas tran mf_su_vcemin_q1 MIN mfq_vce_q1 from=0.0 to=2e-08
meas tran mf_ss_vcemax_q1 MAX mfq_vce_q1 from=2e-08 to=4e-08
meas tran mf_ss_vcemin_q1 MIN mfq_vce_q1 from=2e-08 to=4e-08
let mfq_vbe_q1 = v(b_q1)-v(e_q1)
meas tran mf_su_vbemax_q1 MAX mfq_vbe_q1 from=0.0 to=2e-08
meas tran mf_su_vbemin_q1 MIN mfq_vbe_q1 from=0.0 to=2e-08
meas tran mf_ss_vbemax_q1 MAX mfq_vbe_q1 from=2e-08 to=4e-08
meas tran mf_ss_vbemin_q1 MIN mfq_vbe_q1 from=2e-08 to=4e-08
let mfq_ic_q1 = i(vic_q1)
meas tran mf_su_icmax_q1 MAX mfq_ic_q1 from=0.0 to=2e-08
meas tran mf_su_icmin_q1 MIN mfq_ic_q1 from=0.0 to=2e-08
meas tran mf_ss_icmax_q1 MAX mfq_ic_q1 from=2e-08 to=4e-08
meas tran mf_ss_icmin_q1 MIN mfq_ic_q1 from=2e-08 to=4e-08
let mfq_vce_q2 = v(c_q2)-v(e_q2)
meas tran mf_su_vcemax_q2 MAX mfq_vce_q2 from=0.0 to=2e-08
meas tran mf_su_vcemin_q2 MIN mfq_vce_q2 from=0.0 to=2e-08
meas tran mf_ss_vcemax_q2 MAX mfq_vce_q2 from=2e-08 to=4e-08
meas tran mf_ss_vcemin_q2 MIN mfq_vce_q2 from=2e-08 to=4e-08
let mfq_vbe_q2 = v(b_q2)-v(e_q2)
meas tran mf_su_vbemax_q2 MAX mfq_vbe_q2 from=0.0 to=2e-08
meas tran mf_su_vbemin_q2 MIN mfq_vbe_q2 from=0.0 to=2e-08
meas tran mf_ss_vbemax_q2 MAX mfq_vbe_q2 from=2e-08 to=4e-08
meas tran mf_ss_vbemin_q2 MIN mfq_vbe_q2 from=2e-08 to=4e-08
let mfq_ic_q2 = i(vic_q2)
meas tran mf_su_icmax_q2 MAX mfq_ic_q2 from=0.0 to=2e-08
meas tran mf_su_icmin_q2 MIN mfq_ic_q2 from=0.0 to=2e-08
meas tran mf_ss_icmax_q2 MAX mfq_ic_q2 from=2e-08 to=4e-08
meas tran mf_ss_icmin_q2 MIN mfq_ic_q2 from=2e-08 to=4e-08
let mfq_vce_q3 = v(c_q3)-v(x1)
meas tran mf_su_vcemax_q3 MAX mfq_vce_q3 from=0.0 to=2e-08
meas tran mf_su_vcemin_q3 MIN mfq_vce_q3 from=0.0 to=2e-08
meas tran mf_ss_vcemax_q3 MAX mfq_vce_q3 from=2e-08 to=4e-08
meas tran mf_ss_vcemin_q3 MIN mfq_vce_q3 from=2e-08 to=4e-08
let mfq_vbe_q3 = v(lo_p)-v(x1)
meas tran mf_su_vbemax_q3 MAX mfq_vbe_q3 from=0.0 to=2e-08
meas tran mf_su_vbemin_q3 MIN mfq_vbe_q3 from=0.0 to=2e-08
meas tran mf_ss_vbemax_q3 MAX mfq_vbe_q3 from=2e-08 to=4e-08
meas tran mf_ss_vbemin_q3 MIN mfq_vbe_q3 from=2e-08 to=4e-08
let mfq_ic_q3 = i(vic_q3)
meas tran mf_su_icmax_q3 MAX mfq_ic_q3 from=0.0 to=2e-08
meas tran mf_su_icmin_q3 MIN mfq_ic_q3 from=0.0 to=2e-08
meas tran mf_ss_icmax_q3 MAX mfq_ic_q3 from=2e-08 to=4e-08
meas tran mf_ss_icmin_q3 MIN mfq_ic_q3 from=2e-08 to=4e-08
let mfq_vce_q4 = v(c_q4)-v(x1)
meas tran mf_su_vcemax_q4 MAX mfq_vce_q4 from=0.0 to=2e-08
meas tran mf_su_vcemin_q4 MIN mfq_vce_q4 from=0.0 to=2e-08
meas tran mf_ss_vcemax_q4 MAX mfq_vce_q4 from=2e-08 to=4e-08
meas tran mf_ss_vcemin_q4 MIN mfq_vce_q4 from=2e-08 to=4e-08
let mfq_vbe_q4 = v(lo_n)-v(x1)
meas tran mf_su_vbemax_q4 MAX mfq_vbe_q4 from=0.0 to=2e-08
meas tran mf_su_vbemin_q4 MIN mfq_vbe_q4 from=0.0 to=2e-08
meas tran mf_ss_vbemax_q4 MAX mfq_vbe_q4 from=2e-08 to=4e-08
meas tran mf_ss_vbemin_q4 MIN mfq_vbe_q4 from=2e-08 to=4e-08
let mfq_ic_q4 = i(vic_q4)
meas tran mf_su_icmax_q4 MAX mfq_ic_q4 from=0.0 to=2e-08
meas tran mf_su_icmin_q4 MIN mfq_ic_q4 from=0.0 to=2e-08
meas tran mf_ss_icmax_q4 MAX mfq_ic_q4 from=2e-08 to=4e-08
meas tran mf_ss_icmin_q4 MIN mfq_ic_q4 from=2e-08 to=4e-08
let mfq_vce_q5 = v(c_q5)-v(x2)
meas tran mf_su_vcemax_q5 MAX mfq_vce_q5 from=0.0 to=2e-08
meas tran mf_su_vcemin_q5 MIN mfq_vce_q5 from=0.0 to=2e-08
meas tran mf_ss_vcemax_q5 MAX mfq_vce_q5 from=2e-08 to=4e-08
meas tran mf_ss_vcemin_q5 MIN mfq_vce_q5 from=2e-08 to=4e-08
let mfq_vbe_q5 = v(lo_p)-v(x2)
meas tran mf_su_vbemax_q5 MAX mfq_vbe_q5 from=0.0 to=2e-08
meas tran mf_su_vbemin_q5 MIN mfq_vbe_q5 from=0.0 to=2e-08
meas tran mf_ss_vbemax_q5 MAX mfq_vbe_q5 from=2e-08 to=4e-08
meas tran mf_ss_vbemin_q5 MIN mfq_vbe_q5 from=2e-08 to=4e-08
let mfq_ic_q5 = i(vic_q5)
meas tran mf_su_icmax_q5 MAX mfq_ic_q5 from=0.0 to=2e-08
meas tran mf_su_icmin_q5 MIN mfq_ic_q5 from=0.0 to=2e-08
meas tran mf_ss_icmax_q5 MAX mfq_ic_q5 from=2e-08 to=4e-08
meas tran mf_ss_icmin_q5 MIN mfq_ic_q5 from=2e-08 to=4e-08
let mfq_vce_q6 = v(c_q6)-v(x2)
meas tran mf_su_vcemax_q6 MAX mfq_vce_q6 from=0.0 to=2e-08
meas tran mf_su_vcemin_q6 MIN mfq_vce_q6 from=0.0 to=2e-08
meas tran mf_ss_vcemax_q6 MAX mfq_vce_q6 from=2e-08 to=4e-08
meas tran mf_ss_vcemin_q6 MIN mfq_vce_q6 from=2e-08 to=4e-08
let mfq_vbe_q6 = v(lo_n)-v(x2)
meas tran mf_su_vbemax_q6 MAX mfq_vbe_q6 from=0.0 to=2e-08
meas tran mf_su_vbemin_q6 MIN mfq_vbe_q6 from=0.0 to=2e-08
meas tran mf_ss_vbemax_q6 MAX mfq_vbe_q6 from=2e-08 to=4e-08
meas tran mf_ss_vbemin_q6 MIN mfq_vbe_q6 from=2e-08 to=4e-08
let mfq_ic_q6 = i(vic_q6)
meas tran mf_su_icmax_q6 MAX mfq_ic_q6 from=0.0 to=2e-08
meas tran mf_su_icmin_q6 MIN mfq_ic_q6 from=0.0 to=2e-08
meas tran mf_ss_icmax_q6 MAX mfq_ic_q6 from=2e-08 to=4e-08
meas tran mf_ss_icmin_q6 MIN mfq_ic_q6 from=2e-08 to=4e-08
meas tran mf_su_sinkmin_tail MIN v(tail) from=0.0 to=2e-08
meas tran mf_ss_sinkmin_tail MIN v(tail) from=2e-08 to=4e-08
print mf_su_vcemax_q1
print mf_su_vcemin_q1
print mf_ss_vcemax_q1
print mf_ss_vcemin_q1
print mf_su_vbemax_q1
print mf_su_vbemin_q1
print mf_ss_vbemax_q1
print mf_ss_vbemin_q1
print mf_su_icmax_q1
print mf_su_icmin_q1
print mf_ss_icmax_q1
print mf_ss_icmin_q1
print mf_su_vcemax_q2
print mf_su_vcemin_q2
print mf_ss_vcemax_q2
print mf_ss_vcemin_q2
print mf_su_vbemax_q2
print mf_su_vbemin_q2
print mf_ss_vbemax_q2
print mf_ss_vbemin_q2
print mf_su_icmax_q2
print mf_su_icmin_q2
print mf_ss_icmax_q2
print mf_ss_icmin_q2
print mf_su_vcemax_q3
print mf_su_vcemin_q3
print mf_ss_vcemax_q3
print mf_ss_vcemin_q3
print mf_su_vbemax_q3
print mf_su_vbemin_q3
print mf_ss_vbemax_q3
print mf_ss_vbemin_q3
print mf_su_icmax_q3
print mf_su_icmin_q3
print mf_ss_icmax_q3
print mf_ss_icmin_q3
print mf_su_vcemax_q4
print mf_su_vcemin_q4
print mf_ss_vcemax_q4
print mf_ss_vcemin_q4
print mf_su_vbemax_q4
print mf_su_vbemin_q4
print mf_ss_vbemax_q4
print mf_ss_vbemin_q4
print mf_su_icmax_q4
print mf_su_icmin_q4
print mf_ss_icmax_q4
print mf_ss_icmin_q4
print mf_su_vcemax_q5
print mf_su_vcemin_q5
print mf_ss_vcemax_q5
print mf_ss_vcemin_q5
print mf_su_vbemax_q5
print mf_su_vbemin_q5
print mf_ss_vbemax_q5
print mf_ss_vbemin_q5
print mf_su_icmax_q5
print mf_su_icmin_q5
print mf_ss_icmax_q5
print mf_ss_icmin_q5
print mf_su_vcemax_q6
print mf_su_vcemin_q6
print mf_ss_vcemax_q6
print mf_ss_vcemin_q6
print mf_su_vbemax_q6
print mf_su_vbemin_q6
print mf_ss_vbemax_q6
print mf_ss_vbemin_q6
print mf_su_icmax_q6
print mf_su_icmin_q6
print mf_ss_icmax_q6
print mf_ss_icmin_q6
print mf_su_sinkmin_tail
print mf_ss_sinkmin_tail
linearize
let mf_l = length(time)
let mfw = (time ge 1.99995e-08) * (time lt 3.99995e-08)
let mf_n = mean(mfw) * mf_l
let mfs = mf_l / mf_n
let mf_prail = mean(v(vdd) * (0 - i(vdd)) * mfw) * mfs
let mfph = 2 * pi * 18450000000.0 * (time - 2e-08)
let mf_lodiff_re = 2 * mean((v(lo_p)-v(lo_n)) * mfw * cos(mfph)) * mfs
let mf_lodiff_im = 2 * mean((v(lo_p)-v(lo_n)) * mfw * sin(mfph)) * mfs
let mfph = 2 * pi * 1000000000.0 * (time - 2e-08)
let mf_if_re = 2 * mean((v(if_out)) * mfw * cos(mfph)) * mfs
let mf_if_im = 2 * mean((v(if_out)) * mfw * sin(mfph)) * mfs
let mfph = 2 * pi * 18450000000.0 * (time - 2e-08)
let mf_loif_re = 2 * mean((v(if_out)) * mfw * cos(mfph)) * mfs
let mf_loif_im = 2 * mean((v(if_out)) * mfw * sin(mfph)) * mfs
let mfph = 2 * pi * 18450000000.0 * (time - 2e-08)
let mf_lorf_re = 2 * mean((v(rf_port)) * mfw * cos(mfph)) * mfs
let mf_lorf_im = 2 * mean((v(rf_port)) * mfw * sin(mfph)) * mfs
let mfph = 2 * pi * 950000000.0 * (time - 2e-08)
let mf_flifa_re = 2 * mean((v(if_out)) * mfw * cos(mfph)) * mfs
let mf_flifa_im = 2 * mean((v(if_out)) * mfw * sin(mfph)) * mfs
let mfph = 2 * pi * 1050000000.0 * (time - 2e-08)
let mf_flifb_re = 2 * mean((v(if_out)) * mfw * cos(mfph)) * mfs
let mf_flifb_im = 2 * mean((v(if_out)) * mfw * sin(mfph)) * mfs
let mfph = 2 * pi * 18500000000.0 * (time - 2e-08)
let mf_fllorf_re = 2 * mean((v(rf_port)) * mfw * cos(mfph)) * mfs
let mf_fllorf_im = 2 * mean((v(rf_port)) * mfw * sin(mfph)) * mfs
let mfph = 2 * pi * 18500000000.0 * (time - 2e-08)
let mf_flloif_re = 2 * mean((v(if_out)) * mfw * cos(mfph)) * mfs
let mf_flloif_im = 2 * mean((v(if_out)) * mfw * sin(mfph)) * mfs
print mf_l
print mf_n
print mf_prail
print mf_lodiff_re
print mf_lodiff_im
print mf_if_re
print mf_if_im
print mf_loif_re
print mf_loif_im
print mf_lorf_re
print mf_lorf_im
print mf_flifa_re
print mf_flifa_im
print mf_flifb_re
print mf_flifb_im
print mf_fllorf_re
print mf_fllorf_im
print mf_flloif_re
print mf_flloif_im
destroy all
echo "MFEND ls_f19p45_m27_rf60"
echo "MFRUN ls_f19p45_m27_rf66"
alterparam f1 = 19450000000.0
alterparam f2 = 19450000000.0
alterparam flo = 18450000000.0
alterparam vrf1 = 0.00031697863849222284
alterparam vrf2 = 0.0
alterparam vlo = 0.039952595059333795
reset
op
let mf_dcirail = 0 - i(vdd)
let mf_dc_vce_q1 = v(c_q1)-v(e_q1)
let mf_dc_vbe_q1 = v(b_q1)-v(e_q1)
let mf_dc_ic_q1 = i(vic_q1)
let mf_dc_vce_q2 = v(c_q2)-v(e_q2)
let mf_dc_vbe_q2 = v(b_q2)-v(e_q2)
let mf_dc_ic_q2 = i(vic_q2)
let mf_dc_vce_q3 = v(c_q3)-v(x1)
let mf_dc_vbe_q3 = v(lo_p)-v(x1)
let mf_dc_ic_q3 = i(vic_q3)
let mf_dc_vce_q4 = v(c_q4)-v(x1)
let mf_dc_vbe_q4 = v(lo_n)-v(x1)
let mf_dc_ic_q4 = i(vic_q4)
let mf_dc_vce_q5 = v(c_q5)-v(x2)
let mf_dc_vbe_q5 = v(lo_p)-v(x2)
let mf_dc_ic_q5 = i(vic_q5)
let mf_dc_vce_q6 = v(c_q6)-v(x2)
let mf_dc_vbe_q6 = v(lo_n)-v(x2)
let mf_dc_ic_q6 = i(vic_q6)
let mf_dc_sink_tail = v(tail)
print mf_dcirail
print mf_dc_vce_q1
print mf_dc_vbe_q1
print mf_dc_ic_q1
print mf_dc_vce_q2
print mf_dc_vbe_q2
print mf_dc_ic_q2
print mf_dc_vce_q3
print mf_dc_vbe_q3
print mf_dc_ic_q3
print mf_dc_vce_q4
print mf_dc_vbe_q4
print mf_dc_ic_q4
print mf_dc_vce_q5
print mf_dc_vbe_q5
print mf_dc_ic_q5
print mf_dc_vce_q6
print mf_dc_vbe_q6
print mf_dc_ic_q6
print mf_dc_sink_tail
tran 1e-12 4e-08 0 1e-12
let mfq_vce_q1 = v(c_q1)-v(e_q1)
meas tran mf_su_vcemax_q1 MAX mfq_vce_q1 from=0.0 to=2e-08
meas tran mf_su_vcemin_q1 MIN mfq_vce_q1 from=0.0 to=2e-08
meas tran mf_ss_vcemax_q1 MAX mfq_vce_q1 from=2e-08 to=4e-08
meas tran mf_ss_vcemin_q1 MIN mfq_vce_q1 from=2e-08 to=4e-08
let mfq_vbe_q1 = v(b_q1)-v(e_q1)
meas tran mf_su_vbemax_q1 MAX mfq_vbe_q1 from=0.0 to=2e-08
meas tran mf_su_vbemin_q1 MIN mfq_vbe_q1 from=0.0 to=2e-08
meas tran mf_ss_vbemax_q1 MAX mfq_vbe_q1 from=2e-08 to=4e-08
meas tran mf_ss_vbemin_q1 MIN mfq_vbe_q1 from=2e-08 to=4e-08
let mfq_ic_q1 = i(vic_q1)
meas tran mf_su_icmax_q1 MAX mfq_ic_q1 from=0.0 to=2e-08
meas tran mf_su_icmin_q1 MIN mfq_ic_q1 from=0.0 to=2e-08
meas tran mf_ss_icmax_q1 MAX mfq_ic_q1 from=2e-08 to=4e-08
meas tran mf_ss_icmin_q1 MIN mfq_ic_q1 from=2e-08 to=4e-08
let mfq_vce_q2 = v(c_q2)-v(e_q2)
meas tran mf_su_vcemax_q2 MAX mfq_vce_q2 from=0.0 to=2e-08
meas tran mf_su_vcemin_q2 MIN mfq_vce_q2 from=0.0 to=2e-08
meas tran mf_ss_vcemax_q2 MAX mfq_vce_q2 from=2e-08 to=4e-08
meas tran mf_ss_vcemin_q2 MIN mfq_vce_q2 from=2e-08 to=4e-08
let mfq_vbe_q2 = v(b_q2)-v(e_q2)
meas tran mf_su_vbemax_q2 MAX mfq_vbe_q2 from=0.0 to=2e-08
meas tran mf_su_vbemin_q2 MIN mfq_vbe_q2 from=0.0 to=2e-08
meas tran mf_ss_vbemax_q2 MAX mfq_vbe_q2 from=2e-08 to=4e-08
meas tran mf_ss_vbemin_q2 MIN mfq_vbe_q2 from=2e-08 to=4e-08
let mfq_ic_q2 = i(vic_q2)
meas tran mf_su_icmax_q2 MAX mfq_ic_q2 from=0.0 to=2e-08
meas tran mf_su_icmin_q2 MIN mfq_ic_q2 from=0.0 to=2e-08
meas tran mf_ss_icmax_q2 MAX mfq_ic_q2 from=2e-08 to=4e-08
meas tran mf_ss_icmin_q2 MIN mfq_ic_q2 from=2e-08 to=4e-08
let mfq_vce_q3 = v(c_q3)-v(x1)
meas tran mf_su_vcemax_q3 MAX mfq_vce_q3 from=0.0 to=2e-08
meas tran mf_su_vcemin_q3 MIN mfq_vce_q3 from=0.0 to=2e-08
meas tran mf_ss_vcemax_q3 MAX mfq_vce_q3 from=2e-08 to=4e-08
meas tran mf_ss_vcemin_q3 MIN mfq_vce_q3 from=2e-08 to=4e-08
let mfq_vbe_q3 = v(lo_p)-v(x1)
meas tran mf_su_vbemax_q3 MAX mfq_vbe_q3 from=0.0 to=2e-08
meas tran mf_su_vbemin_q3 MIN mfq_vbe_q3 from=0.0 to=2e-08
meas tran mf_ss_vbemax_q3 MAX mfq_vbe_q3 from=2e-08 to=4e-08
meas tran mf_ss_vbemin_q3 MIN mfq_vbe_q3 from=2e-08 to=4e-08
let mfq_ic_q3 = i(vic_q3)
meas tran mf_su_icmax_q3 MAX mfq_ic_q3 from=0.0 to=2e-08
meas tran mf_su_icmin_q3 MIN mfq_ic_q3 from=0.0 to=2e-08
meas tran mf_ss_icmax_q3 MAX mfq_ic_q3 from=2e-08 to=4e-08
meas tran mf_ss_icmin_q3 MIN mfq_ic_q3 from=2e-08 to=4e-08
let mfq_vce_q4 = v(c_q4)-v(x1)
meas tran mf_su_vcemax_q4 MAX mfq_vce_q4 from=0.0 to=2e-08
meas tran mf_su_vcemin_q4 MIN mfq_vce_q4 from=0.0 to=2e-08
meas tran mf_ss_vcemax_q4 MAX mfq_vce_q4 from=2e-08 to=4e-08
meas tran mf_ss_vcemin_q4 MIN mfq_vce_q4 from=2e-08 to=4e-08
let mfq_vbe_q4 = v(lo_n)-v(x1)
meas tran mf_su_vbemax_q4 MAX mfq_vbe_q4 from=0.0 to=2e-08
meas tran mf_su_vbemin_q4 MIN mfq_vbe_q4 from=0.0 to=2e-08
meas tran mf_ss_vbemax_q4 MAX mfq_vbe_q4 from=2e-08 to=4e-08
meas tran mf_ss_vbemin_q4 MIN mfq_vbe_q4 from=2e-08 to=4e-08
let mfq_ic_q4 = i(vic_q4)
meas tran mf_su_icmax_q4 MAX mfq_ic_q4 from=0.0 to=2e-08
meas tran mf_su_icmin_q4 MIN mfq_ic_q4 from=0.0 to=2e-08
meas tran mf_ss_icmax_q4 MAX mfq_ic_q4 from=2e-08 to=4e-08
meas tran mf_ss_icmin_q4 MIN mfq_ic_q4 from=2e-08 to=4e-08
let mfq_vce_q5 = v(c_q5)-v(x2)
meas tran mf_su_vcemax_q5 MAX mfq_vce_q5 from=0.0 to=2e-08
meas tran mf_su_vcemin_q5 MIN mfq_vce_q5 from=0.0 to=2e-08
meas tran mf_ss_vcemax_q5 MAX mfq_vce_q5 from=2e-08 to=4e-08
meas tran mf_ss_vcemin_q5 MIN mfq_vce_q5 from=2e-08 to=4e-08
let mfq_vbe_q5 = v(lo_p)-v(x2)
meas tran mf_su_vbemax_q5 MAX mfq_vbe_q5 from=0.0 to=2e-08
meas tran mf_su_vbemin_q5 MIN mfq_vbe_q5 from=0.0 to=2e-08
meas tran mf_ss_vbemax_q5 MAX mfq_vbe_q5 from=2e-08 to=4e-08
meas tran mf_ss_vbemin_q5 MIN mfq_vbe_q5 from=2e-08 to=4e-08
let mfq_ic_q5 = i(vic_q5)
meas tran mf_su_icmax_q5 MAX mfq_ic_q5 from=0.0 to=2e-08
meas tran mf_su_icmin_q5 MIN mfq_ic_q5 from=0.0 to=2e-08
meas tran mf_ss_icmax_q5 MAX mfq_ic_q5 from=2e-08 to=4e-08
meas tran mf_ss_icmin_q5 MIN mfq_ic_q5 from=2e-08 to=4e-08
let mfq_vce_q6 = v(c_q6)-v(x2)
meas tran mf_su_vcemax_q6 MAX mfq_vce_q6 from=0.0 to=2e-08
meas tran mf_su_vcemin_q6 MIN mfq_vce_q6 from=0.0 to=2e-08
meas tran mf_ss_vcemax_q6 MAX mfq_vce_q6 from=2e-08 to=4e-08
meas tran mf_ss_vcemin_q6 MIN mfq_vce_q6 from=2e-08 to=4e-08
let mfq_vbe_q6 = v(lo_n)-v(x2)
meas tran mf_su_vbemax_q6 MAX mfq_vbe_q6 from=0.0 to=2e-08
meas tran mf_su_vbemin_q6 MIN mfq_vbe_q6 from=0.0 to=2e-08
meas tran mf_ss_vbemax_q6 MAX mfq_vbe_q6 from=2e-08 to=4e-08
meas tran mf_ss_vbemin_q6 MIN mfq_vbe_q6 from=2e-08 to=4e-08
let mfq_ic_q6 = i(vic_q6)
meas tran mf_su_icmax_q6 MAX mfq_ic_q6 from=0.0 to=2e-08
meas tran mf_su_icmin_q6 MIN mfq_ic_q6 from=0.0 to=2e-08
meas tran mf_ss_icmax_q6 MAX mfq_ic_q6 from=2e-08 to=4e-08
meas tran mf_ss_icmin_q6 MIN mfq_ic_q6 from=2e-08 to=4e-08
meas tran mf_su_sinkmin_tail MIN v(tail) from=0.0 to=2e-08
meas tran mf_ss_sinkmin_tail MIN v(tail) from=2e-08 to=4e-08
print mf_su_vcemax_q1
print mf_su_vcemin_q1
print mf_ss_vcemax_q1
print mf_ss_vcemin_q1
print mf_su_vbemax_q1
print mf_su_vbemin_q1
print mf_ss_vbemax_q1
print mf_ss_vbemin_q1
print mf_su_icmax_q1
print mf_su_icmin_q1
print mf_ss_icmax_q1
print mf_ss_icmin_q1
print mf_su_vcemax_q2
print mf_su_vcemin_q2
print mf_ss_vcemax_q2
print mf_ss_vcemin_q2
print mf_su_vbemax_q2
print mf_su_vbemin_q2
print mf_ss_vbemax_q2
print mf_ss_vbemin_q2
print mf_su_icmax_q2
print mf_su_icmin_q2
print mf_ss_icmax_q2
print mf_ss_icmin_q2
print mf_su_vcemax_q3
print mf_su_vcemin_q3
print mf_ss_vcemax_q3
print mf_ss_vcemin_q3
print mf_su_vbemax_q3
print mf_su_vbemin_q3
print mf_ss_vbemax_q3
print mf_ss_vbemin_q3
print mf_su_icmax_q3
print mf_su_icmin_q3
print mf_ss_icmax_q3
print mf_ss_icmin_q3
print mf_su_vcemax_q4
print mf_su_vcemin_q4
print mf_ss_vcemax_q4
print mf_ss_vcemin_q4
print mf_su_vbemax_q4
print mf_su_vbemin_q4
print mf_ss_vbemax_q4
print mf_ss_vbemin_q4
print mf_su_icmax_q4
print mf_su_icmin_q4
print mf_ss_icmax_q4
print mf_ss_icmin_q4
print mf_su_vcemax_q5
print mf_su_vcemin_q5
print mf_ss_vcemax_q5
print mf_ss_vcemin_q5
print mf_su_vbemax_q5
print mf_su_vbemin_q5
print mf_ss_vbemax_q5
print mf_ss_vbemin_q5
print mf_su_icmax_q5
print mf_su_icmin_q5
print mf_ss_icmax_q5
print mf_ss_icmin_q5
print mf_su_vcemax_q6
print mf_su_vcemin_q6
print mf_ss_vcemax_q6
print mf_ss_vcemin_q6
print mf_su_vbemax_q6
print mf_su_vbemin_q6
print mf_ss_vbemax_q6
print mf_ss_vbemin_q6
print mf_su_icmax_q6
print mf_su_icmin_q6
print mf_ss_icmax_q6
print mf_ss_icmin_q6
print mf_su_sinkmin_tail
print mf_ss_sinkmin_tail
linearize
let mf_l = length(time)
let mfw = (time ge 1.99995e-08) * (time lt 3.99995e-08)
let mf_n = mean(mfw) * mf_l
let mfs = mf_l / mf_n
let mf_prail = mean(v(vdd) * (0 - i(vdd)) * mfw) * mfs
let mfph = 2 * pi * 18450000000.0 * (time - 2e-08)
let mf_lodiff_re = 2 * mean((v(lo_p)-v(lo_n)) * mfw * cos(mfph)) * mfs
let mf_lodiff_im = 2 * mean((v(lo_p)-v(lo_n)) * mfw * sin(mfph)) * mfs
let mfph = 2 * pi * 1000000000.0 * (time - 2e-08)
let mf_if_re = 2 * mean((v(if_out)) * mfw * cos(mfph)) * mfs
let mf_if_im = 2 * mean((v(if_out)) * mfw * sin(mfph)) * mfs
let mfph = 2 * pi * 18450000000.0 * (time - 2e-08)
let mf_loif_re = 2 * mean((v(if_out)) * mfw * cos(mfph)) * mfs
let mf_loif_im = 2 * mean((v(if_out)) * mfw * sin(mfph)) * mfs
let mfph = 2 * pi * 18450000000.0 * (time - 2e-08)
let mf_lorf_re = 2 * mean((v(rf_port)) * mfw * cos(mfph)) * mfs
let mf_lorf_im = 2 * mean((v(rf_port)) * mfw * sin(mfph)) * mfs
let mfph = 2 * pi * 950000000.0 * (time - 2e-08)
let mf_flifa_re = 2 * mean((v(if_out)) * mfw * cos(mfph)) * mfs
let mf_flifa_im = 2 * mean((v(if_out)) * mfw * sin(mfph)) * mfs
let mfph = 2 * pi * 1050000000.0 * (time - 2e-08)
let mf_flifb_re = 2 * mean((v(if_out)) * mfw * cos(mfph)) * mfs
let mf_flifb_im = 2 * mean((v(if_out)) * mfw * sin(mfph)) * mfs
let mfph = 2 * pi * 18500000000.0 * (time - 2e-08)
let mf_fllorf_re = 2 * mean((v(rf_port)) * mfw * cos(mfph)) * mfs
let mf_fllorf_im = 2 * mean((v(rf_port)) * mfw * sin(mfph)) * mfs
let mfph = 2 * pi * 18500000000.0 * (time - 2e-08)
let mf_flloif_re = 2 * mean((v(if_out)) * mfw * cos(mfph)) * mfs
let mf_flloif_im = 2 * mean((v(if_out)) * mfw * sin(mfph)) * mfs
print mf_l
print mf_n
print mf_prail
print mf_lodiff_re
print mf_lodiff_im
print mf_if_re
print mf_if_im
print mf_loif_re
print mf_loif_im
print mf_lorf_re
print mf_lorf_im
print mf_flifa_re
print mf_flifa_im
print mf_flifb_re
print mf_flifb_im
print mf_fllorf_re
print mf_fllorf_im
print mf_flloif_re
print mf_flloif_im
destroy all
echo "MFEND ls_f19p45_m27_rf66"
echo "MFRUN ls_f19p45_m24_rf60"
alterparam f1 = 19450000000.0
alterparam f2 = 19450000000.0
alterparam flo = 18450000000.0
alterparam vrf1 = 0.0006324555320336759
alterparam vrf2 = 0.0
alterparam vlo = 0.05643454052641856
reset
op
let mf_dcirail = 0 - i(vdd)
let mf_dc_vce_q1 = v(c_q1)-v(e_q1)
let mf_dc_vbe_q1 = v(b_q1)-v(e_q1)
let mf_dc_ic_q1 = i(vic_q1)
let mf_dc_vce_q2 = v(c_q2)-v(e_q2)
let mf_dc_vbe_q2 = v(b_q2)-v(e_q2)
let mf_dc_ic_q2 = i(vic_q2)
let mf_dc_vce_q3 = v(c_q3)-v(x1)
let mf_dc_vbe_q3 = v(lo_p)-v(x1)
let mf_dc_ic_q3 = i(vic_q3)
let mf_dc_vce_q4 = v(c_q4)-v(x1)
let mf_dc_vbe_q4 = v(lo_n)-v(x1)
let mf_dc_ic_q4 = i(vic_q4)
let mf_dc_vce_q5 = v(c_q5)-v(x2)
let mf_dc_vbe_q5 = v(lo_p)-v(x2)
let mf_dc_ic_q5 = i(vic_q5)
let mf_dc_vce_q6 = v(c_q6)-v(x2)
let mf_dc_vbe_q6 = v(lo_n)-v(x2)
let mf_dc_ic_q6 = i(vic_q6)
let mf_dc_sink_tail = v(tail)
print mf_dcirail
print mf_dc_vce_q1
print mf_dc_vbe_q1
print mf_dc_ic_q1
print mf_dc_vce_q2
print mf_dc_vbe_q2
print mf_dc_ic_q2
print mf_dc_vce_q3
print mf_dc_vbe_q3
print mf_dc_ic_q3
print mf_dc_vce_q4
print mf_dc_vbe_q4
print mf_dc_ic_q4
print mf_dc_vce_q5
print mf_dc_vbe_q5
print mf_dc_ic_q5
print mf_dc_vce_q6
print mf_dc_vbe_q6
print mf_dc_ic_q6
print mf_dc_sink_tail
tran 1e-12 4e-08 0 1e-12
let mfq_vce_q1 = v(c_q1)-v(e_q1)
meas tran mf_su_vcemax_q1 MAX mfq_vce_q1 from=0.0 to=2e-08
meas tran mf_su_vcemin_q1 MIN mfq_vce_q1 from=0.0 to=2e-08
meas tran mf_ss_vcemax_q1 MAX mfq_vce_q1 from=2e-08 to=4e-08
meas tran mf_ss_vcemin_q1 MIN mfq_vce_q1 from=2e-08 to=4e-08
let mfq_vbe_q1 = v(b_q1)-v(e_q1)
meas tran mf_su_vbemax_q1 MAX mfq_vbe_q1 from=0.0 to=2e-08
meas tran mf_su_vbemin_q1 MIN mfq_vbe_q1 from=0.0 to=2e-08
meas tran mf_ss_vbemax_q1 MAX mfq_vbe_q1 from=2e-08 to=4e-08
meas tran mf_ss_vbemin_q1 MIN mfq_vbe_q1 from=2e-08 to=4e-08
let mfq_ic_q1 = i(vic_q1)
meas tran mf_su_icmax_q1 MAX mfq_ic_q1 from=0.0 to=2e-08
meas tran mf_su_icmin_q1 MIN mfq_ic_q1 from=0.0 to=2e-08
meas tran mf_ss_icmax_q1 MAX mfq_ic_q1 from=2e-08 to=4e-08
meas tran mf_ss_icmin_q1 MIN mfq_ic_q1 from=2e-08 to=4e-08
let mfq_vce_q2 = v(c_q2)-v(e_q2)
meas tran mf_su_vcemax_q2 MAX mfq_vce_q2 from=0.0 to=2e-08
meas tran mf_su_vcemin_q2 MIN mfq_vce_q2 from=0.0 to=2e-08
meas tran mf_ss_vcemax_q2 MAX mfq_vce_q2 from=2e-08 to=4e-08
meas tran mf_ss_vcemin_q2 MIN mfq_vce_q2 from=2e-08 to=4e-08
let mfq_vbe_q2 = v(b_q2)-v(e_q2)
meas tran mf_su_vbemax_q2 MAX mfq_vbe_q2 from=0.0 to=2e-08
meas tran mf_su_vbemin_q2 MIN mfq_vbe_q2 from=0.0 to=2e-08
meas tran mf_ss_vbemax_q2 MAX mfq_vbe_q2 from=2e-08 to=4e-08
meas tran mf_ss_vbemin_q2 MIN mfq_vbe_q2 from=2e-08 to=4e-08
let mfq_ic_q2 = i(vic_q2)
meas tran mf_su_icmax_q2 MAX mfq_ic_q2 from=0.0 to=2e-08
meas tran mf_su_icmin_q2 MIN mfq_ic_q2 from=0.0 to=2e-08
meas tran mf_ss_icmax_q2 MAX mfq_ic_q2 from=2e-08 to=4e-08
meas tran mf_ss_icmin_q2 MIN mfq_ic_q2 from=2e-08 to=4e-08
let mfq_vce_q3 = v(c_q3)-v(x1)
meas tran mf_su_vcemax_q3 MAX mfq_vce_q3 from=0.0 to=2e-08
meas tran mf_su_vcemin_q3 MIN mfq_vce_q3 from=0.0 to=2e-08
meas tran mf_ss_vcemax_q3 MAX mfq_vce_q3 from=2e-08 to=4e-08
meas tran mf_ss_vcemin_q3 MIN mfq_vce_q3 from=2e-08 to=4e-08
let mfq_vbe_q3 = v(lo_p)-v(x1)
meas tran mf_su_vbemax_q3 MAX mfq_vbe_q3 from=0.0 to=2e-08
meas tran mf_su_vbemin_q3 MIN mfq_vbe_q3 from=0.0 to=2e-08
meas tran mf_ss_vbemax_q3 MAX mfq_vbe_q3 from=2e-08 to=4e-08
meas tran mf_ss_vbemin_q3 MIN mfq_vbe_q3 from=2e-08 to=4e-08
let mfq_ic_q3 = i(vic_q3)
meas tran mf_su_icmax_q3 MAX mfq_ic_q3 from=0.0 to=2e-08
meas tran mf_su_icmin_q3 MIN mfq_ic_q3 from=0.0 to=2e-08
meas tran mf_ss_icmax_q3 MAX mfq_ic_q3 from=2e-08 to=4e-08
meas tran mf_ss_icmin_q3 MIN mfq_ic_q3 from=2e-08 to=4e-08
let mfq_vce_q4 = v(c_q4)-v(x1)
meas tran mf_su_vcemax_q4 MAX mfq_vce_q4 from=0.0 to=2e-08
meas tran mf_su_vcemin_q4 MIN mfq_vce_q4 from=0.0 to=2e-08
meas tran mf_ss_vcemax_q4 MAX mfq_vce_q4 from=2e-08 to=4e-08
meas tran mf_ss_vcemin_q4 MIN mfq_vce_q4 from=2e-08 to=4e-08
let mfq_vbe_q4 = v(lo_n)-v(x1)
meas tran mf_su_vbemax_q4 MAX mfq_vbe_q4 from=0.0 to=2e-08
meas tran mf_su_vbemin_q4 MIN mfq_vbe_q4 from=0.0 to=2e-08
meas tran mf_ss_vbemax_q4 MAX mfq_vbe_q4 from=2e-08 to=4e-08
meas tran mf_ss_vbemin_q4 MIN mfq_vbe_q4 from=2e-08 to=4e-08
let mfq_ic_q4 = i(vic_q4)
meas tran mf_su_icmax_q4 MAX mfq_ic_q4 from=0.0 to=2e-08
meas tran mf_su_icmin_q4 MIN mfq_ic_q4 from=0.0 to=2e-08
meas tran mf_ss_icmax_q4 MAX mfq_ic_q4 from=2e-08 to=4e-08
meas tran mf_ss_icmin_q4 MIN mfq_ic_q4 from=2e-08 to=4e-08
let mfq_vce_q5 = v(c_q5)-v(x2)
meas tran mf_su_vcemax_q5 MAX mfq_vce_q5 from=0.0 to=2e-08
meas tran mf_su_vcemin_q5 MIN mfq_vce_q5 from=0.0 to=2e-08
meas tran mf_ss_vcemax_q5 MAX mfq_vce_q5 from=2e-08 to=4e-08
meas tran mf_ss_vcemin_q5 MIN mfq_vce_q5 from=2e-08 to=4e-08
let mfq_vbe_q5 = v(lo_p)-v(x2)
meas tran mf_su_vbemax_q5 MAX mfq_vbe_q5 from=0.0 to=2e-08
meas tran mf_su_vbemin_q5 MIN mfq_vbe_q5 from=0.0 to=2e-08
meas tran mf_ss_vbemax_q5 MAX mfq_vbe_q5 from=2e-08 to=4e-08
meas tran mf_ss_vbemin_q5 MIN mfq_vbe_q5 from=2e-08 to=4e-08
let mfq_ic_q5 = i(vic_q5)
meas tran mf_su_icmax_q5 MAX mfq_ic_q5 from=0.0 to=2e-08
meas tran mf_su_icmin_q5 MIN mfq_ic_q5 from=0.0 to=2e-08
meas tran mf_ss_icmax_q5 MAX mfq_ic_q5 from=2e-08 to=4e-08
meas tran mf_ss_icmin_q5 MIN mfq_ic_q5 from=2e-08 to=4e-08
let mfq_vce_q6 = v(c_q6)-v(x2)
meas tran mf_su_vcemax_q6 MAX mfq_vce_q6 from=0.0 to=2e-08
meas tran mf_su_vcemin_q6 MIN mfq_vce_q6 from=0.0 to=2e-08
meas tran mf_ss_vcemax_q6 MAX mfq_vce_q6 from=2e-08 to=4e-08
meas tran mf_ss_vcemin_q6 MIN mfq_vce_q6 from=2e-08 to=4e-08
let mfq_vbe_q6 = v(lo_n)-v(x2)
meas tran mf_su_vbemax_q6 MAX mfq_vbe_q6 from=0.0 to=2e-08
meas tran mf_su_vbemin_q6 MIN mfq_vbe_q6 from=0.0 to=2e-08
meas tran mf_ss_vbemax_q6 MAX mfq_vbe_q6 from=2e-08 to=4e-08
meas tran mf_ss_vbemin_q6 MIN mfq_vbe_q6 from=2e-08 to=4e-08
let mfq_ic_q6 = i(vic_q6)
meas tran mf_su_icmax_q6 MAX mfq_ic_q6 from=0.0 to=2e-08
meas tran mf_su_icmin_q6 MIN mfq_ic_q6 from=0.0 to=2e-08
meas tran mf_ss_icmax_q6 MAX mfq_ic_q6 from=2e-08 to=4e-08
meas tran mf_ss_icmin_q6 MIN mfq_ic_q6 from=2e-08 to=4e-08
meas tran mf_su_sinkmin_tail MIN v(tail) from=0.0 to=2e-08
meas tran mf_ss_sinkmin_tail MIN v(tail) from=2e-08 to=4e-08
print mf_su_vcemax_q1
print mf_su_vcemin_q1
print mf_ss_vcemax_q1
print mf_ss_vcemin_q1
print mf_su_vbemax_q1
print mf_su_vbemin_q1
print mf_ss_vbemax_q1
print mf_ss_vbemin_q1
print mf_su_icmax_q1
print mf_su_icmin_q1
print mf_ss_icmax_q1
print mf_ss_icmin_q1
print mf_su_vcemax_q2
print mf_su_vcemin_q2
print mf_ss_vcemax_q2
print mf_ss_vcemin_q2
print mf_su_vbemax_q2
print mf_su_vbemin_q2
print mf_ss_vbemax_q2
print mf_ss_vbemin_q2
print mf_su_icmax_q2
print mf_su_icmin_q2
print mf_ss_icmax_q2
print mf_ss_icmin_q2
print mf_su_vcemax_q3
print mf_su_vcemin_q3
print mf_ss_vcemax_q3
print mf_ss_vcemin_q3
print mf_su_vbemax_q3
print mf_su_vbemin_q3
print mf_ss_vbemax_q3
print mf_ss_vbemin_q3
print mf_su_icmax_q3
print mf_su_icmin_q3
print mf_ss_icmax_q3
print mf_ss_icmin_q3
print mf_su_vcemax_q4
print mf_su_vcemin_q4
print mf_ss_vcemax_q4
print mf_ss_vcemin_q4
print mf_su_vbemax_q4
print mf_su_vbemin_q4
print mf_ss_vbemax_q4
print mf_ss_vbemin_q4
print mf_su_icmax_q4
print mf_su_icmin_q4
print mf_ss_icmax_q4
print mf_ss_icmin_q4
print mf_su_vcemax_q5
print mf_su_vcemin_q5
print mf_ss_vcemax_q5
print mf_ss_vcemin_q5
print mf_su_vbemax_q5
print mf_su_vbemin_q5
print mf_ss_vbemax_q5
print mf_ss_vbemin_q5
print mf_su_icmax_q5
print mf_su_icmin_q5
print mf_ss_icmax_q5
print mf_ss_icmin_q5
print mf_su_vcemax_q6
print mf_su_vcemin_q6
print mf_ss_vcemax_q6
print mf_ss_vcemin_q6
print mf_su_vbemax_q6
print mf_su_vbemin_q6
print mf_ss_vbemax_q6
print mf_ss_vbemin_q6
print mf_su_icmax_q6
print mf_su_icmin_q6
print mf_ss_icmax_q6
print mf_ss_icmin_q6
print mf_su_sinkmin_tail
print mf_ss_sinkmin_tail
linearize
let mf_l = length(time)
let mfw = (time ge 1.99995e-08) * (time lt 3.99995e-08)
let mf_n = mean(mfw) * mf_l
let mfs = mf_l / mf_n
let mf_prail = mean(v(vdd) * (0 - i(vdd)) * mfw) * mfs
let mfph = 2 * pi * 18450000000.0 * (time - 2e-08)
let mf_lodiff_re = 2 * mean((v(lo_p)-v(lo_n)) * mfw * cos(mfph)) * mfs
let mf_lodiff_im = 2 * mean((v(lo_p)-v(lo_n)) * mfw * sin(mfph)) * mfs
let mfph = 2 * pi * 1000000000.0 * (time - 2e-08)
let mf_if_re = 2 * mean((v(if_out)) * mfw * cos(mfph)) * mfs
let mf_if_im = 2 * mean((v(if_out)) * mfw * sin(mfph)) * mfs
let mfph = 2 * pi * 18450000000.0 * (time - 2e-08)
let mf_loif_re = 2 * mean((v(if_out)) * mfw * cos(mfph)) * mfs
let mf_loif_im = 2 * mean((v(if_out)) * mfw * sin(mfph)) * mfs
let mfph = 2 * pi * 18450000000.0 * (time - 2e-08)
let mf_lorf_re = 2 * mean((v(rf_port)) * mfw * cos(mfph)) * mfs
let mf_lorf_im = 2 * mean((v(rf_port)) * mfw * sin(mfph)) * mfs
let mfph = 2 * pi * 950000000.0 * (time - 2e-08)
let mf_flifa_re = 2 * mean((v(if_out)) * mfw * cos(mfph)) * mfs
let mf_flifa_im = 2 * mean((v(if_out)) * mfw * sin(mfph)) * mfs
let mfph = 2 * pi * 1050000000.0 * (time - 2e-08)
let mf_flifb_re = 2 * mean((v(if_out)) * mfw * cos(mfph)) * mfs
let mf_flifb_im = 2 * mean((v(if_out)) * mfw * sin(mfph)) * mfs
let mfph = 2 * pi * 18500000000.0 * (time - 2e-08)
let mf_fllorf_re = 2 * mean((v(rf_port)) * mfw * cos(mfph)) * mfs
let mf_fllorf_im = 2 * mean((v(rf_port)) * mfw * sin(mfph)) * mfs
let mfph = 2 * pi * 18500000000.0 * (time - 2e-08)
let mf_flloif_re = 2 * mean((v(if_out)) * mfw * cos(mfph)) * mfs
let mf_flloif_im = 2 * mean((v(if_out)) * mfw * sin(mfph)) * mfs
print mf_l
print mf_n
print mf_prail
print mf_lodiff_re
print mf_lodiff_im
print mf_if_re
print mf_if_im
print mf_loif_re
print mf_loif_im
print mf_lorf_re
print mf_lorf_im
print mf_flifa_re
print mf_flifa_im
print mf_flifb_re
print mf_flifb_im
print mf_fllorf_re
print mf_fllorf_im
print mf_flloif_re
print mf_flloif_im
destroy all
echo "MFEND ls_f19p45_m24_rf60"
echo "MFRUN ls_f19p45_m24_rf66"
alterparam f1 = 19450000000.0
alterparam f2 = 19450000000.0
alterparam flo = 18450000000.0
alterparam vrf1 = 0.00031697863849222284
alterparam vrf2 = 0.0
alterparam vlo = 0.05643454052641856
reset
op
let mf_dcirail = 0 - i(vdd)
let mf_dc_vce_q1 = v(c_q1)-v(e_q1)
let mf_dc_vbe_q1 = v(b_q1)-v(e_q1)
let mf_dc_ic_q1 = i(vic_q1)
let mf_dc_vce_q2 = v(c_q2)-v(e_q2)
let mf_dc_vbe_q2 = v(b_q2)-v(e_q2)
let mf_dc_ic_q2 = i(vic_q2)
let mf_dc_vce_q3 = v(c_q3)-v(x1)
let mf_dc_vbe_q3 = v(lo_p)-v(x1)
let mf_dc_ic_q3 = i(vic_q3)
let mf_dc_vce_q4 = v(c_q4)-v(x1)
let mf_dc_vbe_q4 = v(lo_n)-v(x1)
let mf_dc_ic_q4 = i(vic_q4)
let mf_dc_vce_q5 = v(c_q5)-v(x2)
let mf_dc_vbe_q5 = v(lo_p)-v(x2)
let mf_dc_ic_q5 = i(vic_q5)
let mf_dc_vce_q6 = v(c_q6)-v(x2)
let mf_dc_vbe_q6 = v(lo_n)-v(x2)
let mf_dc_ic_q6 = i(vic_q6)
let mf_dc_sink_tail = v(tail)
print mf_dcirail
print mf_dc_vce_q1
print mf_dc_vbe_q1
print mf_dc_ic_q1
print mf_dc_vce_q2
print mf_dc_vbe_q2
print mf_dc_ic_q2
print mf_dc_vce_q3
print mf_dc_vbe_q3
print mf_dc_ic_q3
print mf_dc_vce_q4
print mf_dc_vbe_q4
print mf_dc_ic_q4
print mf_dc_vce_q5
print mf_dc_vbe_q5
print mf_dc_ic_q5
print mf_dc_vce_q6
print mf_dc_vbe_q6
print mf_dc_ic_q6
print mf_dc_sink_tail
tran 1e-12 4e-08 0 1e-12
let mfq_vce_q1 = v(c_q1)-v(e_q1)
meas tran mf_su_vcemax_q1 MAX mfq_vce_q1 from=0.0 to=2e-08
meas tran mf_su_vcemin_q1 MIN mfq_vce_q1 from=0.0 to=2e-08
meas tran mf_ss_vcemax_q1 MAX mfq_vce_q1 from=2e-08 to=4e-08
meas tran mf_ss_vcemin_q1 MIN mfq_vce_q1 from=2e-08 to=4e-08
let mfq_vbe_q1 = v(b_q1)-v(e_q1)
meas tran mf_su_vbemax_q1 MAX mfq_vbe_q1 from=0.0 to=2e-08
meas tran mf_su_vbemin_q1 MIN mfq_vbe_q1 from=0.0 to=2e-08
meas tran mf_ss_vbemax_q1 MAX mfq_vbe_q1 from=2e-08 to=4e-08
meas tran mf_ss_vbemin_q1 MIN mfq_vbe_q1 from=2e-08 to=4e-08
let mfq_ic_q1 = i(vic_q1)
meas tran mf_su_icmax_q1 MAX mfq_ic_q1 from=0.0 to=2e-08
meas tran mf_su_icmin_q1 MIN mfq_ic_q1 from=0.0 to=2e-08
meas tran mf_ss_icmax_q1 MAX mfq_ic_q1 from=2e-08 to=4e-08
meas tran mf_ss_icmin_q1 MIN mfq_ic_q1 from=2e-08 to=4e-08
let mfq_vce_q2 = v(c_q2)-v(e_q2)
meas tran mf_su_vcemax_q2 MAX mfq_vce_q2 from=0.0 to=2e-08
meas tran mf_su_vcemin_q2 MIN mfq_vce_q2 from=0.0 to=2e-08
meas tran mf_ss_vcemax_q2 MAX mfq_vce_q2 from=2e-08 to=4e-08
meas tran mf_ss_vcemin_q2 MIN mfq_vce_q2 from=2e-08 to=4e-08
let mfq_vbe_q2 = v(b_q2)-v(e_q2)
meas tran mf_su_vbemax_q2 MAX mfq_vbe_q2 from=0.0 to=2e-08
meas tran mf_su_vbemin_q2 MIN mfq_vbe_q2 from=0.0 to=2e-08
meas tran mf_ss_vbemax_q2 MAX mfq_vbe_q2 from=2e-08 to=4e-08
meas tran mf_ss_vbemin_q2 MIN mfq_vbe_q2 from=2e-08 to=4e-08
let mfq_ic_q2 = i(vic_q2)
meas tran mf_su_icmax_q2 MAX mfq_ic_q2 from=0.0 to=2e-08
meas tran mf_su_icmin_q2 MIN mfq_ic_q2 from=0.0 to=2e-08
meas tran mf_ss_icmax_q2 MAX mfq_ic_q2 from=2e-08 to=4e-08
meas tran mf_ss_icmin_q2 MIN mfq_ic_q2 from=2e-08 to=4e-08
let mfq_vce_q3 = v(c_q3)-v(x1)
meas tran mf_su_vcemax_q3 MAX mfq_vce_q3 from=0.0 to=2e-08
meas tran mf_su_vcemin_q3 MIN mfq_vce_q3 from=0.0 to=2e-08
meas tran mf_ss_vcemax_q3 MAX mfq_vce_q3 from=2e-08 to=4e-08
meas tran mf_ss_vcemin_q3 MIN mfq_vce_q3 from=2e-08 to=4e-08
let mfq_vbe_q3 = v(lo_p)-v(x1)
meas tran mf_su_vbemax_q3 MAX mfq_vbe_q3 from=0.0 to=2e-08
meas tran mf_su_vbemin_q3 MIN mfq_vbe_q3 from=0.0 to=2e-08
meas tran mf_ss_vbemax_q3 MAX mfq_vbe_q3 from=2e-08 to=4e-08
meas tran mf_ss_vbemin_q3 MIN mfq_vbe_q3 from=2e-08 to=4e-08
let mfq_ic_q3 = i(vic_q3)
meas tran mf_su_icmax_q3 MAX mfq_ic_q3 from=0.0 to=2e-08
meas tran mf_su_icmin_q3 MIN mfq_ic_q3 from=0.0 to=2e-08
meas tran mf_ss_icmax_q3 MAX mfq_ic_q3 from=2e-08 to=4e-08
meas tran mf_ss_icmin_q3 MIN mfq_ic_q3 from=2e-08 to=4e-08
let mfq_vce_q4 = v(c_q4)-v(x1)
meas tran mf_su_vcemax_q4 MAX mfq_vce_q4 from=0.0 to=2e-08
meas tran mf_su_vcemin_q4 MIN mfq_vce_q4 from=0.0 to=2e-08
meas tran mf_ss_vcemax_q4 MAX mfq_vce_q4 from=2e-08 to=4e-08
meas tran mf_ss_vcemin_q4 MIN mfq_vce_q4 from=2e-08 to=4e-08
let mfq_vbe_q4 = v(lo_n)-v(x1)
meas tran mf_su_vbemax_q4 MAX mfq_vbe_q4 from=0.0 to=2e-08
meas tran mf_su_vbemin_q4 MIN mfq_vbe_q4 from=0.0 to=2e-08
meas tran mf_ss_vbemax_q4 MAX mfq_vbe_q4 from=2e-08 to=4e-08
meas tran mf_ss_vbemin_q4 MIN mfq_vbe_q4 from=2e-08 to=4e-08
let mfq_ic_q4 = i(vic_q4)
meas tran mf_su_icmax_q4 MAX mfq_ic_q4 from=0.0 to=2e-08
meas tran mf_su_icmin_q4 MIN mfq_ic_q4 from=0.0 to=2e-08
meas tran mf_ss_icmax_q4 MAX mfq_ic_q4 from=2e-08 to=4e-08
meas tran mf_ss_icmin_q4 MIN mfq_ic_q4 from=2e-08 to=4e-08
let mfq_vce_q5 = v(c_q5)-v(x2)
meas tran mf_su_vcemax_q5 MAX mfq_vce_q5 from=0.0 to=2e-08
meas tran mf_su_vcemin_q5 MIN mfq_vce_q5 from=0.0 to=2e-08
meas tran mf_ss_vcemax_q5 MAX mfq_vce_q5 from=2e-08 to=4e-08
meas tran mf_ss_vcemin_q5 MIN mfq_vce_q5 from=2e-08 to=4e-08
let mfq_vbe_q5 = v(lo_p)-v(x2)
meas tran mf_su_vbemax_q5 MAX mfq_vbe_q5 from=0.0 to=2e-08
meas tran mf_su_vbemin_q5 MIN mfq_vbe_q5 from=0.0 to=2e-08
meas tran mf_ss_vbemax_q5 MAX mfq_vbe_q5 from=2e-08 to=4e-08
meas tran mf_ss_vbemin_q5 MIN mfq_vbe_q5 from=2e-08 to=4e-08
let mfq_ic_q5 = i(vic_q5)
meas tran mf_su_icmax_q5 MAX mfq_ic_q5 from=0.0 to=2e-08
meas tran mf_su_icmin_q5 MIN mfq_ic_q5 from=0.0 to=2e-08
meas tran mf_ss_icmax_q5 MAX mfq_ic_q5 from=2e-08 to=4e-08
meas tran mf_ss_icmin_q5 MIN mfq_ic_q5 from=2e-08 to=4e-08
let mfq_vce_q6 = v(c_q6)-v(x2)
meas tran mf_su_vcemax_q6 MAX mfq_vce_q6 from=0.0 to=2e-08
meas tran mf_su_vcemin_q6 MIN mfq_vce_q6 from=0.0 to=2e-08
meas tran mf_ss_vcemax_q6 MAX mfq_vce_q6 from=2e-08 to=4e-08
meas tran mf_ss_vcemin_q6 MIN mfq_vce_q6 from=2e-08 to=4e-08
let mfq_vbe_q6 = v(lo_n)-v(x2)
meas tran mf_su_vbemax_q6 MAX mfq_vbe_q6 from=0.0 to=2e-08
meas tran mf_su_vbemin_q6 MIN mfq_vbe_q6 from=0.0 to=2e-08
meas tran mf_ss_vbemax_q6 MAX mfq_vbe_q6 from=2e-08 to=4e-08
meas tran mf_ss_vbemin_q6 MIN mfq_vbe_q6 from=2e-08 to=4e-08
let mfq_ic_q6 = i(vic_q6)
meas tran mf_su_icmax_q6 MAX mfq_ic_q6 from=0.0 to=2e-08
meas tran mf_su_icmin_q6 MIN mfq_ic_q6 from=0.0 to=2e-08
meas tran mf_ss_icmax_q6 MAX mfq_ic_q6 from=2e-08 to=4e-08
meas tran mf_ss_icmin_q6 MIN mfq_ic_q6 from=2e-08 to=4e-08
meas tran mf_su_sinkmin_tail MIN v(tail) from=0.0 to=2e-08
meas tran mf_ss_sinkmin_tail MIN v(tail) from=2e-08 to=4e-08
print mf_su_vcemax_q1
print mf_su_vcemin_q1
print mf_ss_vcemax_q1
print mf_ss_vcemin_q1
print mf_su_vbemax_q1
print mf_su_vbemin_q1
print mf_ss_vbemax_q1
print mf_ss_vbemin_q1
print mf_su_icmax_q1
print mf_su_icmin_q1
print mf_ss_icmax_q1
print mf_ss_icmin_q1
print mf_su_vcemax_q2
print mf_su_vcemin_q2
print mf_ss_vcemax_q2
print mf_ss_vcemin_q2
print mf_su_vbemax_q2
print mf_su_vbemin_q2
print mf_ss_vbemax_q2
print mf_ss_vbemin_q2
print mf_su_icmax_q2
print mf_su_icmin_q2
print mf_ss_icmax_q2
print mf_ss_icmin_q2
print mf_su_vcemax_q3
print mf_su_vcemin_q3
print mf_ss_vcemax_q3
print mf_ss_vcemin_q3
print mf_su_vbemax_q3
print mf_su_vbemin_q3
print mf_ss_vbemax_q3
print mf_ss_vbemin_q3
print mf_su_icmax_q3
print mf_su_icmin_q3
print mf_ss_icmax_q3
print mf_ss_icmin_q3
print mf_su_vcemax_q4
print mf_su_vcemin_q4
print mf_ss_vcemax_q4
print mf_ss_vcemin_q4
print mf_su_vbemax_q4
print mf_su_vbemin_q4
print mf_ss_vbemax_q4
print mf_ss_vbemin_q4
print mf_su_icmax_q4
print mf_su_icmin_q4
print mf_ss_icmax_q4
print mf_ss_icmin_q4
print mf_su_vcemax_q5
print mf_su_vcemin_q5
print mf_ss_vcemax_q5
print mf_ss_vcemin_q5
print mf_su_vbemax_q5
print mf_su_vbemin_q5
print mf_ss_vbemax_q5
print mf_ss_vbemin_q5
print mf_su_icmax_q5
print mf_su_icmin_q5
print mf_ss_icmax_q5
print mf_ss_icmin_q5
print mf_su_vcemax_q6
print mf_su_vcemin_q6
print mf_ss_vcemax_q6
print mf_ss_vcemin_q6
print mf_su_vbemax_q6
print mf_su_vbemin_q6
print mf_ss_vbemax_q6
print mf_ss_vbemin_q6
print mf_su_icmax_q6
print mf_su_icmin_q6
print mf_ss_icmax_q6
print mf_ss_icmin_q6
print mf_su_sinkmin_tail
print mf_ss_sinkmin_tail
linearize
let mf_l = length(time)
let mfw = (time ge 1.99995e-08) * (time lt 3.99995e-08)
let mf_n = mean(mfw) * mf_l
let mfs = mf_l / mf_n
let mf_prail = mean(v(vdd) * (0 - i(vdd)) * mfw) * mfs
let mfph = 2 * pi * 18450000000.0 * (time - 2e-08)
let mf_lodiff_re = 2 * mean((v(lo_p)-v(lo_n)) * mfw * cos(mfph)) * mfs
let mf_lodiff_im = 2 * mean((v(lo_p)-v(lo_n)) * mfw * sin(mfph)) * mfs
let mfph = 2 * pi * 1000000000.0 * (time - 2e-08)
let mf_if_re = 2 * mean((v(if_out)) * mfw * cos(mfph)) * mfs
let mf_if_im = 2 * mean((v(if_out)) * mfw * sin(mfph)) * mfs
let mfph = 2 * pi * 18450000000.0 * (time - 2e-08)
let mf_loif_re = 2 * mean((v(if_out)) * mfw * cos(mfph)) * mfs
let mf_loif_im = 2 * mean((v(if_out)) * mfw * sin(mfph)) * mfs
let mfph = 2 * pi * 18450000000.0 * (time - 2e-08)
let mf_lorf_re = 2 * mean((v(rf_port)) * mfw * cos(mfph)) * mfs
let mf_lorf_im = 2 * mean((v(rf_port)) * mfw * sin(mfph)) * mfs
let mfph = 2 * pi * 950000000.0 * (time - 2e-08)
let mf_flifa_re = 2 * mean((v(if_out)) * mfw * cos(mfph)) * mfs
let mf_flifa_im = 2 * mean((v(if_out)) * mfw * sin(mfph)) * mfs
let mfph = 2 * pi * 1050000000.0 * (time - 2e-08)
let mf_flifb_re = 2 * mean((v(if_out)) * mfw * cos(mfph)) * mfs
let mf_flifb_im = 2 * mean((v(if_out)) * mfw * sin(mfph)) * mfs
let mfph = 2 * pi * 18500000000.0 * (time - 2e-08)
let mf_fllorf_re = 2 * mean((v(rf_port)) * mfw * cos(mfph)) * mfs
let mf_fllorf_im = 2 * mean((v(rf_port)) * mfw * sin(mfph)) * mfs
let mfph = 2 * pi * 18500000000.0 * (time - 2e-08)
let mf_flloif_re = 2 * mean((v(if_out)) * mfw * cos(mfph)) * mfs
let mf_flloif_im = 2 * mean((v(if_out)) * mfw * sin(mfph)) * mfs
print mf_l
print mf_n
print mf_prail
print mf_lodiff_re
print mf_lodiff_im
print mf_if_re
print mf_if_im
print mf_loif_re
print mf_loif_im
print mf_lorf_re
print mf_lorf_im
print mf_flifa_re
print mf_flifa_im
print mf_flifb_re
print mf_flifb_im
print mf_fllorf_re
print mf_fllorf_im
print mf_flloif_re
print mf_flloif_im
destroy all
echo "MFEND ls_f19p45_m24_rf66"
echo "MFRUN ls_f19p45_m21_rf60"
alterparam f1 = 19450000000.0
alterparam f2 = 19450000000.0
alterparam flo = 18450000000.0
alterparam vrf1 = 0.0006324555320336759
alterparam vrf2 = 0.0
alterparam vlo = 0.07971590730710057
reset
op
let mf_dcirail = 0 - i(vdd)
let mf_dc_vce_q1 = v(c_q1)-v(e_q1)
let mf_dc_vbe_q1 = v(b_q1)-v(e_q1)
let mf_dc_ic_q1 = i(vic_q1)
let mf_dc_vce_q2 = v(c_q2)-v(e_q2)
let mf_dc_vbe_q2 = v(b_q2)-v(e_q2)
let mf_dc_ic_q2 = i(vic_q2)
let mf_dc_vce_q3 = v(c_q3)-v(x1)
let mf_dc_vbe_q3 = v(lo_p)-v(x1)
let mf_dc_ic_q3 = i(vic_q3)
let mf_dc_vce_q4 = v(c_q4)-v(x1)
let mf_dc_vbe_q4 = v(lo_n)-v(x1)
let mf_dc_ic_q4 = i(vic_q4)
let mf_dc_vce_q5 = v(c_q5)-v(x2)
let mf_dc_vbe_q5 = v(lo_p)-v(x2)
let mf_dc_ic_q5 = i(vic_q5)
let mf_dc_vce_q6 = v(c_q6)-v(x2)
let mf_dc_vbe_q6 = v(lo_n)-v(x2)
let mf_dc_ic_q6 = i(vic_q6)
let mf_dc_sink_tail = v(tail)
print mf_dcirail
print mf_dc_vce_q1
print mf_dc_vbe_q1
print mf_dc_ic_q1
print mf_dc_vce_q2
print mf_dc_vbe_q2
print mf_dc_ic_q2
print mf_dc_vce_q3
print mf_dc_vbe_q3
print mf_dc_ic_q3
print mf_dc_vce_q4
print mf_dc_vbe_q4
print mf_dc_ic_q4
print mf_dc_vce_q5
print mf_dc_vbe_q5
print mf_dc_ic_q5
print mf_dc_vce_q6
print mf_dc_vbe_q6
print mf_dc_ic_q6
print mf_dc_sink_tail
tran 1e-12 4e-08 0 1e-12
let mfq_vce_q1 = v(c_q1)-v(e_q1)
meas tran mf_su_vcemax_q1 MAX mfq_vce_q1 from=0.0 to=2e-08
meas tran mf_su_vcemin_q1 MIN mfq_vce_q1 from=0.0 to=2e-08
meas tran mf_ss_vcemax_q1 MAX mfq_vce_q1 from=2e-08 to=4e-08
meas tran mf_ss_vcemin_q1 MIN mfq_vce_q1 from=2e-08 to=4e-08
let mfq_vbe_q1 = v(b_q1)-v(e_q1)
meas tran mf_su_vbemax_q1 MAX mfq_vbe_q1 from=0.0 to=2e-08
meas tran mf_su_vbemin_q1 MIN mfq_vbe_q1 from=0.0 to=2e-08
meas tran mf_ss_vbemax_q1 MAX mfq_vbe_q1 from=2e-08 to=4e-08
meas tran mf_ss_vbemin_q1 MIN mfq_vbe_q1 from=2e-08 to=4e-08
let mfq_ic_q1 = i(vic_q1)
meas tran mf_su_icmax_q1 MAX mfq_ic_q1 from=0.0 to=2e-08
meas tran mf_su_icmin_q1 MIN mfq_ic_q1 from=0.0 to=2e-08
meas tran mf_ss_icmax_q1 MAX mfq_ic_q1 from=2e-08 to=4e-08
meas tran mf_ss_icmin_q1 MIN mfq_ic_q1 from=2e-08 to=4e-08
let mfq_vce_q2 = v(c_q2)-v(e_q2)
meas tran mf_su_vcemax_q2 MAX mfq_vce_q2 from=0.0 to=2e-08
meas tran mf_su_vcemin_q2 MIN mfq_vce_q2 from=0.0 to=2e-08
meas tran mf_ss_vcemax_q2 MAX mfq_vce_q2 from=2e-08 to=4e-08
meas tran mf_ss_vcemin_q2 MIN mfq_vce_q2 from=2e-08 to=4e-08
let mfq_vbe_q2 = v(b_q2)-v(e_q2)
meas tran mf_su_vbemax_q2 MAX mfq_vbe_q2 from=0.0 to=2e-08
meas tran mf_su_vbemin_q2 MIN mfq_vbe_q2 from=0.0 to=2e-08
meas tran mf_ss_vbemax_q2 MAX mfq_vbe_q2 from=2e-08 to=4e-08
meas tran mf_ss_vbemin_q2 MIN mfq_vbe_q2 from=2e-08 to=4e-08
let mfq_ic_q2 = i(vic_q2)
meas tran mf_su_icmax_q2 MAX mfq_ic_q2 from=0.0 to=2e-08
meas tran mf_su_icmin_q2 MIN mfq_ic_q2 from=0.0 to=2e-08
meas tran mf_ss_icmax_q2 MAX mfq_ic_q2 from=2e-08 to=4e-08
meas tran mf_ss_icmin_q2 MIN mfq_ic_q2 from=2e-08 to=4e-08
let mfq_vce_q3 = v(c_q3)-v(x1)
meas tran mf_su_vcemax_q3 MAX mfq_vce_q3 from=0.0 to=2e-08
meas tran mf_su_vcemin_q3 MIN mfq_vce_q3 from=0.0 to=2e-08
meas tran mf_ss_vcemax_q3 MAX mfq_vce_q3 from=2e-08 to=4e-08
meas tran mf_ss_vcemin_q3 MIN mfq_vce_q3 from=2e-08 to=4e-08
let mfq_vbe_q3 = v(lo_p)-v(x1)
meas tran mf_su_vbemax_q3 MAX mfq_vbe_q3 from=0.0 to=2e-08
meas tran mf_su_vbemin_q3 MIN mfq_vbe_q3 from=0.0 to=2e-08
meas tran mf_ss_vbemax_q3 MAX mfq_vbe_q3 from=2e-08 to=4e-08
meas tran mf_ss_vbemin_q3 MIN mfq_vbe_q3 from=2e-08 to=4e-08
let mfq_ic_q3 = i(vic_q3)
meas tran mf_su_icmax_q3 MAX mfq_ic_q3 from=0.0 to=2e-08
meas tran mf_su_icmin_q3 MIN mfq_ic_q3 from=0.0 to=2e-08
meas tran mf_ss_icmax_q3 MAX mfq_ic_q3 from=2e-08 to=4e-08
meas tran mf_ss_icmin_q3 MIN mfq_ic_q3 from=2e-08 to=4e-08
let mfq_vce_q4 = v(c_q4)-v(x1)
meas tran mf_su_vcemax_q4 MAX mfq_vce_q4 from=0.0 to=2e-08
meas tran mf_su_vcemin_q4 MIN mfq_vce_q4 from=0.0 to=2e-08
meas tran mf_ss_vcemax_q4 MAX mfq_vce_q4 from=2e-08 to=4e-08
meas tran mf_ss_vcemin_q4 MIN mfq_vce_q4 from=2e-08 to=4e-08
let mfq_vbe_q4 = v(lo_n)-v(x1)
meas tran mf_su_vbemax_q4 MAX mfq_vbe_q4 from=0.0 to=2e-08
meas tran mf_su_vbemin_q4 MIN mfq_vbe_q4 from=0.0 to=2e-08
meas tran mf_ss_vbemax_q4 MAX mfq_vbe_q4 from=2e-08 to=4e-08
meas tran mf_ss_vbemin_q4 MIN mfq_vbe_q4 from=2e-08 to=4e-08
let mfq_ic_q4 = i(vic_q4)
meas tran mf_su_icmax_q4 MAX mfq_ic_q4 from=0.0 to=2e-08
meas tran mf_su_icmin_q4 MIN mfq_ic_q4 from=0.0 to=2e-08
meas tran mf_ss_icmax_q4 MAX mfq_ic_q4 from=2e-08 to=4e-08
meas tran mf_ss_icmin_q4 MIN mfq_ic_q4 from=2e-08 to=4e-08
let mfq_vce_q5 = v(c_q5)-v(x2)
meas tran mf_su_vcemax_q5 MAX mfq_vce_q5 from=0.0 to=2e-08
meas tran mf_su_vcemin_q5 MIN mfq_vce_q5 from=0.0 to=2e-08
meas tran mf_ss_vcemax_q5 MAX mfq_vce_q5 from=2e-08 to=4e-08
meas tran mf_ss_vcemin_q5 MIN mfq_vce_q5 from=2e-08 to=4e-08
let mfq_vbe_q5 = v(lo_p)-v(x2)
meas tran mf_su_vbemax_q5 MAX mfq_vbe_q5 from=0.0 to=2e-08
meas tran mf_su_vbemin_q5 MIN mfq_vbe_q5 from=0.0 to=2e-08
meas tran mf_ss_vbemax_q5 MAX mfq_vbe_q5 from=2e-08 to=4e-08
meas tran mf_ss_vbemin_q5 MIN mfq_vbe_q5 from=2e-08 to=4e-08
let mfq_ic_q5 = i(vic_q5)
meas tran mf_su_icmax_q5 MAX mfq_ic_q5 from=0.0 to=2e-08
meas tran mf_su_icmin_q5 MIN mfq_ic_q5 from=0.0 to=2e-08
meas tran mf_ss_icmax_q5 MAX mfq_ic_q5 from=2e-08 to=4e-08
meas tran mf_ss_icmin_q5 MIN mfq_ic_q5 from=2e-08 to=4e-08
let mfq_vce_q6 = v(c_q6)-v(x2)
meas tran mf_su_vcemax_q6 MAX mfq_vce_q6 from=0.0 to=2e-08
meas tran mf_su_vcemin_q6 MIN mfq_vce_q6 from=0.0 to=2e-08
meas tran mf_ss_vcemax_q6 MAX mfq_vce_q6 from=2e-08 to=4e-08
meas tran mf_ss_vcemin_q6 MIN mfq_vce_q6 from=2e-08 to=4e-08
let mfq_vbe_q6 = v(lo_n)-v(x2)
meas tran mf_su_vbemax_q6 MAX mfq_vbe_q6 from=0.0 to=2e-08
meas tran mf_su_vbemin_q6 MIN mfq_vbe_q6 from=0.0 to=2e-08
meas tran mf_ss_vbemax_q6 MAX mfq_vbe_q6 from=2e-08 to=4e-08
meas tran mf_ss_vbemin_q6 MIN mfq_vbe_q6 from=2e-08 to=4e-08
let mfq_ic_q6 = i(vic_q6)
meas tran mf_su_icmax_q6 MAX mfq_ic_q6 from=0.0 to=2e-08
meas tran mf_su_icmin_q6 MIN mfq_ic_q6 from=0.0 to=2e-08
meas tran mf_ss_icmax_q6 MAX mfq_ic_q6 from=2e-08 to=4e-08
meas tran mf_ss_icmin_q6 MIN mfq_ic_q6 from=2e-08 to=4e-08
meas tran mf_su_sinkmin_tail MIN v(tail) from=0.0 to=2e-08
meas tran mf_ss_sinkmin_tail MIN v(tail) from=2e-08 to=4e-08
print mf_su_vcemax_q1
print mf_su_vcemin_q1
print mf_ss_vcemax_q1
print mf_ss_vcemin_q1
print mf_su_vbemax_q1
print mf_su_vbemin_q1
print mf_ss_vbemax_q1
print mf_ss_vbemin_q1
print mf_su_icmax_q1
print mf_su_icmin_q1
print mf_ss_icmax_q1
print mf_ss_icmin_q1
print mf_su_vcemax_q2
print mf_su_vcemin_q2
print mf_ss_vcemax_q2
print mf_ss_vcemin_q2
print mf_su_vbemax_q2
print mf_su_vbemin_q2
print mf_ss_vbemax_q2
print mf_ss_vbemin_q2
print mf_su_icmax_q2
print mf_su_icmin_q2
print mf_ss_icmax_q2
print mf_ss_icmin_q2
print mf_su_vcemax_q3
print mf_su_vcemin_q3
print mf_ss_vcemax_q3
print mf_ss_vcemin_q3
print mf_su_vbemax_q3
print mf_su_vbemin_q3
print mf_ss_vbemax_q3
print mf_ss_vbemin_q3
print mf_su_icmax_q3
print mf_su_icmin_q3
print mf_ss_icmax_q3
print mf_ss_icmin_q3
print mf_su_vcemax_q4
print mf_su_vcemin_q4
print mf_ss_vcemax_q4
print mf_ss_vcemin_q4
print mf_su_vbemax_q4
print mf_su_vbemin_q4
print mf_ss_vbemax_q4
print mf_ss_vbemin_q4
print mf_su_icmax_q4
print mf_su_icmin_q4
print mf_ss_icmax_q4
print mf_ss_icmin_q4
print mf_su_vcemax_q5
print mf_su_vcemin_q5
print mf_ss_vcemax_q5
print mf_ss_vcemin_q5
print mf_su_vbemax_q5
print mf_su_vbemin_q5
print mf_ss_vbemax_q5
print mf_ss_vbemin_q5
print mf_su_icmax_q5
print mf_su_icmin_q5
print mf_ss_icmax_q5
print mf_ss_icmin_q5
print mf_su_vcemax_q6
print mf_su_vcemin_q6
print mf_ss_vcemax_q6
print mf_ss_vcemin_q6
print mf_su_vbemax_q6
print mf_su_vbemin_q6
print mf_ss_vbemax_q6
print mf_ss_vbemin_q6
print mf_su_icmax_q6
print mf_su_icmin_q6
print mf_ss_icmax_q6
print mf_ss_icmin_q6
print mf_su_sinkmin_tail
print mf_ss_sinkmin_tail
linearize
let mf_l = length(time)
let mfw = (time ge 1.99995e-08) * (time lt 3.99995e-08)
let mf_n = mean(mfw) * mf_l
let mfs = mf_l / mf_n
let mf_prail = mean(v(vdd) * (0 - i(vdd)) * mfw) * mfs
let mfph = 2 * pi * 18450000000.0 * (time - 2e-08)
let mf_lodiff_re = 2 * mean((v(lo_p)-v(lo_n)) * mfw * cos(mfph)) * mfs
let mf_lodiff_im = 2 * mean((v(lo_p)-v(lo_n)) * mfw * sin(mfph)) * mfs
let mfph = 2 * pi * 1000000000.0 * (time - 2e-08)
let mf_if_re = 2 * mean((v(if_out)) * mfw * cos(mfph)) * mfs
let mf_if_im = 2 * mean((v(if_out)) * mfw * sin(mfph)) * mfs
let mfph = 2 * pi * 18450000000.0 * (time - 2e-08)
let mf_loif_re = 2 * mean((v(if_out)) * mfw * cos(mfph)) * mfs
let mf_loif_im = 2 * mean((v(if_out)) * mfw * sin(mfph)) * mfs
let mfph = 2 * pi * 18450000000.0 * (time - 2e-08)
let mf_lorf_re = 2 * mean((v(rf_port)) * mfw * cos(mfph)) * mfs
let mf_lorf_im = 2 * mean((v(rf_port)) * mfw * sin(mfph)) * mfs
let mfph = 2 * pi * 950000000.0 * (time - 2e-08)
let mf_flifa_re = 2 * mean((v(if_out)) * mfw * cos(mfph)) * mfs
let mf_flifa_im = 2 * mean((v(if_out)) * mfw * sin(mfph)) * mfs
let mfph = 2 * pi * 1050000000.0 * (time - 2e-08)
let mf_flifb_re = 2 * mean((v(if_out)) * mfw * cos(mfph)) * mfs
let mf_flifb_im = 2 * mean((v(if_out)) * mfw * sin(mfph)) * mfs
let mfph = 2 * pi * 18500000000.0 * (time - 2e-08)
let mf_fllorf_re = 2 * mean((v(rf_port)) * mfw * cos(mfph)) * mfs
let mf_fllorf_im = 2 * mean((v(rf_port)) * mfw * sin(mfph)) * mfs
let mfph = 2 * pi * 18500000000.0 * (time - 2e-08)
let mf_flloif_re = 2 * mean((v(if_out)) * mfw * cos(mfph)) * mfs
let mf_flloif_im = 2 * mean((v(if_out)) * mfw * sin(mfph)) * mfs
print mf_l
print mf_n
print mf_prail
print mf_lodiff_re
print mf_lodiff_im
print mf_if_re
print mf_if_im
print mf_loif_re
print mf_loif_im
print mf_lorf_re
print mf_lorf_im
print mf_flifa_re
print mf_flifa_im
print mf_flifb_re
print mf_flifb_im
print mf_fllorf_re
print mf_fllorf_im
print mf_flloif_re
print mf_flloif_im
destroy all
echo "MFEND ls_f19p45_m21_rf60"
echo "MFRUN ls_f19p45_m21_rf66"
alterparam f1 = 19450000000.0
alterparam f2 = 19450000000.0
alterparam flo = 18450000000.0
alterparam vrf1 = 0.00031697863849222284
alterparam vrf2 = 0.0
alterparam vlo = 0.07971590730710057
reset
op
let mf_dcirail = 0 - i(vdd)
let mf_dc_vce_q1 = v(c_q1)-v(e_q1)
let mf_dc_vbe_q1 = v(b_q1)-v(e_q1)
let mf_dc_ic_q1 = i(vic_q1)
let mf_dc_vce_q2 = v(c_q2)-v(e_q2)
let mf_dc_vbe_q2 = v(b_q2)-v(e_q2)
let mf_dc_ic_q2 = i(vic_q2)
let mf_dc_vce_q3 = v(c_q3)-v(x1)
let mf_dc_vbe_q3 = v(lo_p)-v(x1)
let mf_dc_ic_q3 = i(vic_q3)
let mf_dc_vce_q4 = v(c_q4)-v(x1)
let mf_dc_vbe_q4 = v(lo_n)-v(x1)
let mf_dc_ic_q4 = i(vic_q4)
let mf_dc_vce_q5 = v(c_q5)-v(x2)
let mf_dc_vbe_q5 = v(lo_p)-v(x2)
let mf_dc_ic_q5 = i(vic_q5)
let mf_dc_vce_q6 = v(c_q6)-v(x2)
let mf_dc_vbe_q6 = v(lo_n)-v(x2)
let mf_dc_ic_q6 = i(vic_q6)
let mf_dc_sink_tail = v(tail)
print mf_dcirail
print mf_dc_vce_q1
print mf_dc_vbe_q1
print mf_dc_ic_q1
print mf_dc_vce_q2
print mf_dc_vbe_q2
print mf_dc_ic_q2
print mf_dc_vce_q3
print mf_dc_vbe_q3
print mf_dc_ic_q3
print mf_dc_vce_q4
print mf_dc_vbe_q4
print mf_dc_ic_q4
print mf_dc_vce_q5
print mf_dc_vbe_q5
print mf_dc_ic_q5
print mf_dc_vce_q6
print mf_dc_vbe_q6
print mf_dc_ic_q6
print mf_dc_sink_tail
tran 1e-12 4e-08 0 1e-12
let mfq_vce_q1 = v(c_q1)-v(e_q1)
meas tran mf_su_vcemax_q1 MAX mfq_vce_q1 from=0.0 to=2e-08
meas tran mf_su_vcemin_q1 MIN mfq_vce_q1 from=0.0 to=2e-08
meas tran mf_ss_vcemax_q1 MAX mfq_vce_q1 from=2e-08 to=4e-08
meas tran mf_ss_vcemin_q1 MIN mfq_vce_q1 from=2e-08 to=4e-08
let mfq_vbe_q1 = v(b_q1)-v(e_q1)
meas tran mf_su_vbemax_q1 MAX mfq_vbe_q1 from=0.0 to=2e-08
meas tran mf_su_vbemin_q1 MIN mfq_vbe_q1 from=0.0 to=2e-08
meas tran mf_ss_vbemax_q1 MAX mfq_vbe_q1 from=2e-08 to=4e-08
meas tran mf_ss_vbemin_q1 MIN mfq_vbe_q1 from=2e-08 to=4e-08
let mfq_ic_q1 = i(vic_q1)
meas tran mf_su_icmax_q1 MAX mfq_ic_q1 from=0.0 to=2e-08
meas tran mf_su_icmin_q1 MIN mfq_ic_q1 from=0.0 to=2e-08
meas tran mf_ss_icmax_q1 MAX mfq_ic_q1 from=2e-08 to=4e-08
meas tran mf_ss_icmin_q1 MIN mfq_ic_q1 from=2e-08 to=4e-08
let mfq_vce_q2 = v(c_q2)-v(e_q2)
meas tran mf_su_vcemax_q2 MAX mfq_vce_q2 from=0.0 to=2e-08
meas tran mf_su_vcemin_q2 MIN mfq_vce_q2 from=0.0 to=2e-08
meas tran mf_ss_vcemax_q2 MAX mfq_vce_q2 from=2e-08 to=4e-08
meas tran mf_ss_vcemin_q2 MIN mfq_vce_q2 from=2e-08 to=4e-08
let mfq_vbe_q2 = v(b_q2)-v(e_q2)
meas tran mf_su_vbemax_q2 MAX mfq_vbe_q2 from=0.0 to=2e-08
meas tran mf_su_vbemin_q2 MIN mfq_vbe_q2 from=0.0 to=2e-08
meas tran mf_ss_vbemax_q2 MAX mfq_vbe_q2 from=2e-08 to=4e-08
meas tran mf_ss_vbemin_q2 MIN mfq_vbe_q2 from=2e-08 to=4e-08
let mfq_ic_q2 = i(vic_q2)
meas tran mf_su_icmax_q2 MAX mfq_ic_q2 from=0.0 to=2e-08
meas tran mf_su_icmin_q2 MIN mfq_ic_q2 from=0.0 to=2e-08
meas tran mf_ss_icmax_q2 MAX mfq_ic_q2 from=2e-08 to=4e-08
meas tran mf_ss_icmin_q2 MIN mfq_ic_q2 from=2e-08 to=4e-08
let mfq_vce_q3 = v(c_q3)-v(x1)
meas tran mf_su_vcemax_q3 MAX mfq_vce_q3 from=0.0 to=2e-08
meas tran mf_su_vcemin_q3 MIN mfq_vce_q3 from=0.0 to=2e-08
meas tran mf_ss_vcemax_q3 MAX mfq_vce_q3 from=2e-08 to=4e-08
meas tran mf_ss_vcemin_q3 MIN mfq_vce_q3 from=2e-08 to=4e-08
let mfq_vbe_q3 = v(lo_p)-v(x1)
meas tran mf_su_vbemax_q3 MAX mfq_vbe_q3 from=0.0 to=2e-08
meas tran mf_su_vbemin_q3 MIN mfq_vbe_q3 from=0.0 to=2e-08
meas tran mf_ss_vbemax_q3 MAX mfq_vbe_q3 from=2e-08 to=4e-08
meas tran mf_ss_vbemin_q3 MIN mfq_vbe_q3 from=2e-08 to=4e-08
let mfq_ic_q3 = i(vic_q3)
meas tran mf_su_icmax_q3 MAX mfq_ic_q3 from=0.0 to=2e-08
meas tran mf_su_icmin_q3 MIN mfq_ic_q3 from=0.0 to=2e-08
meas tran mf_ss_icmax_q3 MAX mfq_ic_q3 from=2e-08 to=4e-08
meas tran mf_ss_icmin_q3 MIN mfq_ic_q3 from=2e-08 to=4e-08
let mfq_vce_q4 = v(c_q4)-v(x1)
meas tran mf_su_vcemax_q4 MAX mfq_vce_q4 from=0.0 to=2e-08
meas tran mf_su_vcemin_q4 MIN mfq_vce_q4 from=0.0 to=2e-08
meas tran mf_ss_vcemax_q4 MAX mfq_vce_q4 from=2e-08 to=4e-08
meas tran mf_ss_vcemin_q4 MIN mfq_vce_q4 from=2e-08 to=4e-08
let mfq_vbe_q4 = v(lo_n)-v(x1)
meas tran mf_su_vbemax_q4 MAX mfq_vbe_q4 from=0.0 to=2e-08
meas tran mf_su_vbemin_q4 MIN mfq_vbe_q4 from=0.0 to=2e-08
meas tran mf_ss_vbemax_q4 MAX mfq_vbe_q4 from=2e-08 to=4e-08
meas tran mf_ss_vbemin_q4 MIN mfq_vbe_q4 from=2e-08 to=4e-08
let mfq_ic_q4 = i(vic_q4)
meas tran mf_su_icmax_q4 MAX mfq_ic_q4 from=0.0 to=2e-08
meas tran mf_su_icmin_q4 MIN mfq_ic_q4 from=0.0 to=2e-08
meas tran mf_ss_icmax_q4 MAX mfq_ic_q4 from=2e-08 to=4e-08
meas tran mf_ss_icmin_q4 MIN mfq_ic_q4 from=2e-08 to=4e-08
let mfq_vce_q5 = v(c_q5)-v(x2)
meas tran mf_su_vcemax_q5 MAX mfq_vce_q5 from=0.0 to=2e-08
meas tran mf_su_vcemin_q5 MIN mfq_vce_q5 from=0.0 to=2e-08
meas tran mf_ss_vcemax_q5 MAX mfq_vce_q5 from=2e-08 to=4e-08
meas tran mf_ss_vcemin_q5 MIN mfq_vce_q5 from=2e-08 to=4e-08
let mfq_vbe_q5 = v(lo_p)-v(x2)
meas tran mf_su_vbemax_q5 MAX mfq_vbe_q5 from=0.0 to=2e-08
meas tran mf_su_vbemin_q5 MIN mfq_vbe_q5 from=0.0 to=2e-08
meas tran mf_ss_vbemax_q5 MAX mfq_vbe_q5 from=2e-08 to=4e-08
meas tran mf_ss_vbemin_q5 MIN mfq_vbe_q5 from=2e-08 to=4e-08
let mfq_ic_q5 = i(vic_q5)
meas tran mf_su_icmax_q5 MAX mfq_ic_q5 from=0.0 to=2e-08
meas tran mf_su_icmin_q5 MIN mfq_ic_q5 from=0.0 to=2e-08
meas tran mf_ss_icmax_q5 MAX mfq_ic_q5 from=2e-08 to=4e-08
meas tran mf_ss_icmin_q5 MIN mfq_ic_q5 from=2e-08 to=4e-08
let mfq_vce_q6 = v(c_q6)-v(x2)
meas tran mf_su_vcemax_q6 MAX mfq_vce_q6 from=0.0 to=2e-08
meas tran mf_su_vcemin_q6 MIN mfq_vce_q6 from=0.0 to=2e-08
meas tran mf_ss_vcemax_q6 MAX mfq_vce_q6 from=2e-08 to=4e-08
meas tran mf_ss_vcemin_q6 MIN mfq_vce_q6 from=2e-08 to=4e-08
let mfq_vbe_q6 = v(lo_n)-v(x2)
meas tran mf_su_vbemax_q6 MAX mfq_vbe_q6 from=0.0 to=2e-08
meas tran mf_su_vbemin_q6 MIN mfq_vbe_q6 from=0.0 to=2e-08
meas tran mf_ss_vbemax_q6 MAX mfq_vbe_q6 from=2e-08 to=4e-08
meas tran mf_ss_vbemin_q6 MIN mfq_vbe_q6 from=2e-08 to=4e-08
let mfq_ic_q6 = i(vic_q6)
meas tran mf_su_icmax_q6 MAX mfq_ic_q6 from=0.0 to=2e-08
meas tran mf_su_icmin_q6 MIN mfq_ic_q6 from=0.0 to=2e-08
meas tran mf_ss_icmax_q6 MAX mfq_ic_q6 from=2e-08 to=4e-08
meas tran mf_ss_icmin_q6 MIN mfq_ic_q6 from=2e-08 to=4e-08
meas tran mf_su_sinkmin_tail MIN v(tail) from=0.0 to=2e-08
meas tran mf_ss_sinkmin_tail MIN v(tail) from=2e-08 to=4e-08
print mf_su_vcemax_q1
print mf_su_vcemin_q1
print mf_ss_vcemax_q1
print mf_ss_vcemin_q1
print mf_su_vbemax_q1
print mf_su_vbemin_q1
print mf_ss_vbemax_q1
print mf_ss_vbemin_q1
print mf_su_icmax_q1
print mf_su_icmin_q1
print mf_ss_icmax_q1
print mf_ss_icmin_q1
print mf_su_vcemax_q2
print mf_su_vcemin_q2
print mf_ss_vcemax_q2
print mf_ss_vcemin_q2
print mf_su_vbemax_q2
print mf_su_vbemin_q2
print mf_ss_vbemax_q2
print mf_ss_vbemin_q2
print mf_su_icmax_q2
print mf_su_icmin_q2
print mf_ss_icmax_q2
print mf_ss_icmin_q2
print mf_su_vcemax_q3
print mf_su_vcemin_q3
print mf_ss_vcemax_q3
print mf_ss_vcemin_q3
print mf_su_vbemax_q3
print mf_su_vbemin_q3
print mf_ss_vbemax_q3
print mf_ss_vbemin_q3
print mf_su_icmax_q3
print mf_su_icmin_q3
print mf_ss_icmax_q3
print mf_ss_icmin_q3
print mf_su_vcemax_q4
print mf_su_vcemin_q4
print mf_ss_vcemax_q4
print mf_ss_vcemin_q4
print mf_su_vbemax_q4
print mf_su_vbemin_q4
print mf_ss_vbemax_q4
print mf_ss_vbemin_q4
print mf_su_icmax_q4
print mf_su_icmin_q4
print mf_ss_icmax_q4
print mf_ss_icmin_q4
print mf_su_vcemax_q5
print mf_su_vcemin_q5
print mf_ss_vcemax_q5
print mf_ss_vcemin_q5
print mf_su_vbemax_q5
print mf_su_vbemin_q5
print mf_ss_vbemax_q5
print mf_ss_vbemin_q5
print mf_su_icmax_q5
print mf_su_icmin_q5
print mf_ss_icmax_q5
print mf_ss_icmin_q5
print mf_su_vcemax_q6
print mf_su_vcemin_q6
print mf_ss_vcemax_q6
print mf_ss_vcemin_q6
print mf_su_vbemax_q6
print mf_su_vbemin_q6
print mf_ss_vbemax_q6
print mf_ss_vbemin_q6
print mf_su_icmax_q6
print mf_su_icmin_q6
print mf_ss_icmax_q6
print mf_ss_icmin_q6
print mf_su_sinkmin_tail
print mf_ss_sinkmin_tail
linearize
let mf_l = length(time)
let mfw = (time ge 1.99995e-08) * (time lt 3.99995e-08)
let mf_n = mean(mfw) * mf_l
let mfs = mf_l / mf_n
let mf_prail = mean(v(vdd) * (0 - i(vdd)) * mfw) * mfs
let mfph = 2 * pi * 18450000000.0 * (time - 2e-08)
let mf_lodiff_re = 2 * mean((v(lo_p)-v(lo_n)) * mfw * cos(mfph)) * mfs
let mf_lodiff_im = 2 * mean((v(lo_p)-v(lo_n)) * mfw * sin(mfph)) * mfs
let mfph = 2 * pi * 1000000000.0 * (time - 2e-08)
let mf_if_re = 2 * mean((v(if_out)) * mfw * cos(mfph)) * mfs
let mf_if_im = 2 * mean((v(if_out)) * mfw * sin(mfph)) * mfs
let mfph = 2 * pi * 18450000000.0 * (time - 2e-08)
let mf_loif_re = 2 * mean((v(if_out)) * mfw * cos(mfph)) * mfs
let mf_loif_im = 2 * mean((v(if_out)) * mfw * sin(mfph)) * mfs
let mfph = 2 * pi * 18450000000.0 * (time - 2e-08)
let mf_lorf_re = 2 * mean((v(rf_port)) * mfw * cos(mfph)) * mfs
let mf_lorf_im = 2 * mean((v(rf_port)) * mfw * sin(mfph)) * mfs
let mfph = 2 * pi * 950000000.0 * (time - 2e-08)
let mf_flifa_re = 2 * mean((v(if_out)) * mfw * cos(mfph)) * mfs
let mf_flifa_im = 2 * mean((v(if_out)) * mfw * sin(mfph)) * mfs
let mfph = 2 * pi * 1050000000.0 * (time - 2e-08)
let mf_flifb_re = 2 * mean((v(if_out)) * mfw * cos(mfph)) * mfs
let mf_flifb_im = 2 * mean((v(if_out)) * mfw * sin(mfph)) * mfs
let mfph = 2 * pi * 18500000000.0 * (time - 2e-08)
let mf_fllorf_re = 2 * mean((v(rf_port)) * mfw * cos(mfph)) * mfs
let mf_fllorf_im = 2 * mean((v(rf_port)) * mfw * sin(mfph)) * mfs
let mfph = 2 * pi * 18500000000.0 * (time - 2e-08)
let mf_flloif_re = 2 * mean((v(if_out)) * mfw * cos(mfph)) * mfs
let mf_flloif_im = 2 * mean((v(if_out)) * mfw * sin(mfph)) * mfs
print mf_l
print mf_n
print mf_prail
print mf_lodiff_re
print mf_lodiff_im
print mf_if_re
print mf_if_im
print mf_loif_re
print mf_loif_im
print mf_lorf_re
print mf_lorf_im
print mf_flifa_re
print mf_flifa_im
print mf_flifb_re
print mf_flifb_im
print mf_fllorf_re
print mf_fllorf_im
print mf_flloif_re
print mf_flloif_im
destroy all
echo "MFEND ls_f19p45_m21_rf66"
echo "MFRUN ls_f19p45_m18_rf60"
alterparam f1 = 19450000000.0
alterparam f2 = 19450000000.0
alterparam flo = 18450000000.0
alterparam vrf1 = 0.0006324555320336759
alterparam vrf2 = 0.0
alterparam vlo = 0.11260171197494694
reset
op
let mf_dcirail = 0 - i(vdd)
let mf_dc_vce_q1 = v(c_q1)-v(e_q1)
let mf_dc_vbe_q1 = v(b_q1)-v(e_q1)
let mf_dc_ic_q1 = i(vic_q1)
let mf_dc_vce_q2 = v(c_q2)-v(e_q2)
let mf_dc_vbe_q2 = v(b_q2)-v(e_q2)
let mf_dc_ic_q2 = i(vic_q2)
let mf_dc_vce_q3 = v(c_q3)-v(x1)
let mf_dc_vbe_q3 = v(lo_p)-v(x1)
let mf_dc_ic_q3 = i(vic_q3)
let mf_dc_vce_q4 = v(c_q4)-v(x1)
let mf_dc_vbe_q4 = v(lo_n)-v(x1)
let mf_dc_ic_q4 = i(vic_q4)
let mf_dc_vce_q5 = v(c_q5)-v(x2)
let mf_dc_vbe_q5 = v(lo_p)-v(x2)
let mf_dc_ic_q5 = i(vic_q5)
let mf_dc_vce_q6 = v(c_q6)-v(x2)
let mf_dc_vbe_q6 = v(lo_n)-v(x2)
let mf_dc_ic_q6 = i(vic_q6)
let mf_dc_sink_tail = v(tail)
print mf_dcirail
print mf_dc_vce_q1
print mf_dc_vbe_q1
print mf_dc_ic_q1
print mf_dc_vce_q2
print mf_dc_vbe_q2
print mf_dc_ic_q2
print mf_dc_vce_q3
print mf_dc_vbe_q3
print mf_dc_ic_q3
print mf_dc_vce_q4
print mf_dc_vbe_q4
print mf_dc_ic_q4
print mf_dc_vce_q5
print mf_dc_vbe_q5
print mf_dc_ic_q5
print mf_dc_vce_q6
print mf_dc_vbe_q6
print mf_dc_ic_q6
print mf_dc_sink_tail
tran 1e-12 4e-08 0 1e-12
let mfq_vce_q1 = v(c_q1)-v(e_q1)
meas tran mf_su_vcemax_q1 MAX mfq_vce_q1 from=0.0 to=2e-08
meas tran mf_su_vcemin_q1 MIN mfq_vce_q1 from=0.0 to=2e-08
meas tran mf_ss_vcemax_q1 MAX mfq_vce_q1 from=2e-08 to=4e-08
meas tran mf_ss_vcemin_q1 MIN mfq_vce_q1 from=2e-08 to=4e-08
let mfq_vbe_q1 = v(b_q1)-v(e_q1)
meas tran mf_su_vbemax_q1 MAX mfq_vbe_q1 from=0.0 to=2e-08
meas tran mf_su_vbemin_q1 MIN mfq_vbe_q1 from=0.0 to=2e-08
meas tran mf_ss_vbemax_q1 MAX mfq_vbe_q1 from=2e-08 to=4e-08
meas tran mf_ss_vbemin_q1 MIN mfq_vbe_q1 from=2e-08 to=4e-08
let mfq_ic_q1 = i(vic_q1)
meas tran mf_su_icmax_q1 MAX mfq_ic_q1 from=0.0 to=2e-08
meas tran mf_su_icmin_q1 MIN mfq_ic_q1 from=0.0 to=2e-08
meas tran mf_ss_icmax_q1 MAX mfq_ic_q1 from=2e-08 to=4e-08
meas tran mf_ss_icmin_q1 MIN mfq_ic_q1 from=2e-08 to=4e-08
let mfq_vce_q2 = v(c_q2)-v(e_q2)
meas tran mf_su_vcemax_q2 MAX mfq_vce_q2 from=0.0 to=2e-08
meas tran mf_su_vcemin_q2 MIN mfq_vce_q2 from=0.0 to=2e-08
meas tran mf_ss_vcemax_q2 MAX mfq_vce_q2 from=2e-08 to=4e-08
meas tran mf_ss_vcemin_q2 MIN mfq_vce_q2 from=2e-08 to=4e-08
let mfq_vbe_q2 = v(b_q2)-v(e_q2)
meas tran mf_su_vbemax_q2 MAX mfq_vbe_q2 from=0.0 to=2e-08
meas tran mf_su_vbemin_q2 MIN mfq_vbe_q2 from=0.0 to=2e-08
meas tran mf_ss_vbemax_q2 MAX mfq_vbe_q2 from=2e-08 to=4e-08
meas tran mf_ss_vbemin_q2 MIN mfq_vbe_q2 from=2e-08 to=4e-08
let mfq_ic_q2 = i(vic_q2)
meas tran mf_su_icmax_q2 MAX mfq_ic_q2 from=0.0 to=2e-08
meas tran mf_su_icmin_q2 MIN mfq_ic_q2 from=0.0 to=2e-08
meas tran mf_ss_icmax_q2 MAX mfq_ic_q2 from=2e-08 to=4e-08
meas tran mf_ss_icmin_q2 MIN mfq_ic_q2 from=2e-08 to=4e-08
let mfq_vce_q3 = v(c_q3)-v(x1)
meas tran mf_su_vcemax_q3 MAX mfq_vce_q3 from=0.0 to=2e-08
meas tran mf_su_vcemin_q3 MIN mfq_vce_q3 from=0.0 to=2e-08
meas tran mf_ss_vcemax_q3 MAX mfq_vce_q3 from=2e-08 to=4e-08
meas tran mf_ss_vcemin_q3 MIN mfq_vce_q3 from=2e-08 to=4e-08
let mfq_vbe_q3 = v(lo_p)-v(x1)
meas tran mf_su_vbemax_q3 MAX mfq_vbe_q3 from=0.0 to=2e-08
meas tran mf_su_vbemin_q3 MIN mfq_vbe_q3 from=0.0 to=2e-08
meas tran mf_ss_vbemax_q3 MAX mfq_vbe_q3 from=2e-08 to=4e-08
meas tran mf_ss_vbemin_q3 MIN mfq_vbe_q3 from=2e-08 to=4e-08
let mfq_ic_q3 = i(vic_q3)
meas tran mf_su_icmax_q3 MAX mfq_ic_q3 from=0.0 to=2e-08
meas tran mf_su_icmin_q3 MIN mfq_ic_q3 from=0.0 to=2e-08
meas tran mf_ss_icmax_q3 MAX mfq_ic_q3 from=2e-08 to=4e-08
meas tran mf_ss_icmin_q3 MIN mfq_ic_q3 from=2e-08 to=4e-08
let mfq_vce_q4 = v(c_q4)-v(x1)
meas tran mf_su_vcemax_q4 MAX mfq_vce_q4 from=0.0 to=2e-08
meas tran mf_su_vcemin_q4 MIN mfq_vce_q4 from=0.0 to=2e-08
meas tran mf_ss_vcemax_q4 MAX mfq_vce_q4 from=2e-08 to=4e-08
meas tran mf_ss_vcemin_q4 MIN mfq_vce_q4 from=2e-08 to=4e-08
let mfq_vbe_q4 = v(lo_n)-v(x1)
meas tran mf_su_vbemax_q4 MAX mfq_vbe_q4 from=0.0 to=2e-08
meas tran mf_su_vbemin_q4 MIN mfq_vbe_q4 from=0.0 to=2e-08
meas tran mf_ss_vbemax_q4 MAX mfq_vbe_q4 from=2e-08 to=4e-08
meas tran mf_ss_vbemin_q4 MIN mfq_vbe_q4 from=2e-08 to=4e-08
let mfq_ic_q4 = i(vic_q4)
meas tran mf_su_icmax_q4 MAX mfq_ic_q4 from=0.0 to=2e-08
meas tran mf_su_icmin_q4 MIN mfq_ic_q4 from=0.0 to=2e-08
meas tran mf_ss_icmax_q4 MAX mfq_ic_q4 from=2e-08 to=4e-08
meas tran mf_ss_icmin_q4 MIN mfq_ic_q4 from=2e-08 to=4e-08
let mfq_vce_q5 = v(c_q5)-v(x2)
meas tran mf_su_vcemax_q5 MAX mfq_vce_q5 from=0.0 to=2e-08
meas tran mf_su_vcemin_q5 MIN mfq_vce_q5 from=0.0 to=2e-08
meas tran mf_ss_vcemax_q5 MAX mfq_vce_q5 from=2e-08 to=4e-08
meas tran mf_ss_vcemin_q5 MIN mfq_vce_q5 from=2e-08 to=4e-08
let mfq_vbe_q5 = v(lo_p)-v(x2)
meas tran mf_su_vbemax_q5 MAX mfq_vbe_q5 from=0.0 to=2e-08
meas tran mf_su_vbemin_q5 MIN mfq_vbe_q5 from=0.0 to=2e-08
meas tran mf_ss_vbemax_q5 MAX mfq_vbe_q5 from=2e-08 to=4e-08
meas tran mf_ss_vbemin_q5 MIN mfq_vbe_q5 from=2e-08 to=4e-08
let mfq_ic_q5 = i(vic_q5)
meas tran mf_su_icmax_q5 MAX mfq_ic_q5 from=0.0 to=2e-08
meas tran mf_su_icmin_q5 MIN mfq_ic_q5 from=0.0 to=2e-08
meas tran mf_ss_icmax_q5 MAX mfq_ic_q5 from=2e-08 to=4e-08
meas tran mf_ss_icmin_q5 MIN mfq_ic_q5 from=2e-08 to=4e-08
let mfq_vce_q6 = v(c_q6)-v(x2)
meas tran mf_su_vcemax_q6 MAX mfq_vce_q6 from=0.0 to=2e-08
meas tran mf_su_vcemin_q6 MIN mfq_vce_q6 from=0.0 to=2e-08
meas tran mf_ss_vcemax_q6 MAX mfq_vce_q6 from=2e-08 to=4e-08
meas tran mf_ss_vcemin_q6 MIN mfq_vce_q6 from=2e-08 to=4e-08
let mfq_vbe_q6 = v(lo_n)-v(x2)
meas tran mf_su_vbemax_q6 MAX mfq_vbe_q6 from=0.0 to=2e-08
meas tran mf_su_vbemin_q6 MIN mfq_vbe_q6 from=0.0 to=2e-08
meas tran mf_ss_vbemax_q6 MAX mfq_vbe_q6 from=2e-08 to=4e-08
meas tran mf_ss_vbemin_q6 MIN mfq_vbe_q6 from=2e-08 to=4e-08
let mfq_ic_q6 = i(vic_q6)
meas tran mf_su_icmax_q6 MAX mfq_ic_q6 from=0.0 to=2e-08
meas tran mf_su_icmin_q6 MIN mfq_ic_q6 from=0.0 to=2e-08
meas tran mf_ss_icmax_q6 MAX mfq_ic_q6 from=2e-08 to=4e-08
meas tran mf_ss_icmin_q6 MIN mfq_ic_q6 from=2e-08 to=4e-08
meas tran mf_su_sinkmin_tail MIN v(tail) from=0.0 to=2e-08
meas tran mf_ss_sinkmin_tail MIN v(tail) from=2e-08 to=4e-08
print mf_su_vcemax_q1
print mf_su_vcemin_q1
print mf_ss_vcemax_q1
print mf_ss_vcemin_q1
print mf_su_vbemax_q1
print mf_su_vbemin_q1
print mf_ss_vbemax_q1
print mf_ss_vbemin_q1
print mf_su_icmax_q1
print mf_su_icmin_q1
print mf_ss_icmax_q1
print mf_ss_icmin_q1
print mf_su_vcemax_q2
print mf_su_vcemin_q2
print mf_ss_vcemax_q2
print mf_ss_vcemin_q2
print mf_su_vbemax_q2
print mf_su_vbemin_q2
print mf_ss_vbemax_q2
print mf_ss_vbemin_q2
print mf_su_icmax_q2
print mf_su_icmin_q2
print mf_ss_icmax_q2
print mf_ss_icmin_q2
print mf_su_vcemax_q3
print mf_su_vcemin_q3
print mf_ss_vcemax_q3
print mf_ss_vcemin_q3
print mf_su_vbemax_q3
print mf_su_vbemin_q3
print mf_ss_vbemax_q3
print mf_ss_vbemin_q3
print mf_su_icmax_q3
print mf_su_icmin_q3
print mf_ss_icmax_q3
print mf_ss_icmin_q3
print mf_su_vcemax_q4
print mf_su_vcemin_q4
print mf_ss_vcemax_q4
print mf_ss_vcemin_q4
print mf_su_vbemax_q4
print mf_su_vbemin_q4
print mf_ss_vbemax_q4
print mf_ss_vbemin_q4
print mf_su_icmax_q4
print mf_su_icmin_q4
print mf_ss_icmax_q4
print mf_ss_icmin_q4
print mf_su_vcemax_q5
print mf_su_vcemin_q5
print mf_ss_vcemax_q5
print mf_ss_vcemin_q5
print mf_su_vbemax_q5
print mf_su_vbemin_q5
print mf_ss_vbemax_q5
print mf_ss_vbemin_q5
print mf_su_icmax_q5
print mf_su_icmin_q5
print mf_ss_icmax_q5
print mf_ss_icmin_q5
print mf_su_vcemax_q6
print mf_su_vcemin_q6
print mf_ss_vcemax_q6
print mf_ss_vcemin_q6
print mf_su_vbemax_q6
print mf_su_vbemin_q6
print mf_ss_vbemax_q6
print mf_ss_vbemin_q6
print mf_su_icmax_q6
print mf_su_icmin_q6
print mf_ss_icmax_q6
print mf_ss_icmin_q6
print mf_su_sinkmin_tail
print mf_ss_sinkmin_tail
linearize
let mf_l = length(time)
let mfw = (time ge 1.99995e-08) * (time lt 3.99995e-08)
let mf_n = mean(mfw) * mf_l
let mfs = mf_l / mf_n
let mf_prail = mean(v(vdd) * (0 - i(vdd)) * mfw) * mfs
let mfph = 2 * pi * 18450000000.0 * (time - 2e-08)
let mf_lodiff_re = 2 * mean((v(lo_p)-v(lo_n)) * mfw * cos(mfph)) * mfs
let mf_lodiff_im = 2 * mean((v(lo_p)-v(lo_n)) * mfw * sin(mfph)) * mfs
let mfph = 2 * pi * 1000000000.0 * (time - 2e-08)
let mf_if_re = 2 * mean((v(if_out)) * mfw * cos(mfph)) * mfs
let mf_if_im = 2 * mean((v(if_out)) * mfw * sin(mfph)) * mfs
let mfph = 2 * pi * 18450000000.0 * (time - 2e-08)
let mf_loif_re = 2 * mean((v(if_out)) * mfw * cos(mfph)) * mfs
let mf_loif_im = 2 * mean((v(if_out)) * mfw * sin(mfph)) * mfs
let mfph = 2 * pi * 18450000000.0 * (time - 2e-08)
let mf_lorf_re = 2 * mean((v(rf_port)) * mfw * cos(mfph)) * mfs
let mf_lorf_im = 2 * mean((v(rf_port)) * mfw * sin(mfph)) * mfs
let mfph = 2 * pi * 950000000.0 * (time - 2e-08)
let mf_flifa_re = 2 * mean((v(if_out)) * mfw * cos(mfph)) * mfs
let mf_flifa_im = 2 * mean((v(if_out)) * mfw * sin(mfph)) * mfs
let mfph = 2 * pi * 1050000000.0 * (time - 2e-08)
let mf_flifb_re = 2 * mean((v(if_out)) * mfw * cos(mfph)) * mfs
let mf_flifb_im = 2 * mean((v(if_out)) * mfw * sin(mfph)) * mfs
let mfph = 2 * pi * 18500000000.0 * (time - 2e-08)
let mf_fllorf_re = 2 * mean((v(rf_port)) * mfw * cos(mfph)) * mfs
let mf_fllorf_im = 2 * mean((v(rf_port)) * mfw * sin(mfph)) * mfs
let mfph = 2 * pi * 18500000000.0 * (time - 2e-08)
let mf_flloif_re = 2 * mean((v(if_out)) * mfw * cos(mfph)) * mfs
let mf_flloif_im = 2 * mean((v(if_out)) * mfw * sin(mfph)) * mfs
print mf_l
print mf_n
print mf_prail
print mf_lodiff_re
print mf_lodiff_im
print mf_if_re
print mf_if_im
print mf_loif_re
print mf_loif_im
print mf_lorf_re
print mf_lorf_im
print mf_flifa_re
print mf_flifa_im
print mf_flifb_re
print mf_flifb_im
print mf_fllorf_re
print mf_fllorf_im
print mf_flloif_re
print mf_flloif_im
destroy all
echo "MFEND ls_f19p45_m18_rf60"
echo "MFRUN ls_f19p45_m18_rf66"
alterparam f1 = 19450000000.0
alterparam f2 = 19450000000.0
alterparam flo = 18450000000.0
alterparam vrf1 = 0.00031697863849222284
alterparam vrf2 = 0.0
alterparam vlo = 0.11260171197494694
reset
op
let mf_dcirail = 0 - i(vdd)
let mf_dc_vce_q1 = v(c_q1)-v(e_q1)
let mf_dc_vbe_q1 = v(b_q1)-v(e_q1)
let mf_dc_ic_q1 = i(vic_q1)
let mf_dc_vce_q2 = v(c_q2)-v(e_q2)
let mf_dc_vbe_q2 = v(b_q2)-v(e_q2)
let mf_dc_ic_q2 = i(vic_q2)
let mf_dc_vce_q3 = v(c_q3)-v(x1)
let mf_dc_vbe_q3 = v(lo_p)-v(x1)
let mf_dc_ic_q3 = i(vic_q3)
let mf_dc_vce_q4 = v(c_q4)-v(x1)
let mf_dc_vbe_q4 = v(lo_n)-v(x1)
let mf_dc_ic_q4 = i(vic_q4)
let mf_dc_vce_q5 = v(c_q5)-v(x2)
let mf_dc_vbe_q5 = v(lo_p)-v(x2)
let mf_dc_ic_q5 = i(vic_q5)
let mf_dc_vce_q6 = v(c_q6)-v(x2)
let mf_dc_vbe_q6 = v(lo_n)-v(x2)
let mf_dc_ic_q6 = i(vic_q6)
let mf_dc_sink_tail = v(tail)
print mf_dcirail
print mf_dc_vce_q1
print mf_dc_vbe_q1
print mf_dc_ic_q1
print mf_dc_vce_q2
print mf_dc_vbe_q2
print mf_dc_ic_q2
print mf_dc_vce_q3
print mf_dc_vbe_q3
print mf_dc_ic_q3
print mf_dc_vce_q4
print mf_dc_vbe_q4
print mf_dc_ic_q4
print mf_dc_vce_q5
print mf_dc_vbe_q5
print mf_dc_ic_q5
print mf_dc_vce_q6
print mf_dc_vbe_q6
print mf_dc_ic_q6
print mf_dc_sink_tail
tran 1e-12 4e-08 0 1e-12
let mfq_vce_q1 = v(c_q1)-v(e_q1)
meas tran mf_su_vcemax_q1 MAX mfq_vce_q1 from=0.0 to=2e-08
meas tran mf_su_vcemin_q1 MIN mfq_vce_q1 from=0.0 to=2e-08
meas tran mf_ss_vcemax_q1 MAX mfq_vce_q1 from=2e-08 to=4e-08
meas tran mf_ss_vcemin_q1 MIN mfq_vce_q1 from=2e-08 to=4e-08
let mfq_vbe_q1 = v(b_q1)-v(e_q1)
meas tran mf_su_vbemax_q1 MAX mfq_vbe_q1 from=0.0 to=2e-08
meas tran mf_su_vbemin_q1 MIN mfq_vbe_q1 from=0.0 to=2e-08
meas tran mf_ss_vbemax_q1 MAX mfq_vbe_q1 from=2e-08 to=4e-08
meas tran mf_ss_vbemin_q1 MIN mfq_vbe_q1 from=2e-08 to=4e-08
let mfq_ic_q1 = i(vic_q1)
meas tran mf_su_icmax_q1 MAX mfq_ic_q1 from=0.0 to=2e-08
meas tran mf_su_icmin_q1 MIN mfq_ic_q1 from=0.0 to=2e-08
meas tran mf_ss_icmax_q1 MAX mfq_ic_q1 from=2e-08 to=4e-08
meas tran mf_ss_icmin_q1 MIN mfq_ic_q1 from=2e-08 to=4e-08
let mfq_vce_q2 = v(c_q2)-v(e_q2)
meas tran mf_su_vcemax_q2 MAX mfq_vce_q2 from=0.0 to=2e-08
meas tran mf_su_vcemin_q2 MIN mfq_vce_q2 from=0.0 to=2e-08
meas tran mf_ss_vcemax_q2 MAX mfq_vce_q2 from=2e-08 to=4e-08
meas tran mf_ss_vcemin_q2 MIN mfq_vce_q2 from=2e-08 to=4e-08
let mfq_vbe_q2 = v(b_q2)-v(e_q2)
meas tran mf_su_vbemax_q2 MAX mfq_vbe_q2 from=0.0 to=2e-08
meas tran mf_su_vbemin_q2 MIN mfq_vbe_q2 from=0.0 to=2e-08
meas tran mf_ss_vbemax_q2 MAX mfq_vbe_q2 from=2e-08 to=4e-08
meas tran mf_ss_vbemin_q2 MIN mfq_vbe_q2 from=2e-08 to=4e-08
let mfq_ic_q2 = i(vic_q2)
meas tran mf_su_icmax_q2 MAX mfq_ic_q2 from=0.0 to=2e-08
meas tran mf_su_icmin_q2 MIN mfq_ic_q2 from=0.0 to=2e-08
meas tran mf_ss_icmax_q2 MAX mfq_ic_q2 from=2e-08 to=4e-08
meas tran mf_ss_icmin_q2 MIN mfq_ic_q2 from=2e-08 to=4e-08
let mfq_vce_q3 = v(c_q3)-v(x1)
meas tran mf_su_vcemax_q3 MAX mfq_vce_q3 from=0.0 to=2e-08
meas tran mf_su_vcemin_q3 MIN mfq_vce_q3 from=0.0 to=2e-08
meas tran mf_ss_vcemax_q3 MAX mfq_vce_q3 from=2e-08 to=4e-08
meas tran mf_ss_vcemin_q3 MIN mfq_vce_q3 from=2e-08 to=4e-08
let mfq_vbe_q3 = v(lo_p)-v(x1)
meas tran mf_su_vbemax_q3 MAX mfq_vbe_q3 from=0.0 to=2e-08
meas tran mf_su_vbemin_q3 MIN mfq_vbe_q3 from=0.0 to=2e-08
meas tran mf_ss_vbemax_q3 MAX mfq_vbe_q3 from=2e-08 to=4e-08
meas tran mf_ss_vbemin_q3 MIN mfq_vbe_q3 from=2e-08 to=4e-08
let mfq_ic_q3 = i(vic_q3)
meas tran mf_su_icmax_q3 MAX mfq_ic_q3 from=0.0 to=2e-08
meas tran mf_su_icmin_q3 MIN mfq_ic_q3 from=0.0 to=2e-08
meas tran mf_ss_icmax_q3 MAX mfq_ic_q3 from=2e-08 to=4e-08
meas tran mf_ss_icmin_q3 MIN mfq_ic_q3 from=2e-08 to=4e-08
let mfq_vce_q4 = v(c_q4)-v(x1)
meas tran mf_su_vcemax_q4 MAX mfq_vce_q4 from=0.0 to=2e-08
meas tran mf_su_vcemin_q4 MIN mfq_vce_q4 from=0.0 to=2e-08
meas tran mf_ss_vcemax_q4 MAX mfq_vce_q4 from=2e-08 to=4e-08
meas tran mf_ss_vcemin_q4 MIN mfq_vce_q4 from=2e-08 to=4e-08
let mfq_vbe_q4 = v(lo_n)-v(x1)
meas tran mf_su_vbemax_q4 MAX mfq_vbe_q4 from=0.0 to=2e-08
meas tran mf_su_vbemin_q4 MIN mfq_vbe_q4 from=0.0 to=2e-08
meas tran mf_ss_vbemax_q4 MAX mfq_vbe_q4 from=2e-08 to=4e-08
meas tran mf_ss_vbemin_q4 MIN mfq_vbe_q4 from=2e-08 to=4e-08
let mfq_ic_q4 = i(vic_q4)
meas tran mf_su_icmax_q4 MAX mfq_ic_q4 from=0.0 to=2e-08
meas tran mf_su_icmin_q4 MIN mfq_ic_q4 from=0.0 to=2e-08
meas tran mf_ss_icmax_q4 MAX mfq_ic_q4 from=2e-08 to=4e-08
meas tran mf_ss_icmin_q4 MIN mfq_ic_q4 from=2e-08 to=4e-08
let mfq_vce_q5 = v(c_q5)-v(x2)
meas tran mf_su_vcemax_q5 MAX mfq_vce_q5 from=0.0 to=2e-08
meas tran mf_su_vcemin_q5 MIN mfq_vce_q5 from=0.0 to=2e-08
meas tran mf_ss_vcemax_q5 MAX mfq_vce_q5 from=2e-08 to=4e-08
meas tran mf_ss_vcemin_q5 MIN mfq_vce_q5 from=2e-08 to=4e-08
let mfq_vbe_q5 = v(lo_p)-v(x2)
meas tran mf_su_vbemax_q5 MAX mfq_vbe_q5 from=0.0 to=2e-08
meas tran mf_su_vbemin_q5 MIN mfq_vbe_q5 from=0.0 to=2e-08
meas tran mf_ss_vbemax_q5 MAX mfq_vbe_q5 from=2e-08 to=4e-08
meas tran mf_ss_vbemin_q5 MIN mfq_vbe_q5 from=2e-08 to=4e-08
let mfq_ic_q5 = i(vic_q5)
meas tran mf_su_icmax_q5 MAX mfq_ic_q5 from=0.0 to=2e-08
meas tran mf_su_icmin_q5 MIN mfq_ic_q5 from=0.0 to=2e-08
meas tran mf_ss_icmax_q5 MAX mfq_ic_q5 from=2e-08 to=4e-08
meas tran mf_ss_icmin_q5 MIN mfq_ic_q5 from=2e-08 to=4e-08
let mfq_vce_q6 = v(c_q6)-v(x2)
meas tran mf_su_vcemax_q6 MAX mfq_vce_q6 from=0.0 to=2e-08
meas tran mf_su_vcemin_q6 MIN mfq_vce_q6 from=0.0 to=2e-08
meas tran mf_ss_vcemax_q6 MAX mfq_vce_q6 from=2e-08 to=4e-08
meas tran mf_ss_vcemin_q6 MIN mfq_vce_q6 from=2e-08 to=4e-08
let mfq_vbe_q6 = v(lo_n)-v(x2)
meas tran mf_su_vbemax_q6 MAX mfq_vbe_q6 from=0.0 to=2e-08
meas tran mf_su_vbemin_q6 MIN mfq_vbe_q6 from=0.0 to=2e-08
meas tran mf_ss_vbemax_q6 MAX mfq_vbe_q6 from=2e-08 to=4e-08
meas tran mf_ss_vbemin_q6 MIN mfq_vbe_q6 from=2e-08 to=4e-08
let mfq_ic_q6 = i(vic_q6)
meas tran mf_su_icmax_q6 MAX mfq_ic_q6 from=0.0 to=2e-08
meas tran mf_su_icmin_q6 MIN mfq_ic_q6 from=0.0 to=2e-08
meas tran mf_ss_icmax_q6 MAX mfq_ic_q6 from=2e-08 to=4e-08
meas tran mf_ss_icmin_q6 MIN mfq_ic_q6 from=2e-08 to=4e-08
meas tran mf_su_sinkmin_tail MIN v(tail) from=0.0 to=2e-08
meas tran mf_ss_sinkmin_tail MIN v(tail) from=2e-08 to=4e-08
print mf_su_vcemax_q1
print mf_su_vcemin_q1
print mf_ss_vcemax_q1
print mf_ss_vcemin_q1
print mf_su_vbemax_q1
print mf_su_vbemin_q1
print mf_ss_vbemax_q1
print mf_ss_vbemin_q1
print mf_su_icmax_q1
print mf_su_icmin_q1
print mf_ss_icmax_q1
print mf_ss_icmin_q1
print mf_su_vcemax_q2
print mf_su_vcemin_q2
print mf_ss_vcemax_q2
print mf_ss_vcemin_q2
print mf_su_vbemax_q2
print mf_su_vbemin_q2
print mf_ss_vbemax_q2
print mf_ss_vbemin_q2
print mf_su_icmax_q2
print mf_su_icmin_q2
print mf_ss_icmax_q2
print mf_ss_icmin_q2
print mf_su_vcemax_q3
print mf_su_vcemin_q3
print mf_ss_vcemax_q3
print mf_ss_vcemin_q3
print mf_su_vbemax_q3
print mf_su_vbemin_q3
print mf_ss_vbemax_q3
print mf_ss_vbemin_q3
print mf_su_icmax_q3
print mf_su_icmin_q3
print mf_ss_icmax_q3
print mf_ss_icmin_q3
print mf_su_vcemax_q4
print mf_su_vcemin_q4
print mf_ss_vcemax_q4
print mf_ss_vcemin_q4
print mf_su_vbemax_q4
print mf_su_vbemin_q4
print mf_ss_vbemax_q4
print mf_ss_vbemin_q4
print mf_su_icmax_q4
print mf_su_icmin_q4
print mf_ss_icmax_q4
print mf_ss_icmin_q4
print mf_su_vcemax_q5
print mf_su_vcemin_q5
print mf_ss_vcemax_q5
print mf_ss_vcemin_q5
print mf_su_vbemax_q5
print mf_su_vbemin_q5
print mf_ss_vbemax_q5
print mf_ss_vbemin_q5
print mf_su_icmax_q5
print mf_su_icmin_q5
print mf_ss_icmax_q5
print mf_ss_icmin_q5
print mf_su_vcemax_q6
print mf_su_vcemin_q6
print mf_ss_vcemax_q6
print mf_ss_vcemin_q6
print mf_su_vbemax_q6
print mf_su_vbemin_q6
print mf_ss_vbemax_q6
print mf_ss_vbemin_q6
print mf_su_icmax_q6
print mf_su_icmin_q6
print mf_ss_icmax_q6
print mf_ss_icmin_q6
print mf_su_sinkmin_tail
print mf_ss_sinkmin_tail
linearize
let mf_l = length(time)
let mfw = (time ge 1.99995e-08) * (time lt 3.99995e-08)
let mf_n = mean(mfw) * mf_l
let mfs = mf_l / mf_n
let mf_prail = mean(v(vdd) * (0 - i(vdd)) * mfw) * mfs
let mfph = 2 * pi * 18450000000.0 * (time - 2e-08)
let mf_lodiff_re = 2 * mean((v(lo_p)-v(lo_n)) * mfw * cos(mfph)) * mfs
let mf_lodiff_im = 2 * mean((v(lo_p)-v(lo_n)) * mfw * sin(mfph)) * mfs
let mfph = 2 * pi * 1000000000.0 * (time - 2e-08)
let mf_if_re = 2 * mean((v(if_out)) * mfw * cos(mfph)) * mfs
let mf_if_im = 2 * mean((v(if_out)) * mfw * sin(mfph)) * mfs
let mfph = 2 * pi * 18450000000.0 * (time - 2e-08)
let mf_loif_re = 2 * mean((v(if_out)) * mfw * cos(mfph)) * mfs
let mf_loif_im = 2 * mean((v(if_out)) * mfw * sin(mfph)) * mfs
let mfph = 2 * pi * 18450000000.0 * (time - 2e-08)
let mf_lorf_re = 2 * mean((v(rf_port)) * mfw * cos(mfph)) * mfs
let mf_lorf_im = 2 * mean((v(rf_port)) * mfw * sin(mfph)) * mfs
let mfph = 2 * pi * 950000000.0 * (time - 2e-08)
let mf_flifa_re = 2 * mean((v(if_out)) * mfw * cos(mfph)) * mfs
let mf_flifa_im = 2 * mean((v(if_out)) * mfw * sin(mfph)) * mfs
let mfph = 2 * pi * 1050000000.0 * (time - 2e-08)
let mf_flifb_re = 2 * mean((v(if_out)) * mfw * cos(mfph)) * mfs
let mf_flifb_im = 2 * mean((v(if_out)) * mfw * sin(mfph)) * mfs
let mfph = 2 * pi * 18500000000.0 * (time - 2e-08)
let mf_fllorf_re = 2 * mean((v(rf_port)) * mfw * cos(mfph)) * mfs
let mf_fllorf_im = 2 * mean((v(rf_port)) * mfw * sin(mfph)) * mfs
let mfph = 2 * pi * 18500000000.0 * (time - 2e-08)
let mf_flloif_re = 2 * mean((v(if_out)) * mfw * cos(mfph)) * mfs
let mf_flloif_im = 2 * mean((v(if_out)) * mfw * sin(mfph)) * mfs
print mf_l
print mf_n
print mf_prail
print mf_lodiff_re
print mf_lodiff_im
print mf_if_re
print mf_if_im
print mf_loif_re
print mf_loif_im
print mf_lorf_re
print mf_lorf_im
print mf_flifa_re
print mf_flifa_im
print mf_flifb_re
print mf_flifb_im
print mf_fllorf_re
print mf_fllorf_im
print mf_flloif_re
print mf_flloif_im
destroy all
echo "MFEND ls_f19p45_m18_rf66"
echo "MFRUN ls_f19p45_m15_rf60"
alterparam f1 = 19450000000.0
alterparam f2 = 19450000000.0
alterparam flo = 18450000000.0
alterparam vrf1 = 0.0006324555320336759
alterparam vrf2 = 0.0
alterparam vlo = 0.15905414575341015
reset
op
let mf_dcirail = 0 - i(vdd)
let mf_dc_vce_q1 = v(c_q1)-v(e_q1)
let mf_dc_vbe_q1 = v(b_q1)-v(e_q1)
let mf_dc_ic_q1 = i(vic_q1)
let mf_dc_vce_q2 = v(c_q2)-v(e_q2)
let mf_dc_vbe_q2 = v(b_q2)-v(e_q2)
let mf_dc_ic_q2 = i(vic_q2)
let mf_dc_vce_q3 = v(c_q3)-v(x1)
let mf_dc_vbe_q3 = v(lo_p)-v(x1)
let mf_dc_ic_q3 = i(vic_q3)
let mf_dc_vce_q4 = v(c_q4)-v(x1)
let mf_dc_vbe_q4 = v(lo_n)-v(x1)
let mf_dc_ic_q4 = i(vic_q4)
let mf_dc_vce_q5 = v(c_q5)-v(x2)
let mf_dc_vbe_q5 = v(lo_p)-v(x2)
let mf_dc_ic_q5 = i(vic_q5)
let mf_dc_vce_q6 = v(c_q6)-v(x2)
let mf_dc_vbe_q6 = v(lo_n)-v(x2)
let mf_dc_ic_q6 = i(vic_q6)
let mf_dc_sink_tail = v(tail)
print mf_dcirail
print mf_dc_vce_q1
print mf_dc_vbe_q1
print mf_dc_ic_q1
print mf_dc_vce_q2
print mf_dc_vbe_q2
print mf_dc_ic_q2
print mf_dc_vce_q3
print mf_dc_vbe_q3
print mf_dc_ic_q3
print mf_dc_vce_q4
print mf_dc_vbe_q4
print mf_dc_ic_q4
print mf_dc_vce_q5
print mf_dc_vbe_q5
print mf_dc_ic_q5
print mf_dc_vce_q6
print mf_dc_vbe_q6
print mf_dc_ic_q6
print mf_dc_sink_tail
tran 1e-12 4e-08 0 1e-12
let mfq_vce_q1 = v(c_q1)-v(e_q1)
meas tran mf_su_vcemax_q1 MAX mfq_vce_q1 from=0.0 to=2e-08
meas tran mf_su_vcemin_q1 MIN mfq_vce_q1 from=0.0 to=2e-08
meas tran mf_ss_vcemax_q1 MAX mfq_vce_q1 from=2e-08 to=4e-08
meas tran mf_ss_vcemin_q1 MIN mfq_vce_q1 from=2e-08 to=4e-08
let mfq_vbe_q1 = v(b_q1)-v(e_q1)
meas tran mf_su_vbemax_q1 MAX mfq_vbe_q1 from=0.0 to=2e-08
meas tran mf_su_vbemin_q1 MIN mfq_vbe_q1 from=0.0 to=2e-08
meas tran mf_ss_vbemax_q1 MAX mfq_vbe_q1 from=2e-08 to=4e-08
meas tran mf_ss_vbemin_q1 MIN mfq_vbe_q1 from=2e-08 to=4e-08
let mfq_ic_q1 = i(vic_q1)
meas tran mf_su_icmax_q1 MAX mfq_ic_q1 from=0.0 to=2e-08
meas tran mf_su_icmin_q1 MIN mfq_ic_q1 from=0.0 to=2e-08
meas tran mf_ss_icmax_q1 MAX mfq_ic_q1 from=2e-08 to=4e-08
meas tran mf_ss_icmin_q1 MIN mfq_ic_q1 from=2e-08 to=4e-08
let mfq_vce_q2 = v(c_q2)-v(e_q2)
meas tran mf_su_vcemax_q2 MAX mfq_vce_q2 from=0.0 to=2e-08
meas tran mf_su_vcemin_q2 MIN mfq_vce_q2 from=0.0 to=2e-08
meas tran mf_ss_vcemax_q2 MAX mfq_vce_q2 from=2e-08 to=4e-08
meas tran mf_ss_vcemin_q2 MIN mfq_vce_q2 from=2e-08 to=4e-08
let mfq_vbe_q2 = v(b_q2)-v(e_q2)
meas tran mf_su_vbemax_q2 MAX mfq_vbe_q2 from=0.0 to=2e-08
meas tran mf_su_vbemin_q2 MIN mfq_vbe_q2 from=0.0 to=2e-08
meas tran mf_ss_vbemax_q2 MAX mfq_vbe_q2 from=2e-08 to=4e-08
meas tran mf_ss_vbemin_q2 MIN mfq_vbe_q2 from=2e-08 to=4e-08
let mfq_ic_q2 = i(vic_q2)
meas tran mf_su_icmax_q2 MAX mfq_ic_q2 from=0.0 to=2e-08
meas tran mf_su_icmin_q2 MIN mfq_ic_q2 from=0.0 to=2e-08
meas tran mf_ss_icmax_q2 MAX mfq_ic_q2 from=2e-08 to=4e-08
meas tran mf_ss_icmin_q2 MIN mfq_ic_q2 from=2e-08 to=4e-08
let mfq_vce_q3 = v(c_q3)-v(x1)
meas tran mf_su_vcemax_q3 MAX mfq_vce_q3 from=0.0 to=2e-08
meas tran mf_su_vcemin_q3 MIN mfq_vce_q3 from=0.0 to=2e-08
meas tran mf_ss_vcemax_q3 MAX mfq_vce_q3 from=2e-08 to=4e-08
meas tran mf_ss_vcemin_q3 MIN mfq_vce_q3 from=2e-08 to=4e-08
let mfq_vbe_q3 = v(lo_p)-v(x1)
meas tran mf_su_vbemax_q3 MAX mfq_vbe_q3 from=0.0 to=2e-08
meas tran mf_su_vbemin_q3 MIN mfq_vbe_q3 from=0.0 to=2e-08
meas tran mf_ss_vbemax_q3 MAX mfq_vbe_q3 from=2e-08 to=4e-08
meas tran mf_ss_vbemin_q3 MIN mfq_vbe_q3 from=2e-08 to=4e-08
let mfq_ic_q3 = i(vic_q3)
meas tran mf_su_icmax_q3 MAX mfq_ic_q3 from=0.0 to=2e-08
meas tran mf_su_icmin_q3 MIN mfq_ic_q3 from=0.0 to=2e-08
meas tran mf_ss_icmax_q3 MAX mfq_ic_q3 from=2e-08 to=4e-08
meas tran mf_ss_icmin_q3 MIN mfq_ic_q3 from=2e-08 to=4e-08
let mfq_vce_q4 = v(c_q4)-v(x1)
meas tran mf_su_vcemax_q4 MAX mfq_vce_q4 from=0.0 to=2e-08
meas tran mf_su_vcemin_q4 MIN mfq_vce_q4 from=0.0 to=2e-08
meas tran mf_ss_vcemax_q4 MAX mfq_vce_q4 from=2e-08 to=4e-08
meas tran mf_ss_vcemin_q4 MIN mfq_vce_q4 from=2e-08 to=4e-08
let mfq_vbe_q4 = v(lo_n)-v(x1)
meas tran mf_su_vbemax_q4 MAX mfq_vbe_q4 from=0.0 to=2e-08
meas tran mf_su_vbemin_q4 MIN mfq_vbe_q4 from=0.0 to=2e-08
meas tran mf_ss_vbemax_q4 MAX mfq_vbe_q4 from=2e-08 to=4e-08
meas tran mf_ss_vbemin_q4 MIN mfq_vbe_q4 from=2e-08 to=4e-08
let mfq_ic_q4 = i(vic_q4)
meas tran mf_su_icmax_q4 MAX mfq_ic_q4 from=0.0 to=2e-08
meas tran mf_su_icmin_q4 MIN mfq_ic_q4 from=0.0 to=2e-08
meas tran mf_ss_icmax_q4 MAX mfq_ic_q4 from=2e-08 to=4e-08
meas tran mf_ss_icmin_q4 MIN mfq_ic_q4 from=2e-08 to=4e-08
let mfq_vce_q5 = v(c_q5)-v(x2)
meas tran mf_su_vcemax_q5 MAX mfq_vce_q5 from=0.0 to=2e-08
meas tran mf_su_vcemin_q5 MIN mfq_vce_q5 from=0.0 to=2e-08
meas tran mf_ss_vcemax_q5 MAX mfq_vce_q5 from=2e-08 to=4e-08
meas tran mf_ss_vcemin_q5 MIN mfq_vce_q5 from=2e-08 to=4e-08
let mfq_vbe_q5 = v(lo_p)-v(x2)
meas tran mf_su_vbemax_q5 MAX mfq_vbe_q5 from=0.0 to=2e-08
meas tran mf_su_vbemin_q5 MIN mfq_vbe_q5 from=0.0 to=2e-08
meas tran mf_ss_vbemax_q5 MAX mfq_vbe_q5 from=2e-08 to=4e-08
meas tran mf_ss_vbemin_q5 MIN mfq_vbe_q5 from=2e-08 to=4e-08
let mfq_ic_q5 = i(vic_q5)
meas tran mf_su_icmax_q5 MAX mfq_ic_q5 from=0.0 to=2e-08
meas tran mf_su_icmin_q5 MIN mfq_ic_q5 from=0.0 to=2e-08
meas tran mf_ss_icmax_q5 MAX mfq_ic_q5 from=2e-08 to=4e-08
meas tran mf_ss_icmin_q5 MIN mfq_ic_q5 from=2e-08 to=4e-08
let mfq_vce_q6 = v(c_q6)-v(x2)
meas tran mf_su_vcemax_q6 MAX mfq_vce_q6 from=0.0 to=2e-08
meas tran mf_su_vcemin_q6 MIN mfq_vce_q6 from=0.0 to=2e-08
meas tran mf_ss_vcemax_q6 MAX mfq_vce_q6 from=2e-08 to=4e-08
meas tran mf_ss_vcemin_q6 MIN mfq_vce_q6 from=2e-08 to=4e-08
let mfq_vbe_q6 = v(lo_n)-v(x2)
meas tran mf_su_vbemax_q6 MAX mfq_vbe_q6 from=0.0 to=2e-08
meas tran mf_su_vbemin_q6 MIN mfq_vbe_q6 from=0.0 to=2e-08
meas tran mf_ss_vbemax_q6 MAX mfq_vbe_q6 from=2e-08 to=4e-08
meas tran mf_ss_vbemin_q6 MIN mfq_vbe_q6 from=2e-08 to=4e-08
let mfq_ic_q6 = i(vic_q6)
meas tran mf_su_icmax_q6 MAX mfq_ic_q6 from=0.0 to=2e-08
meas tran mf_su_icmin_q6 MIN mfq_ic_q6 from=0.0 to=2e-08
meas tran mf_ss_icmax_q6 MAX mfq_ic_q6 from=2e-08 to=4e-08
meas tran mf_ss_icmin_q6 MIN mfq_ic_q6 from=2e-08 to=4e-08
meas tran mf_su_sinkmin_tail MIN v(tail) from=0.0 to=2e-08
meas tran mf_ss_sinkmin_tail MIN v(tail) from=2e-08 to=4e-08
print mf_su_vcemax_q1
print mf_su_vcemin_q1
print mf_ss_vcemax_q1
print mf_ss_vcemin_q1
print mf_su_vbemax_q1
print mf_su_vbemin_q1
print mf_ss_vbemax_q1
print mf_ss_vbemin_q1
print mf_su_icmax_q1
print mf_su_icmin_q1
print mf_ss_icmax_q1
print mf_ss_icmin_q1
print mf_su_vcemax_q2
print mf_su_vcemin_q2
print mf_ss_vcemax_q2
print mf_ss_vcemin_q2
print mf_su_vbemax_q2
print mf_su_vbemin_q2
print mf_ss_vbemax_q2
print mf_ss_vbemin_q2
print mf_su_icmax_q2
print mf_su_icmin_q2
print mf_ss_icmax_q2
print mf_ss_icmin_q2
print mf_su_vcemax_q3
print mf_su_vcemin_q3
print mf_ss_vcemax_q3
print mf_ss_vcemin_q3
print mf_su_vbemax_q3
print mf_su_vbemin_q3
print mf_ss_vbemax_q3
print mf_ss_vbemin_q3
print mf_su_icmax_q3
print mf_su_icmin_q3
print mf_ss_icmax_q3
print mf_ss_icmin_q3
print mf_su_vcemax_q4
print mf_su_vcemin_q4
print mf_ss_vcemax_q4
print mf_ss_vcemin_q4
print mf_su_vbemax_q4
print mf_su_vbemin_q4
print mf_ss_vbemax_q4
print mf_ss_vbemin_q4
print mf_su_icmax_q4
print mf_su_icmin_q4
print mf_ss_icmax_q4
print mf_ss_icmin_q4
print mf_su_vcemax_q5
print mf_su_vcemin_q5
print mf_ss_vcemax_q5
print mf_ss_vcemin_q5
print mf_su_vbemax_q5
print mf_su_vbemin_q5
print mf_ss_vbemax_q5
print mf_ss_vbemin_q5
print mf_su_icmax_q5
print mf_su_icmin_q5
print mf_ss_icmax_q5
print mf_ss_icmin_q5
print mf_su_vcemax_q6
print mf_su_vcemin_q6
print mf_ss_vcemax_q6
print mf_ss_vcemin_q6
print mf_su_vbemax_q6
print mf_su_vbemin_q6
print mf_ss_vbemax_q6
print mf_ss_vbemin_q6
print mf_su_icmax_q6
print mf_su_icmin_q6
print mf_ss_icmax_q6
print mf_ss_icmin_q6
print mf_su_sinkmin_tail
print mf_ss_sinkmin_tail
linearize
let mf_l = length(time)
let mfw = (time ge 1.99995e-08) * (time lt 3.99995e-08)
let mf_n = mean(mfw) * mf_l
let mfs = mf_l / mf_n
let mf_prail = mean(v(vdd) * (0 - i(vdd)) * mfw) * mfs
let mfph = 2 * pi * 18450000000.0 * (time - 2e-08)
let mf_lodiff_re = 2 * mean((v(lo_p)-v(lo_n)) * mfw * cos(mfph)) * mfs
let mf_lodiff_im = 2 * mean((v(lo_p)-v(lo_n)) * mfw * sin(mfph)) * mfs
let mfph = 2 * pi * 1000000000.0 * (time - 2e-08)
let mf_if_re = 2 * mean((v(if_out)) * mfw * cos(mfph)) * mfs
let mf_if_im = 2 * mean((v(if_out)) * mfw * sin(mfph)) * mfs
let mfph = 2 * pi * 18450000000.0 * (time - 2e-08)
let mf_loif_re = 2 * mean((v(if_out)) * mfw * cos(mfph)) * mfs
let mf_loif_im = 2 * mean((v(if_out)) * mfw * sin(mfph)) * mfs
let mfph = 2 * pi * 18450000000.0 * (time - 2e-08)
let mf_lorf_re = 2 * mean((v(rf_port)) * mfw * cos(mfph)) * mfs
let mf_lorf_im = 2 * mean((v(rf_port)) * mfw * sin(mfph)) * mfs
let mfph = 2 * pi * 950000000.0 * (time - 2e-08)
let mf_flifa_re = 2 * mean((v(if_out)) * mfw * cos(mfph)) * mfs
let mf_flifa_im = 2 * mean((v(if_out)) * mfw * sin(mfph)) * mfs
let mfph = 2 * pi * 1050000000.0 * (time - 2e-08)
let mf_flifb_re = 2 * mean((v(if_out)) * mfw * cos(mfph)) * mfs
let mf_flifb_im = 2 * mean((v(if_out)) * mfw * sin(mfph)) * mfs
let mfph = 2 * pi * 18500000000.0 * (time - 2e-08)
let mf_fllorf_re = 2 * mean((v(rf_port)) * mfw * cos(mfph)) * mfs
let mf_fllorf_im = 2 * mean((v(rf_port)) * mfw * sin(mfph)) * mfs
let mfph = 2 * pi * 18500000000.0 * (time - 2e-08)
let mf_flloif_re = 2 * mean((v(if_out)) * mfw * cos(mfph)) * mfs
let mf_flloif_im = 2 * mean((v(if_out)) * mfw * sin(mfph)) * mfs
print mf_l
print mf_n
print mf_prail
print mf_lodiff_re
print mf_lodiff_im
print mf_if_re
print mf_if_im
print mf_loif_re
print mf_loif_im
print mf_lorf_re
print mf_lorf_im
print mf_flifa_re
print mf_flifa_im
print mf_flifb_re
print mf_flifb_im
print mf_fllorf_re
print mf_fllorf_im
print mf_flloif_re
print mf_flloif_im
destroy all
echo "MFEND ls_f19p45_m15_rf60"
echo "MFRUN ls_f19p45_m15_rf66"
alterparam f1 = 19450000000.0
alterparam f2 = 19450000000.0
alterparam flo = 18450000000.0
alterparam vrf1 = 0.00031697863849222284
alterparam vrf2 = 0.0
alterparam vlo = 0.15905414575341015
reset
op
let mf_dcirail = 0 - i(vdd)
let mf_dc_vce_q1 = v(c_q1)-v(e_q1)
let mf_dc_vbe_q1 = v(b_q1)-v(e_q1)
let mf_dc_ic_q1 = i(vic_q1)
let mf_dc_vce_q2 = v(c_q2)-v(e_q2)
let mf_dc_vbe_q2 = v(b_q2)-v(e_q2)
let mf_dc_ic_q2 = i(vic_q2)
let mf_dc_vce_q3 = v(c_q3)-v(x1)
let mf_dc_vbe_q3 = v(lo_p)-v(x1)
let mf_dc_ic_q3 = i(vic_q3)
let mf_dc_vce_q4 = v(c_q4)-v(x1)
let mf_dc_vbe_q4 = v(lo_n)-v(x1)
let mf_dc_ic_q4 = i(vic_q4)
let mf_dc_vce_q5 = v(c_q5)-v(x2)
let mf_dc_vbe_q5 = v(lo_p)-v(x2)
let mf_dc_ic_q5 = i(vic_q5)
let mf_dc_vce_q6 = v(c_q6)-v(x2)
let mf_dc_vbe_q6 = v(lo_n)-v(x2)
let mf_dc_ic_q6 = i(vic_q6)
let mf_dc_sink_tail = v(tail)
print mf_dcirail
print mf_dc_vce_q1
print mf_dc_vbe_q1
print mf_dc_ic_q1
print mf_dc_vce_q2
print mf_dc_vbe_q2
print mf_dc_ic_q2
print mf_dc_vce_q3
print mf_dc_vbe_q3
print mf_dc_ic_q3
print mf_dc_vce_q4
print mf_dc_vbe_q4
print mf_dc_ic_q4
print mf_dc_vce_q5
print mf_dc_vbe_q5
print mf_dc_ic_q5
print mf_dc_vce_q6
print mf_dc_vbe_q6
print mf_dc_ic_q6
print mf_dc_sink_tail
tran 1e-12 4e-08 0 1e-12
let mfq_vce_q1 = v(c_q1)-v(e_q1)
meas tran mf_su_vcemax_q1 MAX mfq_vce_q1 from=0.0 to=2e-08
meas tran mf_su_vcemin_q1 MIN mfq_vce_q1 from=0.0 to=2e-08
meas tran mf_ss_vcemax_q1 MAX mfq_vce_q1 from=2e-08 to=4e-08
meas tran mf_ss_vcemin_q1 MIN mfq_vce_q1 from=2e-08 to=4e-08
let mfq_vbe_q1 = v(b_q1)-v(e_q1)
meas tran mf_su_vbemax_q1 MAX mfq_vbe_q1 from=0.0 to=2e-08
meas tran mf_su_vbemin_q1 MIN mfq_vbe_q1 from=0.0 to=2e-08
meas tran mf_ss_vbemax_q1 MAX mfq_vbe_q1 from=2e-08 to=4e-08
meas tran mf_ss_vbemin_q1 MIN mfq_vbe_q1 from=2e-08 to=4e-08
let mfq_ic_q1 = i(vic_q1)
meas tran mf_su_icmax_q1 MAX mfq_ic_q1 from=0.0 to=2e-08
meas tran mf_su_icmin_q1 MIN mfq_ic_q1 from=0.0 to=2e-08
meas tran mf_ss_icmax_q1 MAX mfq_ic_q1 from=2e-08 to=4e-08
meas tran mf_ss_icmin_q1 MIN mfq_ic_q1 from=2e-08 to=4e-08
let mfq_vce_q2 = v(c_q2)-v(e_q2)
meas tran mf_su_vcemax_q2 MAX mfq_vce_q2 from=0.0 to=2e-08
meas tran mf_su_vcemin_q2 MIN mfq_vce_q2 from=0.0 to=2e-08
meas tran mf_ss_vcemax_q2 MAX mfq_vce_q2 from=2e-08 to=4e-08
meas tran mf_ss_vcemin_q2 MIN mfq_vce_q2 from=2e-08 to=4e-08
let mfq_vbe_q2 = v(b_q2)-v(e_q2)
meas tran mf_su_vbemax_q2 MAX mfq_vbe_q2 from=0.0 to=2e-08
meas tran mf_su_vbemin_q2 MIN mfq_vbe_q2 from=0.0 to=2e-08
meas tran mf_ss_vbemax_q2 MAX mfq_vbe_q2 from=2e-08 to=4e-08
meas tran mf_ss_vbemin_q2 MIN mfq_vbe_q2 from=2e-08 to=4e-08
let mfq_ic_q2 = i(vic_q2)
meas tran mf_su_icmax_q2 MAX mfq_ic_q2 from=0.0 to=2e-08
meas tran mf_su_icmin_q2 MIN mfq_ic_q2 from=0.0 to=2e-08
meas tran mf_ss_icmax_q2 MAX mfq_ic_q2 from=2e-08 to=4e-08
meas tran mf_ss_icmin_q2 MIN mfq_ic_q2 from=2e-08 to=4e-08
let mfq_vce_q3 = v(c_q3)-v(x1)
meas tran mf_su_vcemax_q3 MAX mfq_vce_q3 from=0.0 to=2e-08
meas tran mf_su_vcemin_q3 MIN mfq_vce_q3 from=0.0 to=2e-08
meas tran mf_ss_vcemax_q3 MAX mfq_vce_q3 from=2e-08 to=4e-08
meas tran mf_ss_vcemin_q3 MIN mfq_vce_q3 from=2e-08 to=4e-08
let mfq_vbe_q3 = v(lo_p)-v(x1)
meas tran mf_su_vbemax_q3 MAX mfq_vbe_q3 from=0.0 to=2e-08
meas tran mf_su_vbemin_q3 MIN mfq_vbe_q3 from=0.0 to=2e-08
meas tran mf_ss_vbemax_q3 MAX mfq_vbe_q3 from=2e-08 to=4e-08
meas tran mf_ss_vbemin_q3 MIN mfq_vbe_q3 from=2e-08 to=4e-08
let mfq_ic_q3 = i(vic_q3)
meas tran mf_su_icmax_q3 MAX mfq_ic_q3 from=0.0 to=2e-08
meas tran mf_su_icmin_q3 MIN mfq_ic_q3 from=0.0 to=2e-08
meas tran mf_ss_icmax_q3 MAX mfq_ic_q3 from=2e-08 to=4e-08
meas tran mf_ss_icmin_q3 MIN mfq_ic_q3 from=2e-08 to=4e-08
let mfq_vce_q4 = v(c_q4)-v(x1)
meas tran mf_su_vcemax_q4 MAX mfq_vce_q4 from=0.0 to=2e-08
meas tran mf_su_vcemin_q4 MIN mfq_vce_q4 from=0.0 to=2e-08
meas tran mf_ss_vcemax_q4 MAX mfq_vce_q4 from=2e-08 to=4e-08
meas tran mf_ss_vcemin_q4 MIN mfq_vce_q4 from=2e-08 to=4e-08
let mfq_vbe_q4 = v(lo_n)-v(x1)
meas tran mf_su_vbemax_q4 MAX mfq_vbe_q4 from=0.0 to=2e-08
meas tran mf_su_vbemin_q4 MIN mfq_vbe_q4 from=0.0 to=2e-08
meas tran mf_ss_vbemax_q4 MAX mfq_vbe_q4 from=2e-08 to=4e-08
meas tran mf_ss_vbemin_q4 MIN mfq_vbe_q4 from=2e-08 to=4e-08
let mfq_ic_q4 = i(vic_q4)
meas tran mf_su_icmax_q4 MAX mfq_ic_q4 from=0.0 to=2e-08
meas tran mf_su_icmin_q4 MIN mfq_ic_q4 from=0.0 to=2e-08
meas tran mf_ss_icmax_q4 MAX mfq_ic_q4 from=2e-08 to=4e-08
meas tran mf_ss_icmin_q4 MIN mfq_ic_q4 from=2e-08 to=4e-08
let mfq_vce_q5 = v(c_q5)-v(x2)
meas tran mf_su_vcemax_q5 MAX mfq_vce_q5 from=0.0 to=2e-08
meas tran mf_su_vcemin_q5 MIN mfq_vce_q5 from=0.0 to=2e-08
meas tran mf_ss_vcemax_q5 MAX mfq_vce_q5 from=2e-08 to=4e-08
meas tran mf_ss_vcemin_q5 MIN mfq_vce_q5 from=2e-08 to=4e-08
let mfq_vbe_q5 = v(lo_p)-v(x2)
meas tran mf_su_vbemax_q5 MAX mfq_vbe_q5 from=0.0 to=2e-08
meas tran mf_su_vbemin_q5 MIN mfq_vbe_q5 from=0.0 to=2e-08
meas tran mf_ss_vbemax_q5 MAX mfq_vbe_q5 from=2e-08 to=4e-08
meas tran mf_ss_vbemin_q5 MIN mfq_vbe_q5 from=2e-08 to=4e-08
let mfq_ic_q5 = i(vic_q5)
meas tran mf_su_icmax_q5 MAX mfq_ic_q5 from=0.0 to=2e-08
meas tran mf_su_icmin_q5 MIN mfq_ic_q5 from=0.0 to=2e-08
meas tran mf_ss_icmax_q5 MAX mfq_ic_q5 from=2e-08 to=4e-08
meas tran mf_ss_icmin_q5 MIN mfq_ic_q5 from=2e-08 to=4e-08
let mfq_vce_q6 = v(c_q6)-v(x2)
meas tran mf_su_vcemax_q6 MAX mfq_vce_q6 from=0.0 to=2e-08
meas tran mf_su_vcemin_q6 MIN mfq_vce_q6 from=0.0 to=2e-08
meas tran mf_ss_vcemax_q6 MAX mfq_vce_q6 from=2e-08 to=4e-08
meas tran mf_ss_vcemin_q6 MIN mfq_vce_q6 from=2e-08 to=4e-08
let mfq_vbe_q6 = v(lo_n)-v(x2)
meas tran mf_su_vbemax_q6 MAX mfq_vbe_q6 from=0.0 to=2e-08
meas tran mf_su_vbemin_q6 MIN mfq_vbe_q6 from=0.0 to=2e-08
meas tran mf_ss_vbemax_q6 MAX mfq_vbe_q6 from=2e-08 to=4e-08
meas tran mf_ss_vbemin_q6 MIN mfq_vbe_q6 from=2e-08 to=4e-08
let mfq_ic_q6 = i(vic_q6)
meas tran mf_su_icmax_q6 MAX mfq_ic_q6 from=0.0 to=2e-08
meas tran mf_su_icmin_q6 MIN mfq_ic_q6 from=0.0 to=2e-08
meas tran mf_ss_icmax_q6 MAX mfq_ic_q6 from=2e-08 to=4e-08
meas tran mf_ss_icmin_q6 MIN mfq_ic_q6 from=2e-08 to=4e-08
meas tran mf_su_sinkmin_tail MIN v(tail) from=0.0 to=2e-08
meas tran mf_ss_sinkmin_tail MIN v(tail) from=2e-08 to=4e-08
print mf_su_vcemax_q1
print mf_su_vcemin_q1
print mf_ss_vcemax_q1
print mf_ss_vcemin_q1
print mf_su_vbemax_q1
print mf_su_vbemin_q1
print mf_ss_vbemax_q1
print mf_ss_vbemin_q1
print mf_su_icmax_q1
print mf_su_icmin_q1
print mf_ss_icmax_q1
print mf_ss_icmin_q1
print mf_su_vcemax_q2
print mf_su_vcemin_q2
print mf_ss_vcemax_q2
print mf_ss_vcemin_q2
print mf_su_vbemax_q2
print mf_su_vbemin_q2
print mf_ss_vbemax_q2
print mf_ss_vbemin_q2
print mf_su_icmax_q2
print mf_su_icmin_q2
print mf_ss_icmax_q2
print mf_ss_icmin_q2
print mf_su_vcemax_q3
print mf_su_vcemin_q3
print mf_ss_vcemax_q3
print mf_ss_vcemin_q3
print mf_su_vbemax_q3
print mf_su_vbemin_q3
print mf_ss_vbemax_q3
print mf_ss_vbemin_q3
print mf_su_icmax_q3
print mf_su_icmin_q3
print mf_ss_icmax_q3
print mf_ss_icmin_q3
print mf_su_vcemax_q4
print mf_su_vcemin_q4
print mf_ss_vcemax_q4
print mf_ss_vcemin_q4
print mf_su_vbemax_q4
print mf_su_vbemin_q4
print mf_ss_vbemax_q4
print mf_ss_vbemin_q4
print mf_su_icmax_q4
print mf_su_icmin_q4
print mf_ss_icmax_q4
print mf_ss_icmin_q4
print mf_su_vcemax_q5
print mf_su_vcemin_q5
print mf_ss_vcemax_q5
print mf_ss_vcemin_q5
print mf_su_vbemax_q5
print mf_su_vbemin_q5
print mf_ss_vbemax_q5
print mf_ss_vbemin_q5
print mf_su_icmax_q5
print mf_su_icmin_q5
print mf_ss_icmax_q5
print mf_ss_icmin_q5
print mf_su_vcemax_q6
print mf_su_vcemin_q6
print mf_ss_vcemax_q6
print mf_ss_vcemin_q6
print mf_su_vbemax_q6
print mf_su_vbemin_q6
print mf_ss_vbemax_q6
print mf_ss_vbemin_q6
print mf_su_icmax_q6
print mf_su_icmin_q6
print mf_ss_icmax_q6
print mf_ss_icmin_q6
print mf_su_sinkmin_tail
print mf_ss_sinkmin_tail
linearize
let mf_l = length(time)
let mfw = (time ge 1.99995e-08) * (time lt 3.99995e-08)
let mf_n = mean(mfw) * mf_l
let mfs = mf_l / mf_n
let mf_prail = mean(v(vdd) * (0 - i(vdd)) * mfw) * mfs
let mfph = 2 * pi * 18450000000.0 * (time - 2e-08)
let mf_lodiff_re = 2 * mean((v(lo_p)-v(lo_n)) * mfw * cos(mfph)) * mfs
let mf_lodiff_im = 2 * mean((v(lo_p)-v(lo_n)) * mfw * sin(mfph)) * mfs
let mfph = 2 * pi * 1000000000.0 * (time - 2e-08)
let mf_if_re = 2 * mean((v(if_out)) * mfw * cos(mfph)) * mfs
let mf_if_im = 2 * mean((v(if_out)) * mfw * sin(mfph)) * mfs
let mfph = 2 * pi * 18450000000.0 * (time - 2e-08)
let mf_loif_re = 2 * mean((v(if_out)) * mfw * cos(mfph)) * mfs
let mf_loif_im = 2 * mean((v(if_out)) * mfw * sin(mfph)) * mfs
let mfph = 2 * pi * 18450000000.0 * (time - 2e-08)
let mf_lorf_re = 2 * mean((v(rf_port)) * mfw * cos(mfph)) * mfs
let mf_lorf_im = 2 * mean((v(rf_port)) * mfw * sin(mfph)) * mfs
let mfph = 2 * pi * 950000000.0 * (time - 2e-08)
let mf_flifa_re = 2 * mean((v(if_out)) * mfw * cos(mfph)) * mfs
let mf_flifa_im = 2 * mean((v(if_out)) * mfw * sin(mfph)) * mfs
let mfph = 2 * pi * 1050000000.0 * (time - 2e-08)
let mf_flifb_re = 2 * mean((v(if_out)) * mfw * cos(mfph)) * mfs
let mf_flifb_im = 2 * mean((v(if_out)) * mfw * sin(mfph)) * mfs
let mfph = 2 * pi * 18500000000.0 * (time - 2e-08)
let mf_fllorf_re = 2 * mean((v(rf_port)) * mfw * cos(mfph)) * mfs
let mf_fllorf_im = 2 * mean((v(rf_port)) * mfw * sin(mfph)) * mfs
let mfph = 2 * pi * 18500000000.0 * (time - 2e-08)
let mf_flloif_re = 2 * mean((v(if_out)) * mfw * cos(mfph)) * mfs
let mf_flloif_im = 2 * mean((v(if_out)) * mfw * sin(mfph)) * mfs
print mf_l
print mf_n
print mf_prail
print mf_lodiff_re
print mf_lodiff_im
print mf_if_re
print mf_if_im
print mf_loif_re
print mf_loif_im
print mf_lorf_re
print mf_lorf_im
print mf_flifa_re
print mf_flifa_im
print mf_flifb_re
print mf_flifb_im
print mf_fllorf_re
print mf_fllorf_im
print mf_flloif_re
print mf_flloif_im
destroy all
echo "MFEND ls_f19p45_m15_rf66"
echo "MFRUN ls_f19p45_m12_rf60"
alterparam f1 = 19450000000.0
alterparam f2 = 19450000000.0
alterparam flo = 18450000000.0
alterparam vrf1 = 0.0006324555320336759
alterparam vrf2 = 0.0
alterparam vlo = 0.22466995250459165
reset
op
let mf_dcirail = 0 - i(vdd)
let mf_dc_vce_q1 = v(c_q1)-v(e_q1)
let mf_dc_vbe_q1 = v(b_q1)-v(e_q1)
let mf_dc_ic_q1 = i(vic_q1)
let mf_dc_vce_q2 = v(c_q2)-v(e_q2)
let mf_dc_vbe_q2 = v(b_q2)-v(e_q2)
let mf_dc_ic_q2 = i(vic_q2)
let mf_dc_vce_q3 = v(c_q3)-v(x1)
let mf_dc_vbe_q3 = v(lo_p)-v(x1)
let mf_dc_ic_q3 = i(vic_q3)
let mf_dc_vce_q4 = v(c_q4)-v(x1)
let mf_dc_vbe_q4 = v(lo_n)-v(x1)
let mf_dc_ic_q4 = i(vic_q4)
let mf_dc_vce_q5 = v(c_q5)-v(x2)
let mf_dc_vbe_q5 = v(lo_p)-v(x2)
let mf_dc_ic_q5 = i(vic_q5)
let mf_dc_vce_q6 = v(c_q6)-v(x2)
let mf_dc_vbe_q6 = v(lo_n)-v(x2)
let mf_dc_ic_q6 = i(vic_q6)
let mf_dc_sink_tail = v(tail)
print mf_dcirail
print mf_dc_vce_q1
print mf_dc_vbe_q1
print mf_dc_ic_q1
print mf_dc_vce_q2
print mf_dc_vbe_q2
print mf_dc_ic_q2
print mf_dc_vce_q3
print mf_dc_vbe_q3
print mf_dc_ic_q3
print mf_dc_vce_q4
print mf_dc_vbe_q4
print mf_dc_ic_q4
print mf_dc_vce_q5
print mf_dc_vbe_q5
print mf_dc_ic_q5
print mf_dc_vce_q6
print mf_dc_vbe_q6
print mf_dc_ic_q6
print mf_dc_sink_tail
tran 1e-12 4e-08 0 1e-12
let mfq_vce_q1 = v(c_q1)-v(e_q1)
meas tran mf_su_vcemax_q1 MAX mfq_vce_q1 from=0.0 to=2e-08
meas tran mf_su_vcemin_q1 MIN mfq_vce_q1 from=0.0 to=2e-08
meas tran mf_ss_vcemax_q1 MAX mfq_vce_q1 from=2e-08 to=4e-08
meas tran mf_ss_vcemin_q1 MIN mfq_vce_q1 from=2e-08 to=4e-08
let mfq_vbe_q1 = v(b_q1)-v(e_q1)
meas tran mf_su_vbemax_q1 MAX mfq_vbe_q1 from=0.0 to=2e-08
meas tran mf_su_vbemin_q1 MIN mfq_vbe_q1 from=0.0 to=2e-08
meas tran mf_ss_vbemax_q1 MAX mfq_vbe_q1 from=2e-08 to=4e-08
meas tran mf_ss_vbemin_q1 MIN mfq_vbe_q1 from=2e-08 to=4e-08
let mfq_ic_q1 = i(vic_q1)
meas tran mf_su_icmax_q1 MAX mfq_ic_q1 from=0.0 to=2e-08
meas tran mf_su_icmin_q1 MIN mfq_ic_q1 from=0.0 to=2e-08
meas tran mf_ss_icmax_q1 MAX mfq_ic_q1 from=2e-08 to=4e-08
meas tran mf_ss_icmin_q1 MIN mfq_ic_q1 from=2e-08 to=4e-08
let mfq_vce_q2 = v(c_q2)-v(e_q2)
meas tran mf_su_vcemax_q2 MAX mfq_vce_q2 from=0.0 to=2e-08
meas tran mf_su_vcemin_q2 MIN mfq_vce_q2 from=0.0 to=2e-08
meas tran mf_ss_vcemax_q2 MAX mfq_vce_q2 from=2e-08 to=4e-08
meas tran mf_ss_vcemin_q2 MIN mfq_vce_q2 from=2e-08 to=4e-08
let mfq_vbe_q2 = v(b_q2)-v(e_q2)
meas tran mf_su_vbemax_q2 MAX mfq_vbe_q2 from=0.0 to=2e-08
meas tran mf_su_vbemin_q2 MIN mfq_vbe_q2 from=0.0 to=2e-08
meas tran mf_ss_vbemax_q2 MAX mfq_vbe_q2 from=2e-08 to=4e-08
meas tran mf_ss_vbemin_q2 MIN mfq_vbe_q2 from=2e-08 to=4e-08
let mfq_ic_q2 = i(vic_q2)
meas tran mf_su_icmax_q2 MAX mfq_ic_q2 from=0.0 to=2e-08
meas tran mf_su_icmin_q2 MIN mfq_ic_q2 from=0.0 to=2e-08
meas tran mf_ss_icmax_q2 MAX mfq_ic_q2 from=2e-08 to=4e-08
meas tran mf_ss_icmin_q2 MIN mfq_ic_q2 from=2e-08 to=4e-08
let mfq_vce_q3 = v(c_q3)-v(x1)
meas tran mf_su_vcemax_q3 MAX mfq_vce_q3 from=0.0 to=2e-08
meas tran mf_su_vcemin_q3 MIN mfq_vce_q3 from=0.0 to=2e-08
meas tran mf_ss_vcemax_q3 MAX mfq_vce_q3 from=2e-08 to=4e-08
meas tran mf_ss_vcemin_q3 MIN mfq_vce_q3 from=2e-08 to=4e-08
let mfq_vbe_q3 = v(lo_p)-v(x1)
meas tran mf_su_vbemax_q3 MAX mfq_vbe_q3 from=0.0 to=2e-08
meas tran mf_su_vbemin_q3 MIN mfq_vbe_q3 from=0.0 to=2e-08
meas tran mf_ss_vbemax_q3 MAX mfq_vbe_q3 from=2e-08 to=4e-08
meas tran mf_ss_vbemin_q3 MIN mfq_vbe_q3 from=2e-08 to=4e-08
let mfq_ic_q3 = i(vic_q3)
meas tran mf_su_icmax_q3 MAX mfq_ic_q3 from=0.0 to=2e-08
meas tran mf_su_icmin_q3 MIN mfq_ic_q3 from=0.0 to=2e-08
meas tran mf_ss_icmax_q3 MAX mfq_ic_q3 from=2e-08 to=4e-08
meas tran mf_ss_icmin_q3 MIN mfq_ic_q3 from=2e-08 to=4e-08
let mfq_vce_q4 = v(c_q4)-v(x1)
meas tran mf_su_vcemax_q4 MAX mfq_vce_q4 from=0.0 to=2e-08
meas tran mf_su_vcemin_q4 MIN mfq_vce_q4 from=0.0 to=2e-08
meas tran mf_ss_vcemax_q4 MAX mfq_vce_q4 from=2e-08 to=4e-08
meas tran mf_ss_vcemin_q4 MIN mfq_vce_q4 from=2e-08 to=4e-08
let mfq_vbe_q4 = v(lo_n)-v(x1)
meas tran mf_su_vbemax_q4 MAX mfq_vbe_q4 from=0.0 to=2e-08
meas tran mf_su_vbemin_q4 MIN mfq_vbe_q4 from=0.0 to=2e-08
meas tran mf_ss_vbemax_q4 MAX mfq_vbe_q4 from=2e-08 to=4e-08
meas tran mf_ss_vbemin_q4 MIN mfq_vbe_q4 from=2e-08 to=4e-08
let mfq_ic_q4 = i(vic_q4)
meas tran mf_su_icmax_q4 MAX mfq_ic_q4 from=0.0 to=2e-08
meas tran mf_su_icmin_q4 MIN mfq_ic_q4 from=0.0 to=2e-08
meas tran mf_ss_icmax_q4 MAX mfq_ic_q4 from=2e-08 to=4e-08
meas tran mf_ss_icmin_q4 MIN mfq_ic_q4 from=2e-08 to=4e-08
let mfq_vce_q5 = v(c_q5)-v(x2)
meas tran mf_su_vcemax_q5 MAX mfq_vce_q5 from=0.0 to=2e-08
meas tran mf_su_vcemin_q5 MIN mfq_vce_q5 from=0.0 to=2e-08
meas tran mf_ss_vcemax_q5 MAX mfq_vce_q5 from=2e-08 to=4e-08
meas tran mf_ss_vcemin_q5 MIN mfq_vce_q5 from=2e-08 to=4e-08
let mfq_vbe_q5 = v(lo_p)-v(x2)
meas tran mf_su_vbemax_q5 MAX mfq_vbe_q5 from=0.0 to=2e-08
meas tran mf_su_vbemin_q5 MIN mfq_vbe_q5 from=0.0 to=2e-08
meas tran mf_ss_vbemax_q5 MAX mfq_vbe_q5 from=2e-08 to=4e-08
meas tran mf_ss_vbemin_q5 MIN mfq_vbe_q5 from=2e-08 to=4e-08
let mfq_ic_q5 = i(vic_q5)
meas tran mf_su_icmax_q5 MAX mfq_ic_q5 from=0.0 to=2e-08
meas tran mf_su_icmin_q5 MIN mfq_ic_q5 from=0.0 to=2e-08
meas tran mf_ss_icmax_q5 MAX mfq_ic_q5 from=2e-08 to=4e-08
meas tran mf_ss_icmin_q5 MIN mfq_ic_q5 from=2e-08 to=4e-08
let mfq_vce_q6 = v(c_q6)-v(x2)
meas tran mf_su_vcemax_q6 MAX mfq_vce_q6 from=0.0 to=2e-08
meas tran mf_su_vcemin_q6 MIN mfq_vce_q6 from=0.0 to=2e-08
meas tran mf_ss_vcemax_q6 MAX mfq_vce_q6 from=2e-08 to=4e-08
meas tran mf_ss_vcemin_q6 MIN mfq_vce_q6 from=2e-08 to=4e-08
let mfq_vbe_q6 = v(lo_n)-v(x2)
meas tran mf_su_vbemax_q6 MAX mfq_vbe_q6 from=0.0 to=2e-08
meas tran mf_su_vbemin_q6 MIN mfq_vbe_q6 from=0.0 to=2e-08
meas tran mf_ss_vbemax_q6 MAX mfq_vbe_q6 from=2e-08 to=4e-08
meas tran mf_ss_vbemin_q6 MIN mfq_vbe_q6 from=2e-08 to=4e-08
let mfq_ic_q6 = i(vic_q6)
meas tran mf_su_icmax_q6 MAX mfq_ic_q6 from=0.0 to=2e-08
meas tran mf_su_icmin_q6 MIN mfq_ic_q6 from=0.0 to=2e-08
meas tran mf_ss_icmax_q6 MAX mfq_ic_q6 from=2e-08 to=4e-08
meas tran mf_ss_icmin_q6 MIN mfq_ic_q6 from=2e-08 to=4e-08
meas tran mf_su_sinkmin_tail MIN v(tail) from=0.0 to=2e-08
meas tran mf_ss_sinkmin_tail MIN v(tail) from=2e-08 to=4e-08
print mf_su_vcemax_q1
print mf_su_vcemin_q1
print mf_ss_vcemax_q1
print mf_ss_vcemin_q1
print mf_su_vbemax_q1
print mf_su_vbemin_q1
print mf_ss_vbemax_q1
print mf_ss_vbemin_q1
print mf_su_icmax_q1
print mf_su_icmin_q1
print mf_ss_icmax_q1
print mf_ss_icmin_q1
print mf_su_vcemax_q2
print mf_su_vcemin_q2
print mf_ss_vcemax_q2
print mf_ss_vcemin_q2
print mf_su_vbemax_q2
print mf_su_vbemin_q2
print mf_ss_vbemax_q2
print mf_ss_vbemin_q2
print mf_su_icmax_q2
print mf_su_icmin_q2
print mf_ss_icmax_q2
print mf_ss_icmin_q2
print mf_su_vcemax_q3
print mf_su_vcemin_q3
print mf_ss_vcemax_q3
print mf_ss_vcemin_q3
print mf_su_vbemax_q3
print mf_su_vbemin_q3
print mf_ss_vbemax_q3
print mf_ss_vbemin_q3
print mf_su_icmax_q3
print mf_su_icmin_q3
print mf_ss_icmax_q3
print mf_ss_icmin_q3
print mf_su_vcemax_q4
print mf_su_vcemin_q4
print mf_ss_vcemax_q4
print mf_ss_vcemin_q4
print mf_su_vbemax_q4
print mf_su_vbemin_q4
print mf_ss_vbemax_q4
print mf_ss_vbemin_q4
print mf_su_icmax_q4
print mf_su_icmin_q4
print mf_ss_icmax_q4
print mf_ss_icmin_q4
print mf_su_vcemax_q5
print mf_su_vcemin_q5
print mf_ss_vcemax_q5
print mf_ss_vcemin_q5
print mf_su_vbemax_q5
print mf_su_vbemin_q5
print mf_ss_vbemax_q5
print mf_ss_vbemin_q5
print mf_su_icmax_q5
print mf_su_icmin_q5
print mf_ss_icmax_q5
print mf_ss_icmin_q5
print mf_su_vcemax_q6
print mf_su_vcemin_q6
print mf_ss_vcemax_q6
print mf_ss_vcemin_q6
print mf_su_vbemax_q6
print mf_su_vbemin_q6
print mf_ss_vbemax_q6
print mf_ss_vbemin_q6
print mf_su_icmax_q6
print mf_su_icmin_q6
print mf_ss_icmax_q6
print mf_ss_icmin_q6
print mf_su_sinkmin_tail
print mf_ss_sinkmin_tail
linearize
let mf_l = length(time)
let mfw = (time ge 1.99995e-08) * (time lt 3.99995e-08)
let mf_n = mean(mfw) * mf_l
let mfs = mf_l / mf_n
let mf_prail = mean(v(vdd) * (0 - i(vdd)) * mfw) * mfs
let mfph = 2 * pi * 18450000000.0 * (time - 2e-08)
let mf_lodiff_re = 2 * mean((v(lo_p)-v(lo_n)) * mfw * cos(mfph)) * mfs
let mf_lodiff_im = 2 * mean((v(lo_p)-v(lo_n)) * mfw * sin(mfph)) * mfs
let mfph = 2 * pi * 1000000000.0 * (time - 2e-08)
let mf_if_re = 2 * mean((v(if_out)) * mfw * cos(mfph)) * mfs
let mf_if_im = 2 * mean((v(if_out)) * mfw * sin(mfph)) * mfs
let mfph = 2 * pi * 18450000000.0 * (time - 2e-08)
let mf_loif_re = 2 * mean((v(if_out)) * mfw * cos(mfph)) * mfs
let mf_loif_im = 2 * mean((v(if_out)) * mfw * sin(mfph)) * mfs
let mfph = 2 * pi * 18450000000.0 * (time - 2e-08)
let mf_lorf_re = 2 * mean((v(rf_port)) * mfw * cos(mfph)) * mfs
let mf_lorf_im = 2 * mean((v(rf_port)) * mfw * sin(mfph)) * mfs
let mfph = 2 * pi * 950000000.0 * (time - 2e-08)
let mf_flifa_re = 2 * mean((v(if_out)) * mfw * cos(mfph)) * mfs
let mf_flifa_im = 2 * mean((v(if_out)) * mfw * sin(mfph)) * mfs
let mfph = 2 * pi * 1050000000.0 * (time - 2e-08)
let mf_flifb_re = 2 * mean((v(if_out)) * mfw * cos(mfph)) * mfs
let mf_flifb_im = 2 * mean((v(if_out)) * mfw * sin(mfph)) * mfs
let mfph = 2 * pi * 18500000000.0 * (time - 2e-08)
let mf_fllorf_re = 2 * mean((v(rf_port)) * mfw * cos(mfph)) * mfs
let mf_fllorf_im = 2 * mean((v(rf_port)) * mfw * sin(mfph)) * mfs
let mfph = 2 * pi * 18500000000.0 * (time - 2e-08)
let mf_flloif_re = 2 * mean((v(if_out)) * mfw * cos(mfph)) * mfs
let mf_flloif_im = 2 * mean((v(if_out)) * mfw * sin(mfph)) * mfs
print mf_l
print mf_n
print mf_prail
print mf_lodiff_re
print mf_lodiff_im
print mf_if_re
print mf_if_im
print mf_loif_re
print mf_loif_im
print mf_lorf_re
print mf_lorf_im
print mf_flifa_re
print mf_flifa_im
print mf_flifb_re
print mf_flifb_im
print mf_fllorf_re
print mf_fllorf_im
print mf_flloif_re
print mf_flloif_im
destroy all
echo "MFEND ls_f19p45_m12_rf60"
echo "MFRUN ls_f19p45_m12_rf66"
alterparam f1 = 19450000000.0
alterparam f2 = 19450000000.0
alterparam flo = 18450000000.0
alterparam vrf1 = 0.00031697863849222284
alterparam vrf2 = 0.0
alterparam vlo = 0.22466995250459165
reset
op
let mf_dcirail = 0 - i(vdd)
let mf_dc_vce_q1 = v(c_q1)-v(e_q1)
let mf_dc_vbe_q1 = v(b_q1)-v(e_q1)
let mf_dc_ic_q1 = i(vic_q1)
let mf_dc_vce_q2 = v(c_q2)-v(e_q2)
let mf_dc_vbe_q2 = v(b_q2)-v(e_q2)
let mf_dc_ic_q2 = i(vic_q2)
let mf_dc_vce_q3 = v(c_q3)-v(x1)
let mf_dc_vbe_q3 = v(lo_p)-v(x1)
let mf_dc_ic_q3 = i(vic_q3)
let mf_dc_vce_q4 = v(c_q4)-v(x1)
let mf_dc_vbe_q4 = v(lo_n)-v(x1)
let mf_dc_ic_q4 = i(vic_q4)
let mf_dc_vce_q5 = v(c_q5)-v(x2)
let mf_dc_vbe_q5 = v(lo_p)-v(x2)
let mf_dc_ic_q5 = i(vic_q5)
let mf_dc_vce_q6 = v(c_q6)-v(x2)
let mf_dc_vbe_q6 = v(lo_n)-v(x2)
let mf_dc_ic_q6 = i(vic_q6)
let mf_dc_sink_tail = v(tail)
print mf_dcirail
print mf_dc_vce_q1
print mf_dc_vbe_q1
print mf_dc_ic_q1
print mf_dc_vce_q2
print mf_dc_vbe_q2
print mf_dc_ic_q2
print mf_dc_vce_q3
print mf_dc_vbe_q3
print mf_dc_ic_q3
print mf_dc_vce_q4
print mf_dc_vbe_q4
print mf_dc_ic_q4
print mf_dc_vce_q5
print mf_dc_vbe_q5
print mf_dc_ic_q5
print mf_dc_vce_q6
print mf_dc_vbe_q6
print mf_dc_ic_q6
print mf_dc_sink_tail
tran 1e-12 4e-08 0 1e-12
let mfq_vce_q1 = v(c_q1)-v(e_q1)
meas tran mf_su_vcemax_q1 MAX mfq_vce_q1 from=0.0 to=2e-08
meas tran mf_su_vcemin_q1 MIN mfq_vce_q1 from=0.0 to=2e-08
meas tran mf_ss_vcemax_q1 MAX mfq_vce_q1 from=2e-08 to=4e-08
meas tran mf_ss_vcemin_q1 MIN mfq_vce_q1 from=2e-08 to=4e-08
let mfq_vbe_q1 = v(b_q1)-v(e_q1)
meas tran mf_su_vbemax_q1 MAX mfq_vbe_q1 from=0.0 to=2e-08
meas tran mf_su_vbemin_q1 MIN mfq_vbe_q1 from=0.0 to=2e-08
meas tran mf_ss_vbemax_q1 MAX mfq_vbe_q1 from=2e-08 to=4e-08
meas tran mf_ss_vbemin_q1 MIN mfq_vbe_q1 from=2e-08 to=4e-08
let mfq_ic_q1 = i(vic_q1)
meas tran mf_su_icmax_q1 MAX mfq_ic_q1 from=0.0 to=2e-08
meas tran mf_su_icmin_q1 MIN mfq_ic_q1 from=0.0 to=2e-08
meas tran mf_ss_icmax_q1 MAX mfq_ic_q1 from=2e-08 to=4e-08
meas tran mf_ss_icmin_q1 MIN mfq_ic_q1 from=2e-08 to=4e-08
let mfq_vce_q2 = v(c_q2)-v(e_q2)
meas tran mf_su_vcemax_q2 MAX mfq_vce_q2 from=0.0 to=2e-08
meas tran mf_su_vcemin_q2 MIN mfq_vce_q2 from=0.0 to=2e-08
meas tran mf_ss_vcemax_q2 MAX mfq_vce_q2 from=2e-08 to=4e-08
meas tran mf_ss_vcemin_q2 MIN mfq_vce_q2 from=2e-08 to=4e-08
let mfq_vbe_q2 = v(b_q2)-v(e_q2)
meas tran mf_su_vbemax_q2 MAX mfq_vbe_q2 from=0.0 to=2e-08
meas tran mf_su_vbemin_q2 MIN mfq_vbe_q2 from=0.0 to=2e-08
meas tran mf_ss_vbemax_q2 MAX mfq_vbe_q2 from=2e-08 to=4e-08
meas tran mf_ss_vbemin_q2 MIN mfq_vbe_q2 from=2e-08 to=4e-08
let mfq_ic_q2 = i(vic_q2)
meas tran mf_su_icmax_q2 MAX mfq_ic_q2 from=0.0 to=2e-08
meas tran mf_su_icmin_q2 MIN mfq_ic_q2 from=0.0 to=2e-08
meas tran mf_ss_icmax_q2 MAX mfq_ic_q2 from=2e-08 to=4e-08
meas tran mf_ss_icmin_q2 MIN mfq_ic_q2 from=2e-08 to=4e-08
let mfq_vce_q3 = v(c_q3)-v(x1)
meas tran mf_su_vcemax_q3 MAX mfq_vce_q3 from=0.0 to=2e-08
meas tran mf_su_vcemin_q3 MIN mfq_vce_q3 from=0.0 to=2e-08
meas tran mf_ss_vcemax_q3 MAX mfq_vce_q3 from=2e-08 to=4e-08
meas tran mf_ss_vcemin_q3 MIN mfq_vce_q3 from=2e-08 to=4e-08
let mfq_vbe_q3 = v(lo_p)-v(x1)
meas tran mf_su_vbemax_q3 MAX mfq_vbe_q3 from=0.0 to=2e-08
meas tran mf_su_vbemin_q3 MIN mfq_vbe_q3 from=0.0 to=2e-08
meas tran mf_ss_vbemax_q3 MAX mfq_vbe_q3 from=2e-08 to=4e-08
meas tran mf_ss_vbemin_q3 MIN mfq_vbe_q3 from=2e-08 to=4e-08
let mfq_ic_q3 = i(vic_q3)
meas tran mf_su_icmax_q3 MAX mfq_ic_q3 from=0.0 to=2e-08
meas tran mf_su_icmin_q3 MIN mfq_ic_q3 from=0.0 to=2e-08
meas tran mf_ss_icmax_q3 MAX mfq_ic_q3 from=2e-08 to=4e-08
meas tran mf_ss_icmin_q3 MIN mfq_ic_q3 from=2e-08 to=4e-08
let mfq_vce_q4 = v(c_q4)-v(x1)
meas tran mf_su_vcemax_q4 MAX mfq_vce_q4 from=0.0 to=2e-08
meas tran mf_su_vcemin_q4 MIN mfq_vce_q4 from=0.0 to=2e-08
meas tran mf_ss_vcemax_q4 MAX mfq_vce_q4 from=2e-08 to=4e-08
meas tran mf_ss_vcemin_q4 MIN mfq_vce_q4 from=2e-08 to=4e-08
let mfq_vbe_q4 = v(lo_n)-v(x1)
meas tran mf_su_vbemax_q4 MAX mfq_vbe_q4 from=0.0 to=2e-08
meas tran mf_su_vbemin_q4 MIN mfq_vbe_q4 from=0.0 to=2e-08
meas tran mf_ss_vbemax_q4 MAX mfq_vbe_q4 from=2e-08 to=4e-08
meas tran mf_ss_vbemin_q4 MIN mfq_vbe_q4 from=2e-08 to=4e-08
let mfq_ic_q4 = i(vic_q4)
meas tran mf_su_icmax_q4 MAX mfq_ic_q4 from=0.0 to=2e-08
meas tran mf_su_icmin_q4 MIN mfq_ic_q4 from=0.0 to=2e-08
meas tran mf_ss_icmax_q4 MAX mfq_ic_q4 from=2e-08 to=4e-08
meas tran mf_ss_icmin_q4 MIN mfq_ic_q4 from=2e-08 to=4e-08
let mfq_vce_q5 = v(c_q5)-v(x2)
meas tran mf_su_vcemax_q5 MAX mfq_vce_q5 from=0.0 to=2e-08
meas tran mf_su_vcemin_q5 MIN mfq_vce_q5 from=0.0 to=2e-08
meas tran mf_ss_vcemax_q5 MAX mfq_vce_q5 from=2e-08 to=4e-08
meas tran mf_ss_vcemin_q5 MIN mfq_vce_q5 from=2e-08 to=4e-08
let mfq_vbe_q5 = v(lo_p)-v(x2)
meas tran mf_su_vbemax_q5 MAX mfq_vbe_q5 from=0.0 to=2e-08
meas tran mf_su_vbemin_q5 MIN mfq_vbe_q5 from=0.0 to=2e-08
meas tran mf_ss_vbemax_q5 MAX mfq_vbe_q5 from=2e-08 to=4e-08
meas tran mf_ss_vbemin_q5 MIN mfq_vbe_q5 from=2e-08 to=4e-08
let mfq_ic_q5 = i(vic_q5)
meas tran mf_su_icmax_q5 MAX mfq_ic_q5 from=0.0 to=2e-08
meas tran mf_su_icmin_q5 MIN mfq_ic_q5 from=0.0 to=2e-08
meas tran mf_ss_icmax_q5 MAX mfq_ic_q5 from=2e-08 to=4e-08
meas tran mf_ss_icmin_q5 MIN mfq_ic_q5 from=2e-08 to=4e-08
let mfq_vce_q6 = v(c_q6)-v(x2)
meas tran mf_su_vcemax_q6 MAX mfq_vce_q6 from=0.0 to=2e-08
meas tran mf_su_vcemin_q6 MIN mfq_vce_q6 from=0.0 to=2e-08
meas tran mf_ss_vcemax_q6 MAX mfq_vce_q6 from=2e-08 to=4e-08
meas tran mf_ss_vcemin_q6 MIN mfq_vce_q6 from=2e-08 to=4e-08
let mfq_vbe_q6 = v(lo_n)-v(x2)
meas tran mf_su_vbemax_q6 MAX mfq_vbe_q6 from=0.0 to=2e-08
meas tran mf_su_vbemin_q6 MIN mfq_vbe_q6 from=0.0 to=2e-08
meas tran mf_ss_vbemax_q6 MAX mfq_vbe_q6 from=2e-08 to=4e-08
meas tran mf_ss_vbemin_q6 MIN mfq_vbe_q6 from=2e-08 to=4e-08
let mfq_ic_q6 = i(vic_q6)
meas tran mf_su_icmax_q6 MAX mfq_ic_q6 from=0.0 to=2e-08
meas tran mf_su_icmin_q6 MIN mfq_ic_q6 from=0.0 to=2e-08
meas tran mf_ss_icmax_q6 MAX mfq_ic_q6 from=2e-08 to=4e-08
meas tran mf_ss_icmin_q6 MIN mfq_ic_q6 from=2e-08 to=4e-08
meas tran mf_su_sinkmin_tail MIN v(tail) from=0.0 to=2e-08
meas tran mf_ss_sinkmin_tail MIN v(tail) from=2e-08 to=4e-08
print mf_su_vcemax_q1
print mf_su_vcemin_q1
print mf_ss_vcemax_q1
print mf_ss_vcemin_q1
print mf_su_vbemax_q1
print mf_su_vbemin_q1
print mf_ss_vbemax_q1
print mf_ss_vbemin_q1
print mf_su_icmax_q1
print mf_su_icmin_q1
print mf_ss_icmax_q1
print mf_ss_icmin_q1
print mf_su_vcemax_q2
print mf_su_vcemin_q2
print mf_ss_vcemax_q2
print mf_ss_vcemin_q2
print mf_su_vbemax_q2
print mf_su_vbemin_q2
print mf_ss_vbemax_q2
print mf_ss_vbemin_q2
print mf_su_icmax_q2
print mf_su_icmin_q2
print mf_ss_icmax_q2
print mf_ss_icmin_q2
print mf_su_vcemax_q3
print mf_su_vcemin_q3
print mf_ss_vcemax_q3
print mf_ss_vcemin_q3
print mf_su_vbemax_q3
print mf_su_vbemin_q3
print mf_ss_vbemax_q3
print mf_ss_vbemin_q3
print mf_su_icmax_q3
print mf_su_icmin_q3
print mf_ss_icmax_q3
print mf_ss_icmin_q3
print mf_su_vcemax_q4
print mf_su_vcemin_q4
print mf_ss_vcemax_q4
print mf_ss_vcemin_q4
print mf_su_vbemax_q4
print mf_su_vbemin_q4
print mf_ss_vbemax_q4
print mf_ss_vbemin_q4
print mf_su_icmax_q4
print mf_su_icmin_q4
print mf_ss_icmax_q4
print mf_ss_icmin_q4
print mf_su_vcemax_q5
print mf_su_vcemin_q5
print mf_ss_vcemax_q5
print mf_ss_vcemin_q5
print mf_su_vbemax_q5
print mf_su_vbemin_q5
print mf_ss_vbemax_q5
print mf_ss_vbemin_q5
print mf_su_icmax_q5
print mf_su_icmin_q5
print mf_ss_icmax_q5
print mf_ss_icmin_q5
print mf_su_vcemax_q6
print mf_su_vcemin_q6
print mf_ss_vcemax_q6
print mf_ss_vcemin_q6
print mf_su_vbemax_q6
print mf_su_vbemin_q6
print mf_ss_vbemax_q6
print mf_ss_vbemin_q6
print mf_su_icmax_q6
print mf_su_icmin_q6
print mf_ss_icmax_q6
print mf_ss_icmin_q6
print mf_su_sinkmin_tail
print mf_ss_sinkmin_tail
linearize
let mf_l = length(time)
let mfw = (time ge 1.99995e-08) * (time lt 3.99995e-08)
let mf_n = mean(mfw) * mf_l
let mfs = mf_l / mf_n
let mf_prail = mean(v(vdd) * (0 - i(vdd)) * mfw) * mfs
let mfph = 2 * pi * 18450000000.0 * (time - 2e-08)
let mf_lodiff_re = 2 * mean((v(lo_p)-v(lo_n)) * mfw * cos(mfph)) * mfs
let mf_lodiff_im = 2 * mean((v(lo_p)-v(lo_n)) * mfw * sin(mfph)) * mfs
let mfph = 2 * pi * 1000000000.0 * (time - 2e-08)
let mf_if_re = 2 * mean((v(if_out)) * mfw * cos(mfph)) * mfs
let mf_if_im = 2 * mean((v(if_out)) * mfw * sin(mfph)) * mfs
let mfph = 2 * pi * 18450000000.0 * (time - 2e-08)
let mf_loif_re = 2 * mean((v(if_out)) * mfw * cos(mfph)) * mfs
let mf_loif_im = 2 * mean((v(if_out)) * mfw * sin(mfph)) * mfs
let mfph = 2 * pi * 18450000000.0 * (time - 2e-08)
let mf_lorf_re = 2 * mean((v(rf_port)) * mfw * cos(mfph)) * mfs
let mf_lorf_im = 2 * mean((v(rf_port)) * mfw * sin(mfph)) * mfs
let mfph = 2 * pi * 950000000.0 * (time - 2e-08)
let mf_flifa_re = 2 * mean((v(if_out)) * mfw * cos(mfph)) * mfs
let mf_flifa_im = 2 * mean((v(if_out)) * mfw * sin(mfph)) * mfs
let mfph = 2 * pi * 1050000000.0 * (time - 2e-08)
let mf_flifb_re = 2 * mean((v(if_out)) * mfw * cos(mfph)) * mfs
let mf_flifb_im = 2 * mean((v(if_out)) * mfw * sin(mfph)) * mfs
let mfph = 2 * pi * 18500000000.0 * (time - 2e-08)
let mf_fllorf_re = 2 * mean((v(rf_port)) * mfw * cos(mfph)) * mfs
let mf_fllorf_im = 2 * mean((v(rf_port)) * mfw * sin(mfph)) * mfs
let mfph = 2 * pi * 18500000000.0 * (time - 2e-08)
let mf_flloif_re = 2 * mean((v(if_out)) * mfw * cos(mfph)) * mfs
let mf_flloif_im = 2 * mean((v(if_out)) * mfw * sin(mfph)) * mfs
print mf_l
print mf_n
print mf_prail
print mf_lodiff_re
print mf_lodiff_im
print mf_if_re
print mf_if_im
print mf_loif_re
print mf_loif_im
print mf_lorf_re
print mf_lorf_im
print mf_flifa_re
print mf_flifa_im
print mf_flifb_re
print mf_flifb_im
print mf_fllorf_re
print mf_fllorf_im
print mf_flloif_re
print mf_flloif_im
destroy all
echo "MFEND ls_f19p45_m12_rf66"
echo "MFRUN ls_f19p45_m9_rf60"
alterparam f1 = 19450000000.0
alterparam f2 = 19450000000.0
alterparam flo = 18450000000.0
alterparam vrf1 = 0.0006324555320336759
alterparam vrf2 = 0.0
alterparam vlo = 0.31735474306134676
reset
op
let mf_dcirail = 0 - i(vdd)
let mf_dc_vce_q1 = v(c_q1)-v(e_q1)
let mf_dc_vbe_q1 = v(b_q1)-v(e_q1)
let mf_dc_ic_q1 = i(vic_q1)
let mf_dc_vce_q2 = v(c_q2)-v(e_q2)
let mf_dc_vbe_q2 = v(b_q2)-v(e_q2)
let mf_dc_ic_q2 = i(vic_q2)
let mf_dc_vce_q3 = v(c_q3)-v(x1)
let mf_dc_vbe_q3 = v(lo_p)-v(x1)
let mf_dc_ic_q3 = i(vic_q3)
let mf_dc_vce_q4 = v(c_q4)-v(x1)
let mf_dc_vbe_q4 = v(lo_n)-v(x1)
let mf_dc_ic_q4 = i(vic_q4)
let mf_dc_vce_q5 = v(c_q5)-v(x2)
let mf_dc_vbe_q5 = v(lo_p)-v(x2)
let mf_dc_ic_q5 = i(vic_q5)
let mf_dc_vce_q6 = v(c_q6)-v(x2)
let mf_dc_vbe_q6 = v(lo_n)-v(x2)
let mf_dc_ic_q6 = i(vic_q6)
let mf_dc_sink_tail = v(tail)
print mf_dcirail
print mf_dc_vce_q1
print mf_dc_vbe_q1
print mf_dc_ic_q1
print mf_dc_vce_q2
print mf_dc_vbe_q2
print mf_dc_ic_q2
print mf_dc_vce_q3
print mf_dc_vbe_q3
print mf_dc_ic_q3
print mf_dc_vce_q4
print mf_dc_vbe_q4
print mf_dc_ic_q4
print mf_dc_vce_q5
print mf_dc_vbe_q5
print mf_dc_ic_q5
print mf_dc_vce_q6
print mf_dc_vbe_q6
print mf_dc_ic_q6
print mf_dc_sink_tail
tran 1e-12 4e-08 0 1e-12
let mfq_vce_q1 = v(c_q1)-v(e_q1)
meas tran mf_su_vcemax_q1 MAX mfq_vce_q1 from=0.0 to=2e-08
meas tran mf_su_vcemin_q1 MIN mfq_vce_q1 from=0.0 to=2e-08
meas tran mf_ss_vcemax_q1 MAX mfq_vce_q1 from=2e-08 to=4e-08
meas tran mf_ss_vcemin_q1 MIN mfq_vce_q1 from=2e-08 to=4e-08
let mfq_vbe_q1 = v(b_q1)-v(e_q1)
meas tran mf_su_vbemax_q1 MAX mfq_vbe_q1 from=0.0 to=2e-08
meas tran mf_su_vbemin_q1 MIN mfq_vbe_q1 from=0.0 to=2e-08
meas tran mf_ss_vbemax_q1 MAX mfq_vbe_q1 from=2e-08 to=4e-08
meas tran mf_ss_vbemin_q1 MIN mfq_vbe_q1 from=2e-08 to=4e-08
let mfq_ic_q1 = i(vic_q1)
meas tran mf_su_icmax_q1 MAX mfq_ic_q1 from=0.0 to=2e-08
meas tran mf_su_icmin_q1 MIN mfq_ic_q1 from=0.0 to=2e-08
meas tran mf_ss_icmax_q1 MAX mfq_ic_q1 from=2e-08 to=4e-08
meas tran mf_ss_icmin_q1 MIN mfq_ic_q1 from=2e-08 to=4e-08
let mfq_vce_q2 = v(c_q2)-v(e_q2)
meas tran mf_su_vcemax_q2 MAX mfq_vce_q2 from=0.0 to=2e-08
meas tran mf_su_vcemin_q2 MIN mfq_vce_q2 from=0.0 to=2e-08
meas tran mf_ss_vcemax_q2 MAX mfq_vce_q2 from=2e-08 to=4e-08
meas tran mf_ss_vcemin_q2 MIN mfq_vce_q2 from=2e-08 to=4e-08
let mfq_vbe_q2 = v(b_q2)-v(e_q2)
meas tran mf_su_vbemax_q2 MAX mfq_vbe_q2 from=0.0 to=2e-08
meas tran mf_su_vbemin_q2 MIN mfq_vbe_q2 from=0.0 to=2e-08
meas tran mf_ss_vbemax_q2 MAX mfq_vbe_q2 from=2e-08 to=4e-08
meas tran mf_ss_vbemin_q2 MIN mfq_vbe_q2 from=2e-08 to=4e-08
let mfq_ic_q2 = i(vic_q2)
meas tran mf_su_icmax_q2 MAX mfq_ic_q2 from=0.0 to=2e-08
meas tran mf_su_icmin_q2 MIN mfq_ic_q2 from=0.0 to=2e-08
meas tran mf_ss_icmax_q2 MAX mfq_ic_q2 from=2e-08 to=4e-08
meas tran mf_ss_icmin_q2 MIN mfq_ic_q2 from=2e-08 to=4e-08
let mfq_vce_q3 = v(c_q3)-v(x1)
meas tran mf_su_vcemax_q3 MAX mfq_vce_q3 from=0.0 to=2e-08
meas tran mf_su_vcemin_q3 MIN mfq_vce_q3 from=0.0 to=2e-08
meas tran mf_ss_vcemax_q3 MAX mfq_vce_q3 from=2e-08 to=4e-08
meas tran mf_ss_vcemin_q3 MIN mfq_vce_q3 from=2e-08 to=4e-08
let mfq_vbe_q3 = v(lo_p)-v(x1)
meas tran mf_su_vbemax_q3 MAX mfq_vbe_q3 from=0.0 to=2e-08
meas tran mf_su_vbemin_q3 MIN mfq_vbe_q3 from=0.0 to=2e-08
meas tran mf_ss_vbemax_q3 MAX mfq_vbe_q3 from=2e-08 to=4e-08
meas tran mf_ss_vbemin_q3 MIN mfq_vbe_q3 from=2e-08 to=4e-08
let mfq_ic_q3 = i(vic_q3)
meas tran mf_su_icmax_q3 MAX mfq_ic_q3 from=0.0 to=2e-08
meas tran mf_su_icmin_q3 MIN mfq_ic_q3 from=0.0 to=2e-08
meas tran mf_ss_icmax_q3 MAX mfq_ic_q3 from=2e-08 to=4e-08
meas tran mf_ss_icmin_q3 MIN mfq_ic_q3 from=2e-08 to=4e-08
let mfq_vce_q4 = v(c_q4)-v(x1)
meas tran mf_su_vcemax_q4 MAX mfq_vce_q4 from=0.0 to=2e-08
meas tran mf_su_vcemin_q4 MIN mfq_vce_q4 from=0.0 to=2e-08
meas tran mf_ss_vcemax_q4 MAX mfq_vce_q4 from=2e-08 to=4e-08
meas tran mf_ss_vcemin_q4 MIN mfq_vce_q4 from=2e-08 to=4e-08
let mfq_vbe_q4 = v(lo_n)-v(x1)
meas tran mf_su_vbemax_q4 MAX mfq_vbe_q4 from=0.0 to=2e-08
meas tran mf_su_vbemin_q4 MIN mfq_vbe_q4 from=0.0 to=2e-08
meas tran mf_ss_vbemax_q4 MAX mfq_vbe_q4 from=2e-08 to=4e-08
meas tran mf_ss_vbemin_q4 MIN mfq_vbe_q4 from=2e-08 to=4e-08
let mfq_ic_q4 = i(vic_q4)
meas tran mf_su_icmax_q4 MAX mfq_ic_q4 from=0.0 to=2e-08
meas tran mf_su_icmin_q4 MIN mfq_ic_q4 from=0.0 to=2e-08
meas tran mf_ss_icmax_q4 MAX mfq_ic_q4 from=2e-08 to=4e-08
meas tran mf_ss_icmin_q4 MIN mfq_ic_q4 from=2e-08 to=4e-08
let mfq_vce_q5 = v(c_q5)-v(x2)
meas tran mf_su_vcemax_q5 MAX mfq_vce_q5 from=0.0 to=2e-08
meas tran mf_su_vcemin_q5 MIN mfq_vce_q5 from=0.0 to=2e-08
meas tran mf_ss_vcemax_q5 MAX mfq_vce_q5 from=2e-08 to=4e-08
meas tran mf_ss_vcemin_q5 MIN mfq_vce_q5 from=2e-08 to=4e-08
let mfq_vbe_q5 = v(lo_p)-v(x2)
meas tran mf_su_vbemax_q5 MAX mfq_vbe_q5 from=0.0 to=2e-08
meas tran mf_su_vbemin_q5 MIN mfq_vbe_q5 from=0.0 to=2e-08
meas tran mf_ss_vbemax_q5 MAX mfq_vbe_q5 from=2e-08 to=4e-08
meas tran mf_ss_vbemin_q5 MIN mfq_vbe_q5 from=2e-08 to=4e-08
let mfq_ic_q5 = i(vic_q5)
meas tran mf_su_icmax_q5 MAX mfq_ic_q5 from=0.0 to=2e-08
meas tran mf_su_icmin_q5 MIN mfq_ic_q5 from=0.0 to=2e-08
meas tran mf_ss_icmax_q5 MAX mfq_ic_q5 from=2e-08 to=4e-08
meas tran mf_ss_icmin_q5 MIN mfq_ic_q5 from=2e-08 to=4e-08
let mfq_vce_q6 = v(c_q6)-v(x2)
meas tran mf_su_vcemax_q6 MAX mfq_vce_q6 from=0.0 to=2e-08
meas tran mf_su_vcemin_q6 MIN mfq_vce_q6 from=0.0 to=2e-08
meas tran mf_ss_vcemax_q6 MAX mfq_vce_q6 from=2e-08 to=4e-08
meas tran mf_ss_vcemin_q6 MIN mfq_vce_q6 from=2e-08 to=4e-08
let mfq_vbe_q6 = v(lo_n)-v(x2)
meas tran mf_su_vbemax_q6 MAX mfq_vbe_q6 from=0.0 to=2e-08
meas tran mf_su_vbemin_q6 MIN mfq_vbe_q6 from=0.0 to=2e-08
meas tran mf_ss_vbemax_q6 MAX mfq_vbe_q6 from=2e-08 to=4e-08
meas tran mf_ss_vbemin_q6 MIN mfq_vbe_q6 from=2e-08 to=4e-08
let mfq_ic_q6 = i(vic_q6)
meas tran mf_su_icmax_q6 MAX mfq_ic_q6 from=0.0 to=2e-08
meas tran mf_su_icmin_q6 MIN mfq_ic_q6 from=0.0 to=2e-08
meas tran mf_ss_icmax_q6 MAX mfq_ic_q6 from=2e-08 to=4e-08
meas tran mf_ss_icmin_q6 MIN mfq_ic_q6 from=2e-08 to=4e-08
meas tran mf_su_sinkmin_tail MIN v(tail) from=0.0 to=2e-08
meas tran mf_ss_sinkmin_tail MIN v(tail) from=2e-08 to=4e-08
print mf_su_vcemax_q1
print mf_su_vcemin_q1
print mf_ss_vcemax_q1
print mf_ss_vcemin_q1
print mf_su_vbemax_q1
print mf_su_vbemin_q1
print mf_ss_vbemax_q1
print mf_ss_vbemin_q1
print mf_su_icmax_q1
print mf_su_icmin_q1
print mf_ss_icmax_q1
print mf_ss_icmin_q1
print mf_su_vcemax_q2
print mf_su_vcemin_q2
print mf_ss_vcemax_q2
print mf_ss_vcemin_q2
print mf_su_vbemax_q2
print mf_su_vbemin_q2
print mf_ss_vbemax_q2
print mf_ss_vbemin_q2
print mf_su_icmax_q2
print mf_su_icmin_q2
print mf_ss_icmax_q2
print mf_ss_icmin_q2
print mf_su_vcemax_q3
print mf_su_vcemin_q3
print mf_ss_vcemax_q3
print mf_ss_vcemin_q3
print mf_su_vbemax_q3
print mf_su_vbemin_q3
print mf_ss_vbemax_q3
print mf_ss_vbemin_q3
print mf_su_icmax_q3
print mf_su_icmin_q3
print mf_ss_icmax_q3
print mf_ss_icmin_q3
print mf_su_vcemax_q4
print mf_su_vcemin_q4
print mf_ss_vcemax_q4
print mf_ss_vcemin_q4
print mf_su_vbemax_q4
print mf_su_vbemin_q4
print mf_ss_vbemax_q4
print mf_ss_vbemin_q4
print mf_su_icmax_q4
print mf_su_icmin_q4
print mf_ss_icmax_q4
print mf_ss_icmin_q4
print mf_su_vcemax_q5
print mf_su_vcemin_q5
print mf_ss_vcemax_q5
print mf_ss_vcemin_q5
print mf_su_vbemax_q5
print mf_su_vbemin_q5
print mf_ss_vbemax_q5
print mf_ss_vbemin_q5
print mf_su_icmax_q5
print mf_su_icmin_q5
print mf_ss_icmax_q5
print mf_ss_icmin_q5
print mf_su_vcemax_q6
print mf_su_vcemin_q6
print mf_ss_vcemax_q6
print mf_ss_vcemin_q6
print mf_su_vbemax_q6
print mf_su_vbemin_q6
print mf_ss_vbemax_q6
print mf_ss_vbemin_q6
print mf_su_icmax_q6
print mf_su_icmin_q6
print mf_ss_icmax_q6
print mf_ss_icmin_q6
print mf_su_sinkmin_tail
print mf_ss_sinkmin_tail
linearize
let mf_l = length(time)
let mfw = (time ge 1.99995e-08) * (time lt 3.99995e-08)
let mf_n = mean(mfw) * mf_l
let mfs = mf_l / mf_n
let mf_prail = mean(v(vdd) * (0 - i(vdd)) * mfw) * mfs
let mfph = 2 * pi * 18450000000.0 * (time - 2e-08)
let mf_lodiff_re = 2 * mean((v(lo_p)-v(lo_n)) * mfw * cos(mfph)) * mfs
let mf_lodiff_im = 2 * mean((v(lo_p)-v(lo_n)) * mfw * sin(mfph)) * mfs
let mfph = 2 * pi * 1000000000.0 * (time - 2e-08)
let mf_if_re = 2 * mean((v(if_out)) * mfw * cos(mfph)) * mfs
let mf_if_im = 2 * mean((v(if_out)) * mfw * sin(mfph)) * mfs
let mfph = 2 * pi * 18450000000.0 * (time - 2e-08)
let mf_loif_re = 2 * mean((v(if_out)) * mfw * cos(mfph)) * mfs
let mf_loif_im = 2 * mean((v(if_out)) * mfw * sin(mfph)) * mfs
let mfph = 2 * pi * 18450000000.0 * (time - 2e-08)
let mf_lorf_re = 2 * mean((v(rf_port)) * mfw * cos(mfph)) * mfs
let mf_lorf_im = 2 * mean((v(rf_port)) * mfw * sin(mfph)) * mfs
let mfph = 2 * pi * 950000000.0 * (time - 2e-08)
let mf_flifa_re = 2 * mean((v(if_out)) * mfw * cos(mfph)) * mfs
let mf_flifa_im = 2 * mean((v(if_out)) * mfw * sin(mfph)) * mfs
let mfph = 2 * pi * 1050000000.0 * (time - 2e-08)
let mf_flifb_re = 2 * mean((v(if_out)) * mfw * cos(mfph)) * mfs
let mf_flifb_im = 2 * mean((v(if_out)) * mfw * sin(mfph)) * mfs
let mfph = 2 * pi * 18500000000.0 * (time - 2e-08)
let mf_fllorf_re = 2 * mean((v(rf_port)) * mfw * cos(mfph)) * mfs
let mf_fllorf_im = 2 * mean((v(rf_port)) * mfw * sin(mfph)) * mfs
let mfph = 2 * pi * 18500000000.0 * (time - 2e-08)
let mf_flloif_re = 2 * mean((v(if_out)) * mfw * cos(mfph)) * mfs
let mf_flloif_im = 2 * mean((v(if_out)) * mfw * sin(mfph)) * mfs
print mf_l
print mf_n
print mf_prail
print mf_lodiff_re
print mf_lodiff_im
print mf_if_re
print mf_if_im
print mf_loif_re
print mf_loif_im
print mf_lorf_re
print mf_lorf_im
print mf_flifa_re
print mf_flifa_im
print mf_flifb_re
print mf_flifb_im
print mf_fllorf_re
print mf_fllorf_im
print mf_flloif_re
print mf_flloif_im
destroy all
echo "MFEND ls_f19p45_m9_rf60"
echo "MFRUN ls_f19p45_m9_rf66"
alterparam f1 = 19450000000.0
alterparam f2 = 19450000000.0
alterparam flo = 18450000000.0
alterparam vrf1 = 0.00031697863849222284
alterparam vrf2 = 0.0
alterparam vlo = 0.31735474306134676
reset
op
let mf_dcirail = 0 - i(vdd)
let mf_dc_vce_q1 = v(c_q1)-v(e_q1)
let mf_dc_vbe_q1 = v(b_q1)-v(e_q1)
let mf_dc_ic_q1 = i(vic_q1)
let mf_dc_vce_q2 = v(c_q2)-v(e_q2)
let mf_dc_vbe_q2 = v(b_q2)-v(e_q2)
let mf_dc_ic_q2 = i(vic_q2)
let mf_dc_vce_q3 = v(c_q3)-v(x1)
let mf_dc_vbe_q3 = v(lo_p)-v(x1)
let mf_dc_ic_q3 = i(vic_q3)
let mf_dc_vce_q4 = v(c_q4)-v(x1)
let mf_dc_vbe_q4 = v(lo_n)-v(x1)
let mf_dc_ic_q4 = i(vic_q4)
let mf_dc_vce_q5 = v(c_q5)-v(x2)
let mf_dc_vbe_q5 = v(lo_p)-v(x2)
let mf_dc_ic_q5 = i(vic_q5)
let mf_dc_vce_q6 = v(c_q6)-v(x2)
let mf_dc_vbe_q6 = v(lo_n)-v(x2)
let mf_dc_ic_q6 = i(vic_q6)
let mf_dc_sink_tail = v(tail)
print mf_dcirail
print mf_dc_vce_q1
print mf_dc_vbe_q1
print mf_dc_ic_q1
print mf_dc_vce_q2
print mf_dc_vbe_q2
print mf_dc_ic_q2
print mf_dc_vce_q3
print mf_dc_vbe_q3
print mf_dc_ic_q3
print mf_dc_vce_q4
print mf_dc_vbe_q4
print mf_dc_ic_q4
print mf_dc_vce_q5
print mf_dc_vbe_q5
print mf_dc_ic_q5
print mf_dc_vce_q6
print mf_dc_vbe_q6
print mf_dc_ic_q6
print mf_dc_sink_tail
tran 1e-12 4e-08 0 1e-12
let mfq_vce_q1 = v(c_q1)-v(e_q1)
meas tran mf_su_vcemax_q1 MAX mfq_vce_q1 from=0.0 to=2e-08
meas tran mf_su_vcemin_q1 MIN mfq_vce_q1 from=0.0 to=2e-08
meas tran mf_ss_vcemax_q1 MAX mfq_vce_q1 from=2e-08 to=4e-08
meas tran mf_ss_vcemin_q1 MIN mfq_vce_q1 from=2e-08 to=4e-08
let mfq_vbe_q1 = v(b_q1)-v(e_q1)
meas tran mf_su_vbemax_q1 MAX mfq_vbe_q1 from=0.0 to=2e-08
meas tran mf_su_vbemin_q1 MIN mfq_vbe_q1 from=0.0 to=2e-08
meas tran mf_ss_vbemax_q1 MAX mfq_vbe_q1 from=2e-08 to=4e-08
meas tran mf_ss_vbemin_q1 MIN mfq_vbe_q1 from=2e-08 to=4e-08
let mfq_ic_q1 = i(vic_q1)
meas tran mf_su_icmax_q1 MAX mfq_ic_q1 from=0.0 to=2e-08
meas tran mf_su_icmin_q1 MIN mfq_ic_q1 from=0.0 to=2e-08
meas tran mf_ss_icmax_q1 MAX mfq_ic_q1 from=2e-08 to=4e-08
meas tran mf_ss_icmin_q1 MIN mfq_ic_q1 from=2e-08 to=4e-08
let mfq_vce_q2 = v(c_q2)-v(e_q2)
meas tran mf_su_vcemax_q2 MAX mfq_vce_q2 from=0.0 to=2e-08
meas tran mf_su_vcemin_q2 MIN mfq_vce_q2 from=0.0 to=2e-08
meas tran mf_ss_vcemax_q2 MAX mfq_vce_q2 from=2e-08 to=4e-08
meas tran mf_ss_vcemin_q2 MIN mfq_vce_q2 from=2e-08 to=4e-08
let mfq_vbe_q2 = v(b_q2)-v(e_q2)
meas tran mf_su_vbemax_q2 MAX mfq_vbe_q2 from=0.0 to=2e-08
meas tran mf_su_vbemin_q2 MIN mfq_vbe_q2 from=0.0 to=2e-08
meas tran mf_ss_vbemax_q2 MAX mfq_vbe_q2 from=2e-08 to=4e-08
meas tran mf_ss_vbemin_q2 MIN mfq_vbe_q2 from=2e-08 to=4e-08
let mfq_ic_q2 = i(vic_q2)
meas tran mf_su_icmax_q2 MAX mfq_ic_q2 from=0.0 to=2e-08
meas tran mf_su_icmin_q2 MIN mfq_ic_q2 from=0.0 to=2e-08
meas tran mf_ss_icmax_q2 MAX mfq_ic_q2 from=2e-08 to=4e-08
meas tran mf_ss_icmin_q2 MIN mfq_ic_q2 from=2e-08 to=4e-08
let mfq_vce_q3 = v(c_q3)-v(x1)
meas tran mf_su_vcemax_q3 MAX mfq_vce_q3 from=0.0 to=2e-08
meas tran mf_su_vcemin_q3 MIN mfq_vce_q3 from=0.0 to=2e-08
meas tran mf_ss_vcemax_q3 MAX mfq_vce_q3 from=2e-08 to=4e-08
meas tran mf_ss_vcemin_q3 MIN mfq_vce_q3 from=2e-08 to=4e-08
let mfq_vbe_q3 = v(lo_p)-v(x1)
meas tran mf_su_vbemax_q3 MAX mfq_vbe_q3 from=0.0 to=2e-08
meas tran mf_su_vbemin_q3 MIN mfq_vbe_q3 from=0.0 to=2e-08
meas tran mf_ss_vbemax_q3 MAX mfq_vbe_q3 from=2e-08 to=4e-08
meas tran mf_ss_vbemin_q3 MIN mfq_vbe_q3 from=2e-08 to=4e-08
let mfq_ic_q3 = i(vic_q3)
meas tran mf_su_icmax_q3 MAX mfq_ic_q3 from=0.0 to=2e-08
meas tran mf_su_icmin_q3 MIN mfq_ic_q3 from=0.0 to=2e-08
meas tran mf_ss_icmax_q3 MAX mfq_ic_q3 from=2e-08 to=4e-08
meas tran mf_ss_icmin_q3 MIN mfq_ic_q3 from=2e-08 to=4e-08
let mfq_vce_q4 = v(c_q4)-v(x1)
meas tran mf_su_vcemax_q4 MAX mfq_vce_q4 from=0.0 to=2e-08
meas tran mf_su_vcemin_q4 MIN mfq_vce_q4 from=0.0 to=2e-08
meas tran mf_ss_vcemax_q4 MAX mfq_vce_q4 from=2e-08 to=4e-08
meas tran mf_ss_vcemin_q4 MIN mfq_vce_q4 from=2e-08 to=4e-08
let mfq_vbe_q4 = v(lo_n)-v(x1)
meas tran mf_su_vbemax_q4 MAX mfq_vbe_q4 from=0.0 to=2e-08
meas tran mf_su_vbemin_q4 MIN mfq_vbe_q4 from=0.0 to=2e-08
meas tran mf_ss_vbemax_q4 MAX mfq_vbe_q4 from=2e-08 to=4e-08
meas tran mf_ss_vbemin_q4 MIN mfq_vbe_q4 from=2e-08 to=4e-08
let mfq_ic_q4 = i(vic_q4)
meas tran mf_su_icmax_q4 MAX mfq_ic_q4 from=0.0 to=2e-08
meas tran mf_su_icmin_q4 MIN mfq_ic_q4 from=0.0 to=2e-08
meas tran mf_ss_icmax_q4 MAX mfq_ic_q4 from=2e-08 to=4e-08
meas tran mf_ss_icmin_q4 MIN mfq_ic_q4 from=2e-08 to=4e-08
let mfq_vce_q5 = v(c_q5)-v(x2)
meas tran mf_su_vcemax_q5 MAX mfq_vce_q5 from=0.0 to=2e-08
meas tran mf_su_vcemin_q5 MIN mfq_vce_q5 from=0.0 to=2e-08
meas tran mf_ss_vcemax_q5 MAX mfq_vce_q5 from=2e-08 to=4e-08
meas tran mf_ss_vcemin_q5 MIN mfq_vce_q5 from=2e-08 to=4e-08
let mfq_vbe_q5 = v(lo_p)-v(x2)
meas tran mf_su_vbemax_q5 MAX mfq_vbe_q5 from=0.0 to=2e-08
meas tran mf_su_vbemin_q5 MIN mfq_vbe_q5 from=0.0 to=2e-08
meas tran mf_ss_vbemax_q5 MAX mfq_vbe_q5 from=2e-08 to=4e-08
meas tran mf_ss_vbemin_q5 MIN mfq_vbe_q5 from=2e-08 to=4e-08
let mfq_ic_q5 = i(vic_q5)
meas tran mf_su_icmax_q5 MAX mfq_ic_q5 from=0.0 to=2e-08
meas tran mf_su_icmin_q5 MIN mfq_ic_q5 from=0.0 to=2e-08
meas tran mf_ss_icmax_q5 MAX mfq_ic_q5 from=2e-08 to=4e-08
meas tran mf_ss_icmin_q5 MIN mfq_ic_q5 from=2e-08 to=4e-08
let mfq_vce_q6 = v(c_q6)-v(x2)
meas tran mf_su_vcemax_q6 MAX mfq_vce_q6 from=0.0 to=2e-08
meas tran mf_su_vcemin_q6 MIN mfq_vce_q6 from=0.0 to=2e-08
meas tran mf_ss_vcemax_q6 MAX mfq_vce_q6 from=2e-08 to=4e-08
meas tran mf_ss_vcemin_q6 MIN mfq_vce_q6 from=2e-08 to=4e-08
let mfq_vbe_q6 = v(lo_n)-v(x2)
meas tran mf_su_vbemax_q6 MAX mfq_vbe_q6 from=0.0 to=2e-08
meas tran mf_su_vbemin_q6 MIN mfq_vbe_q6 from=0.0 to=2e-08
meas tran mf_ss_vbemax_q6 MAX mfq_vbe_q6 from=2e-08 to=4e-08
meas tran mf_ss_vbemin_q6 MIN mfq_vbe_q6 from=2e-08 to=4e-08
let mfq_ic_q6 = i(vic_q6)
meas tran mf_su_icmax_q6 MAX mfq_ic_q6 from=0.0 to=2e-08
meas tran mf_su_icmin_q6 MIN mfq_ic_q6 from=0.0 to=2e-08
meas tran mf_ss_icmax_q6 MAX mfq_ic_q6 from=2e-08 to=4e-08
meas tran mf_ss_icmin_q6 MIN mfq_ic_q6 from=2e-08 to=4e-08
meas tran mf_su_sinkmin_tail MIN v(tail) from=0.0 to=2e-08
meas tran mf_ss_sinkmin_tail MIN v(tail) from=2e-08 to=4e-08
print mf_su_vcemax_q1
print mf_su_vcemin_q1
print mf_ss_vcemax_q1
print mf_ss_vcemin_q1
print mf_su_vbemax_q1
print mf_su_vbemin_q1
print mf_ss_vbemax_q1
print mf_ss_vbemin_q1
print mf_su_icmax_q1
print mf_su_icmin_q1
print mf_ss_icmax_q1
print mf_ss_icmin_q1
print mf_su_vcemax_q2
print mf_su_vcemin_q2
print mf_ss_vcemax_q2
print mf_ss_vcemin_q2
print mf_su_vbemax_q2
print mf_su_vbemin_q2
print mf_ss_vbemax_q2
print mf_ss_vbemin_q2
print mf_su_icmax_q2
print mf_su_icmin_q2
print mf_ss_icmax_q2
print mf_ss_icmin_q2
print mf_su_vcemax_q3
print mf_su_vcemin_q3
print mf_ss_vcemax_q3
print mf_ss_vcemin_q3
print mf_su_vbemax_q3
print mf_su_vbemin_q3
print mf_ss_vbemax_q3
print mf_ss_vbemin_q3
print mf_su_icmax_q3
print mf_su_icmin_q3
print mf_ss_icmax_q3
print mf_ss_icmin_q3
print mf_su_vcemax_q4
print mf_su_vcemin_q4
print mf_ss_vcemax_q4
print mf_ss_vcemin_q4
print mf_su_vbemax_q4
print mf_su_vbemin_q4
print mf_ss_vbemax_q4
print mf_ss_vbemin_q4
print mf_su_icmax_q4
print mf_su_icmin_q4
print mf_ss_icmax_q4
print mf_ss_icmin_q4
print mf_su_vcemax_q5
print mf_su_vcemin_q5
print mf_ss_vcemax_q5
print mf_ss_vcemin_q5
print mf_su_vbemax_q5
print mf_su_vbemin_q5
print mf_ss_vbemax_q5
print mf_ss_vbemin_q5
print mf_su_icmax_q5
print mf_su_icmin_q5
print mf_ss_icmax_q5
print mf_ss_icmin_q5
print mf_su_vcemax_q6
print mf_su_vcemin_q6
print mf_ss_vcemax_q6
print mf_ss_vcemin_q6
print mf_su_vbemax_q6
print mf_su_vbemin_q6
print mf_ss_vbemax_q6
print mf_ss_vbemin_q6
print mf_su_icmax_q6
print mf_su_icmin_q6
print mf_ss_icmax_q6
print mf_ss_icmin_q6
print mf_su_sinkmin_tail
print mf_ss_sinkmin_tail
linearize
let mf_l = length(time)
let mfw = (time ge 1.99995e-08) * (time lt 3.99995e-08)
let mf_n = mean(mfw) * mf_l
let mfs = mf_l / mf_n
let mf_prail = mean(v(vdd) * (0 - i(vdd)) * mfw) * mfs
let mfph = 2 * pi * 18450000000.0 * (time - 2e-08)
let mf_lodiff_re = 2 * mean((v(lo_p)-v(lo_n)) * mfw * cos(mfph)) * mfs
let mf_lodiff_im = 2 * mean((v(lo_p)-v(lo_n)) * mfw * sin(mfph)) * mfs
let mfph = 2 * pi * 1000000000.0 * (time - 2e-08)
let mf_if_re = 2 * mean((v(if_out)) * mfw * cos(mfph)) * mfs
let mf_if_im = 2 * mean((v(if_out)) * mfw * sin(mfph)) * mfs
let mfph = 2 * pi * 18450000000.0 * (time - 2e-08)
let mf_loif_re = 2 * mean((v(if_out)) * mfw * cos(mfph)) * mfs
let mf_loif_im = 2 * mean((v(if_out)) * mfw * sin(mfph)) * mfs
let mfph = 2 * pi * 18450000000.0 * (time - 2e-08)
let mf_lorf_re = 2 * mean((v(rf_port)) * mfw * cos(mfph)) * mfs
let mf_lorf_im = 2 * mean((v(rf_port)) * mfw * sin(mfph)) * mfs
let mfph = 2 * pi * 950000000.0 * (time - 2e-08)
let mf_flifa_re = 2 * mean((v(if_out)) * mfw * cos(mfph)) * mfs
let mf_flifa_im = 2 * mean((v(if_out)) * mfw * sin(mfph)) * mfs
let mfph = 2 * pi * 1050000000.0 * (time - 2e-08)
let mf_flifb_re = 2 * mean((v(if_out)) * mfw * cos(mfph)) * mfs
let mf_flifb_im = 2 * mean((v(if_out)) * mfw * sin(mfph)) * mfs
let mfph = 2 * pi * 18500000000.0 * (time - 2e-08)
let mf_fllorf_re = 2 * mean((v(rf_port)) * mfw * cos(mfph)) * mfs
let mf_fllorf_im = 2 * mean((v(rf_port)) * mfw * sin(mfph)) * mfs
let mfph = 2 * pi * 18500000000.0 * (time - 2e-08)
let mf_flloif_re = 2 * mean((v(if_out)) * mfw * cos(mfph)) * mfs
let mf_flloif_im = 2 * mean((v(if_out)) * mfw * sin(mfph)) * mfs
print mf_l
print mf_n
print mf_prail
print mf_lodiff_re
print mf_lodiff_im
print mf_if_re
print mf_if_im
print mf_loif_re
print mf_loif_im
print mf_lorf_re
print mf_lorf_im
print mf_flifa_re
print mf_flifa_im
print mf_flifb_re
print mf_flifb_im
print mf_fllorf_re
print mf_fllorf_im
print mf_flloif_re
print mf_flloif_im
destroy all
echo "MFEND ls_f19p45_m9_rf66"
echo "MFRUN ls_f19p45_m6_rf60"
alterparam f1 = 19450000000.0
alterparam f2 = 19450000000.0
alterparam flo = 18450000000.0
alterparam vrf1 = 0.0006324555320336759
alterparam vrf2 = 0.0
alterparam vlo = 0.44827548953825974
reset
op
let mf_dcirail = 0 - i(vdd)
let mf_dc_vce_q1 = v(c_q1)-v(e_q1)
let mf_dc_vbe_q1 = v(b_q1)-v(e_q1)
let mf_dc_ic_q1 = i(vic_q1)
let mf_dc_vce_q2 = v(c_q2)-v(e_q2)
let mf_dc_vbe_q2 = v(b_q2)-v(e_q2)
let mf_dc_ic_q2 = i(vic_q2)
let mf_dc_vce_q3 = v(c_q3)-v(x1)
let mf_dc_vbe_q3 = v(lo_p)-v(x1)
let mf_dc_ic_q3 = i(vic_q3)
let mf_dc_vce_q4 = v(c_q4)-v(x1)
let mf_dc_vbe_q4 = v(lo_n)-v(x1)
let mf_dc_ic_q4 = i(vic_q4)
let mf_dc_vce_q5 = v(c_q5)-v(x2)
let mf_dc_vbe_q5 = v(lo_p)-v(x2)
let mf_dc_ic_q5 = i(vic_q5)
let mf_dc_vce_q6 = v(c_q6)-v(x2)
let mf_dc_vbe_q6 = v(lo_n)-v(x2)
let mf_dc_ic_q6 = i(vic_q6)
let mf_dc_sink_tail = v(tail)
print mf_dcirail
print mf_dc_vce_q1
print mf_dc_vbe_q1
print mf_dc_ic_q1
print mf_dc_vce_q2
print mf_dc_vbe_q2
print mf_dc_ic_q2
print mf_dc_vce_q3
print mf_dc_vbe_q3
print mf_dc_ic_q3
print mf_dc_vce_q4
print mf_dc_vbe_q4
print mf_dc_ic_q4
print mf_dc_vce_q5
print mf_dc_vbe_q5
print mf_dc_ic_q5
print mf_dc_vce_q6
print mf_dc_vbe_q6
print mf_dc_ic_q6
print mf_dc_sink_tail
tran 1e-12 4e-08 0 1e-12
let mfq_vce_q1 = v(c_q1)-v(e_q1)
meas tran mf_su_vcemax_q1 MAX mfq_vce_q1 from=0.0 to=2e-08
meas tran mf_su_vcemin_q1 MIN mfq_vce_q1 from=0.0 to=2e-08
meas tran mf_ss_vcemax_q1 MAX mfq_vce_q1 from=2e-08 to=4e-08
meas tran mf_ss_vcemin_q1 MIN mfq_vce_q1 from=2e-08 to=4e-08
let mfq_vbe_q1 = v(b_q1)-v(e_q1)
meas tran mf_su_vbemax_q1 MAX mfq_vbe_q1 from=0.0 to=2e-08
meas tran mf_su_vbemin_q1 MIN mfq_vbe_q1 from=0.0 to=2e-08
meas tran mf_ss_vbemax_q1 MAX mfq_vbe_q1 from=2e-08 to=4e-08
meas tran mf_ss_vbemin_q1 MIN mfq_vbe_q1 from=2e-08 to=4e-08
let mfq_ic_q1 = i(vic_q1)
meas tran mf_su_icmax_q1 MAX mfq_ic_q1 from=0.0 to=2e-08
meas tran mf_su_icmin_q1 MIN mfq_ic_q1 from=0.0 to=2e-08
meas tran mf_ss_icmax_q1 MAX mfq_ic_q1 from=2e-08 to=4e-08
meas tran mf_ss_icmin_q1 MIN mfq_ic_q1 from=2e-08 to=4e-08
let mfq_vce_q2 = v(c_q2)-v(e_q2)
meas tran mf_su_vcemax_q2 MAX mfq_vce_q2 from=0.0 to=2e-08
meas tran mf_su_vcemin_q2 MIN mfq_vce_q2 from=0.0 to=2e-08
meas tran mf_ss_vcemax_q2 MAX mfq_vce_q2 from=2e-08 to=4e-08
meas tran mf_ss_vcemin_q2 MIN mfq_vce_q2 from=2e-08 to=4e-08
let mfq_vbe_q2 = v(b_q2)-v(e_q2)
meas tran mf_su_vbemax_q2 MAX mfq_vbe_q2 from=0.0 to=2e-08
meas tran mf_su_vbemin_q2 MIN mfq_vbe_q2 from=0.0 to=2e-08
meas tran mf_ss_vbemax_q2 MAX mfq_vbe_q2 from=2e-08 to=4e-08
meas tran mf_ss_vbemin_q2 MIN mfq_vbe_q2 from=2e-08 to=4e-08
let mfq_ic_q2 = i(vic_q2)
meas tran mf_su_icmax_q2 MAX mfq_ic_q2 from=0.0 to=2e-08
meas tran mf_su_icmin_q2 MIN mfq_ic_q2 from=0.0 to=2e-08
meas tran mf_ss_icmax_q2 MAX mfq_ic_q2 from=2e-08 to=4e-08
meas tran mf_ss_icmin_q2 MIN mfq_ic_q2 from=2e-08 to=4e-08
let mfq_vce_q3 = v(c_q3)-v(x1)
meas tran mf_su_vcemax_q3 MAX mfq_vce_q3 from=0.0 to=2e-08
meas tran mf_su_vcemin_q3 MIN mfq_vce_q3 from=0.0 to=2e-08
meas tran mf_ss_vcemax_q3 MAX mfq_vce_q3 from=2e-08 to=4e-08
meas tran mf_ss_vcemin_q3 MIN mfq_vce_q3 from=2e-08 to=4e-08
let mfq_vbe_q3 = v(lo_p)-v(x1)
meas tran mf_su_vbemax_q3 MAX mfq_vbe_q3 from=0.0 to=2e-08
meas tran mf_su_vbemin_q3 MIN mfq_vbe_q3 from=0.0 to=2e-08
meas tran mf_ss_vbemax_q3 MAX mfq_vbe_q3 from=2e-08 to=4e-08
meas tran mf_ss_vbemin_q3 MIN mfq_vbe_q3 from=2e-08 to=4e-08
let mfq_ic_q3 = i(vic_q3)
meas tran mf_su_icmax_q3 MAX mfq_ic_q3 from=0.0 to=2e-08
meas tran mf_su_icmin_q3 MIN mfq_ic_q3 from=0.0 to=2e-08
meas tran mf_ss_icmax_q3 MAX mfq_ic_q3 from=2e-08 to=4e-08
meas tran mf_ss_icmin_q3 MIN mfq_ic_q3 from=2e-08 to=4e-08
let mfq_vce_q4 = v(c_q4)-v(x1)
meas tran mf_su_vcemax_q4 MAX mfq_vce_q4 from=0.0 to=2e-08
meas tran mf_su_vcemin_q4 MIN mfq_vce_q4 from=0.0 to=2e-08
meas tran mf_ss_vcemax_q4 MAX mfq_vce_q4 from=2e-08 to=4e-08
meas tran mf_ss_vcemin_q4 MIN mfq_vce_q4 from=2e-08 to=4e-08
let mfq_vbe_q4 = v(lo_n)-v(x1)
meas tran mf_su_vbemax_q4 MAX mfq_vbe_q4 from=0.0 to=2e-08
meas tran mf_su_vbemin_q4 MIN mfq_vbe_q4 from=0.0 to=2e-08
meas tran mf_ss_vbemax_q4 MAX mfq_vbe_q4 from=2e-08 to=4e-08
meas tran mf_ss_vbemin_q4 MIN mfq_vbe_q4 from=2e-08 to=4e-08
let mfq_ic_q4 = i(vic_q4)
meas tran mf_su_icmax_q4 MAX mfq_ic_q4 from=0.0 to=2e-08
meas tran mf_su_icmin_q4 MIN mfq_ic_q4 from=0.0 to=2e-08
meas tran mf_ss_icmax_q4 MAX mfq_ic_q4 from=2e-08 to=4e-08
meas tran mf_ss_icmin_q4 MIN mfq_ic_q4 from=2e-08 to=4e-08
let mfq_vce_q5 = v(c_q5)-v(x2)
meas tran mf_su_vcemax_q5 MAX mfq_vce_q5 from=0.0 to=2e-08
meas tran mf_su_vcemin_q5 MIN mfq_vce_q5 from=0.0 to=2e-08
meas tran mf_ss_vcemax_q5 MAX mfq_vce_q5 from=2e-08 to=4e-08
meas tran mf_ss_vcemin_q5 MIN mfq_vce_q5 from=2e-08 to=4e-08
let mfq_vbe_q5 = v(lo_p)-v(x2)
meas tran mf_su_vbemax_q5 MAX mfq_vbe_q5 from=0.0 to=2e-08
meas tran mf_su_vbemin_q5 MIN mfq_vbe_q5 from=0.0 to=2e-08
meas tran mf_ss_vbemax_q5 MAX mfq_vbe_q5 from=2e-08 to=4e-08
meas tran mf_ss_vbemin_q5 MIN mfq_vbe_q5 from=2e-08 to=4e-08
let mfq_ic_q5 = i(vic_q5)
meas tran mf_su_icmax_q5 MAX mfq_ic_q5 from=0.0 to=2e-08
meas tran mf_su_icmin_q5 MIN mfq_ic_q5 from=0.0 to=2e-08
meas tran mf_ss_icmax_q5 MAX mfq_ic_q5 from=2e-08 to=4e-08
meas tran mf_ss_icmin_q5 MIN mfq_ic_q5 from=2e-08 to=4e-08
let mfq_vce_q6 = v(c_q6)-v(x2)
meas tran mf_su_vcemax_q6 MAX mfq_vce_q6 from=0.0 to=2e-08
meas tran mf_su_vcemin_q6 MIN mfq_vce_q6 from=0.0 to=2e-08
meas tran mf_ss_vcemax_q6 MAX mfq_vce_q6 from=2e-08 to=4e-08
meas tran mf_ss_vcemin_q6 MIN mfq_vce_q6 from=2e-08 to=4e-08
let mfq_vbe_q6 = v(lo_n)-v(x2)
meas tran mf_su_vbemax_q6 MAX mfq_vbe_q6 from=0.0 to=2e-08
meas tran mf_su_vbemin_q6 MIN mfq_vbe_q6 from=0.0 to=2e-08
meas tran mf_ss_vbemax_q6 MAX mfq_vbe_q6 from=2e-08 to=4e-08
meas tran mf_ss_vbemin_q6 MIN mfq_vbe_q6 from=2e-08 to=4e-08
let mfq_ic_q6 = i(vic_q6)
meas tran mf_su_icmax_q6 MAX mfq_ic_q6 from=0.0 to=2e-08
meas tran mf_su_icmin_q6 MIN mfq_ic_q6 from=0.0 to=2e-08
meas tran mf_ss_icmax_q6 MAX mfq_ic_q6 from=2e-08 to=4e-08
meas tran mf_ss_icmin_q6 MIN mfq_ic_q6 from=2e-08 to=4e-08
meas tran mf_su_sinkmin_tail MIN v(tail) from=0.0 to=2e-08
meas tran mf_ss_sinkmin_tail MIN v(tail) from=2e-08 to=4e-08
print mf_su_vcemax_q1
print mf_su_vcemin_q1
print mf_ss_vcemax_q1
print mf_ss_vcemin_q1
print mf_su_vbemax_q1
print mf_su_vbemin_q1
print mf_ss_vbemax_q1
print mf_ss_vbemin_q1
print mf_su_icmax_q1
print mf_su_icmin_q1
print mf_ss_icmax_q1
print mf_ss_icmin_q1
print mf_su_vcemax_q2
print mf_su_vcemin_q2
print mf_ss_vcemax_q2
print mf_ss_vcemin_q2
print mf_su_vbemax_q2
print mf_su_vbemin_q2
print mf_ss_vbemax_q2
print mf_ss_vbemin_q2
print mf_su_icmax_q2
print mf_su_icmin_q2
print mf_ss_icmax_q2
print mf_ss_icmin_q2
print mf_su_vcemax_q3
print mf_su_vcemin_q3
print mf_ss_vcemax_q3
print mf_ss_vcemin_q3
print mf_su_vbemax_q3
print mf_su_vbemin_q3
print mf_ss_vbemax_q3
print mf_ss_vbemin_q3
print mf_su_icmax_q3
print mf_su_icmin_q3
print mf_ss_icmax_q3
print mf_ss_icmin_q3
print mf_su_vcemax_q4
print mf_su_vcemin_q4
print mf_ss_vcemax_q4
print mf_ss_vcemin_q4
print mf_su_vbemax_q4
print mf_su_vbemin_q4
print mf_ss_vbemax_q4
print mf_ss_vbemin_q4
print mf_su_icmax_q4
print mf_su_icmin_q4
print mf_ss_icmax_q4
print mf_ss_icmin_q4
print mf_su_vcemax_q5
print mf_su_vcemin_q5
print mf_ss_vcemax_q5
print mf_ss_vcemin_q5
print mf_su_vbemax_q5
print mf_su_vbemin_q5
print mf_ss_vbemax_q5
print mf_ss_vbemin_q5
print mf_su_icmax_q5
print mf_su_icmin_q5
print mf_ss_icmax_q5
print mf_ss_icmin_q5
print mf_su_vcemax_q6
print mf_su_vcemin_q6
print mf_ss_vcemax_q6
print mf_ss_vcemin_q6
print mf_su_vbemax_q6
print mf_su_vbemin_q6
print mf_ss_vbemax_q6
print mf_ss_vbemin_q6
print mf_su_icmax_q6
print mf_su_icmin_q6
print mf_ss_icmax_q6
print mf_ss_icmin_q6
print mf_su_sinkmin_tail
print mf_ss_sinkmin_tail
linearize
let mf_l = length(time)
let mfw = (time ge 1.99995e-08) * (time lt 3.99995e-08)
let mf_n = mean(mfw) * mf_l
let mfs = mf_l / mf_n
let mf_prail = mean(v(vdd) * (0 - i(vdd)) * mfw) * mfs
let mfph = 2 * pi * 18450000000.0 * (time - 2e-08)
let mf_lodiff_re = 2 * mean((v(lo_p)-v(lo_n)) * mfw * cos(mfph)) * mfs
let mf_lodiff_im = 2 * mean((v(lo_p)-v(lo_n)) * mfw * sin(mfph)) * mfs
let mfph = 2 * pi * 1000000000.0 * (time - 2e-08)
let mf_if_re = 2 * mean((v(if_out)) * mfw * cos(mfph)) * mfs
let mf_if_im = 2 * mean((v(if_out)) * mfw * sin(mfph)) * mfs
let mfph = 2 * pi * 18450000000.0 * (time - 2e-08)
let mf_loif_re = 2 * mean((v(if_out)) * mfw * cos(mfph)) * mfs
let mf_loif_im = 2 * mean((v(if_out)) * mfw * sin(mfph)) * mfs
let mfph = 2 * pi * 18450000000.0 * (time - 2e-08)
let mf_lorf_re = 2 * mean((v(rf_port)) * mfw * cos(mfph)) * mfs
let mf_lorf_im = 2 * mean((v(rf_port)) * mfw * sin(mfph)) * mfs
let mfph = 2 * pi * 950000000.0 * (time - 2e-08)
let mf_flifa_re = 2 * mean((v(if_out)) * mfw * cos(mfph)) * mfs
let mf_flifa_im = 2 * mean((v(if_out)) * mfw * sin(mfph)) * mfs
let mfph = 2 * pi * 1050000000.0 * (time - 2e-08)
let mf_flifb_re = 2 * mean((v(if_out)) * mfw * cos(mfph)) * mfs
let mf_flifb_im = 2 * mean((v(if_out)) * mfw * sin(mfph)) * mfs
let mfph = 2 * pi * 18500000000.0 * (time - 2e-08)
let mf_fllorf_re = 2 * mean((v(rf_port)) * mfw * cos(mfph)) * mfs
let mf_fllorf_im = 2 * mean((v(rf_port)) * mfw * sin(mfph)) * mfs
let mfph = 2 * pi * 18500000000.0 * (time - 2e-08)
let mf_flloif_re = 2 * mean((v(if_out)) * mfw * cos(mfph)) * mfs
let mf_flloif_im = 2 * mean((v(if_out)) * mfw * sin(mfph)) * mfs
print mf_l
print mf_n
print mf_prail
print mf_lodiff_re
print mf_lodiff_im
print mf_if_re
print mf_if_im
print mf_loif_re
print mf_loif_im
print mf_lorf_re
print mf_lorf_im
print mf_flifa_re
print mf_flifa_im
print mf_flifb_re
print mf_flifb_im
print mf_fllorf_re
print mf_fllorf_im
print mf_flloif_re
print mf_flloif_im
destroy all
echo "MFEND ls_f19p45_m6_rf60"
echo "MFRUN ls_f19p45_m6_rf66"
alterparam f1 = 19450000000.0
alterparam f2 = 19450000000.0
alterparam flo = 18450000000.0
alterparam vrf1 = 0.00031697863849222284
alterparam vrf2 = 0.0
alterparam vlo = 0.44827548953825974
reset
op
let mf_dcirail = 0 - i(vdd)
let mf_dc_vce_q1 = v(c_q1)-v(e_q1)
let mf_dc_vbe_q1 = v(b_q1)-v(e_q1)
let mf_dc_ic_q1 = i(vic_q1)
let mf_dc_vce_q2 = v(c_q2)-v(e_q2)
let mf_dc_vbe_q2 = v(b_q2)-v(e_q2)
let mf_dc_ic_q2 = i(vic_q2)
let mf_dc_vce_q3 = v(c_q3)-v(x1)
let mf_dc_vbe_q3 = v(lo_p)-v(x1)
let mf_dc_ic_q3 = i(vic_q3)
let mf_dc_vce_q4 = v(c_q4)-v(x1)
let mf_dc_vbe_q4 = v(lo_n)-v(x1)
let mf_dc_ic_q4 = i(vic_q4)
let mf_dc_vce_q5 = v(c_q5)-v(x2)
let mf_dc_vbe_q5 = v(lo_p)-v(x2)
let mf_dc_ic_q5 = i(vic_q5)
let mf_dc_vce_q6 = v(c_q6)-v(x2)
let mf_dc_vbe_q6 = v(lo_n)-v(x2)
let mf_dc_ic_q6 = i(vic_q6)
let mf_dc_sink_tail = v(tail)
print mf_dcirail
print mf_dc_vce_q1
print mf_dc_vbe_q1
print mf_dc_ic_q1
print mf_dc_vce_q2
print mf_dc_vbe_q2
print mf_dc_ic_q2
print mf_dc_vce_q3
print mf_dc_vbe_q3
print mf_dc_ic_q3
print mf_dc_vce_q4
print mf_dc_vbe_q4
print mf_dc_ic_q4
print mf_dc_vce_q5
print mf_dc_vbe_q5
print mf_dc_ic_q5
print mf_dc_vce_q6
print mf_dc_vbe_q6
print mf_dc_ic_q6
print mf_dc_sink_tail
tran 1e-12 4e-08 0 1e-12
let mfq_vce_q1 = v(c_q1)-v(e_q1)
meas tran mf_su_vcemax_q1 MAX mfq_vce_q1 from=0.0 to=2e-08
meas tran mf_su_vcemin_q1 MIN mfq_vce_q1 from=0.0 to=2e-08
meas tran mf_ss_vcemax_q1 MAX mfq_vce_q1 from=2e-08 to=4e-08
meas tran mf_ss_vcemin_q1 MIN mfq_vce_q1 from=2e-08 to=4e-08
let mfq_vbe_q1 = v(b_q1)-v(e_q1)
meas tran mf_su_vbemax_q1 MAX mfq_vbe_q1 from=0.0 to=2e-08
meas tran mf_su_vbemin_q1 MIN mfq_vbe_q1 from=0.0 to=2e-08
meas tran mf_ss_vbemax_q1 MAX mfq_vbe_q1 from=2e-08 to=4e-08
meas tran mf_ss_vbemin_q1 MIN mfq_vbe_q1 from=2e-08 to=4e-08
let mfq_ic_q1 = i(vic_q1)
meas tran mf_su_icmax_q1 MAX mfq_ic_q1 from=0.0 to=2e-08
meas tran mf_su_icmin_q1 MIN mfq_ic_q1 from=0.0 to=2e-08
meas tran mf_ss_icmax_q1 MAX mfq_ic_q1 from=2e-08 to=4e-08
meas tran mf_ss_icmin_q1 MIN mfq_ic_q1 from=2e-08 to=4e-08
let mfq_vce_q2 = v(c_q2)-v(e_q2)
meas tran mf_su_vcemax_q2 MAX mfq_vce_q2 from=0.0 to=2e-08
meas tran mf_su_vcemin_q2 MIN mfq_vce_q2 from=0.0 to=2e-08
meas tran mf_ss_vcemax_q2 MAX mfq_vce_q2 from=2e-08 to=4e-08
meas tran mf_ss_vcemin_q2 MIN mfq_vce_q2 from=2e-08 to=4e-08
let mfq_vbe_q2 = v(b_q2)-v(e_q2)
meas tran mf_su_vbemax_q2 MAX mfq_vbe_q2 from=0.0 to=2e-08
meas tran mf_su_vbemin_q2 MIN mfq_vbe_q2 from=0.0 to=2e-08
meas tran mf_ss_vbemax_q2 MAX mfq_vbe_q2 from=2e-08 to=4e-08
meas tran mf_ss_vbemin_q2 MIN mfq_vbe_q2 from=2e-08 to=4e-08
let mfq_ic_q2 = i(vic_q2)
meas tran mf_su_icmax_q2 MAX mfq_ic_q2 from=0.0 to=2e-08
meas tran mf_su_icmin_q2 MIN mfq_ic_q2 from=0.0 to=2e-08
meas tran mf_ss_icmax_q2 MAX mfq_ic_q2 from=2e-08 to=4e-08
meas tran mf_ss_icmin_q2 MIN mfq_ic_q2 from=2e-08 to=4e-08
let mfq_vce_q3 = v(c_q3)-v(x1)
meas tran mf_su_vcemax_q3 MAX mfq_vce_q3 from=0.0 to=2e-08
meas tran mf_su_vcemin_q3 MIN mfq_vce_q3 from=0.0 to=2e-08
meas tran mf_ss_vcemax_q3 MAX mfq_vce_q3 from=2e-08 to=4e-08
meas tran mf_ss_vcemin_q3 MIN mfq_vce_q3 from=2e-08 to=4e-08
let mfq_vbe_q3 = v(lo_p)-v(x1)
meas tran mf_su_vbemax_q3 MAX mfq_vbe_q3 from=0.0 to=2e-08
meas tran mf_su_vbemin_q3 MIN mfq_vbe_q3 from=0.0 to=2e-08
meas tran mf_ss_vbemax_q3 MAX mfq_vbe_q3 from=2e-08 to=4e-08
meas tran mf_ss_vbemin_q3 MIN mfq_vbe_q3 from=2e-08 to=4e-08
let mfq_ic_q3 = i(vic_q3)
meas tran mf_su_icmax_q3 MAX mfq_ic_q3 from=0.0 to=2e-08
meas tran mf_su_icmin_q3 MIN mfq_ic_q3 from=0.0 to=2e-08
meas tran mf_ss_icmax_q3 MAX mfq_ic_q3 from=2e-08 to=4e-08
meas tran mf_ss_icmin_q3 MIN mfq_ic_q3 from=2e-08 to=4e-08
let mfq_vce_q4 = v(c_q4)-v(x1)
meas tran mf_su_vcemax_q4 MAX mfq_vce_q4 from=0.0 to=2e-08
meas tran mf_su_vcemin_q4 MIN mfq_vce_q4 from=0.0 to=2e-08
meas tran mf_ss_vcemax_q4 MAX mfq_vce_q4 from=2e-08 to=4e-08
meas tran mf_ss_vcemin_q4 MIN mfq_vce_q4 from=2e-08 to=4e-08
let mfq_vbe_q4 = v(lo_n)-v(x1)
meas tran mf_su_vbemax_q4 MAX mfq_vbe_q4 from=0.0 to=2e-08
meas tran mf_su_vbemin_q4 MIN mfq_vbe_q4 from=0.0 to=2e-08
meas tran mf_ss_vbemax_q4 MAX mfq_vbe_q4 from=2e-08 to=4e-08
meas tran mf_ss_vbemin_q4 MIN mfq_vbe_q4 from=2e-08 to=4e-08
let mfq_ic_q4 = i(vic_q4)
meas tran mf_su_icmax_q4 MAX mfq_ic_q4 from=0.0 to=2e-08
meas tran mf_su_icmin_q4 MIN mfq_ic_q4 from=0.0 to=2e-08
meas tran mf_ss_icmax_q4 MAX mfq_ic_q4 from=2e-08 to=4e-08
meas tran mf_ss_icmin_q4 MIN mfq_ic_q4 from=2e-08 to=4e-08
let mfq_vce_q5 = v(c_q5)-v(x2)
meas tran mf_su_vcemax_q5 MAX mfq_vce_q5 from=0.0 to=2e-08
meas tran mf_su_vcemin_q5 MIN mfq_vce_q5 from=0.0 to=2e-08
meas tran mf_ss_vcemax_q5 MAX mfq_vce_q5 from=2e-08 to=4e-08
meas tran mf_ss_vcemin_q5 MIN mfq_vce_q5 from=2e-08 to=4e-08
let mfq_vbe_q5 = v(lo_p)-v(x2)
meas tran mf_su_vbemax_q5 MAX mfq_vbe_q5 from=0.0 to=2e-08
meas tran mf_su_vbemin_q5 MIN mfq_vbe_q5 from=0.0 to=2e-08
meas tran mf_ss_vbemax_q5 MAX mfq_vbe_q5 from=2e-08 to=4e-08
meas tran mf_ss_vbemin_q5 MIN mfq_vbe_q5 from=2e-08 to=4e-08
let mfq_ic_q5 = i(vic_q5)
meas tran mf_su_icmax_q5 MAX mfq_ic_q5 from=0.0 to=2e-08
meas tran mf_su_icmin_q5 MIN mfq_ic_q5 from=0.0 to=2e-08
meas tran mf_ss_icmax_q5 MAX mfq_ic_q5 from=2e-08 to=4e-08
meas tran mf_ss_icmin_q5 MIN mfq_ic_q5 from=2e-08 to=4e-08
let mfq_vce_q6 = v(c_q6)-v(x2)
meas tran mf_su_vcemax_q6 MAX mfq_vce_q6 from=0.0 to=2e-08
meas tran mf_su_vcemin_q6 MIN mfq_vce_q6 from=0.0 to=2e-08
meas tran mf_ss_vcemax_q6 MAX mfq_vce_q6 from=2e-08 to=4e-08
meas tran mf_ss_vcemin_q6 MIN mfq_vce_q6 from=2e-08 to=4e-08
let mfq_vbe_q6 = v(lo_n)-v(x2)
meas tran mf_su_vbemax_q6 MAX mfq_vbe_q6 from=0.0 to=2e-08
meas tran mf_su_vbemin_q6 MIN mfq_vbe_q6 from=0.0 to=2e-08
meas tran mf_ss_vbemax_q6 MAX mfq_vbe_q6 from=2e-08 to=4e-08
meas tran mf_ss_vbemin_q6 MIN mfq_vbe_q6 from=2e-08 to=4e-08
let mfq_ic_q6 = i(vic_q6)
meas tran mf_su_icmax_q6 MAX mfq_ic_q6 from=0.0 to=2e-08
meas tran mf_su_icmin_q6 MIN mfq_ic_q6 from=0.0 to=2e-08
meas tran mf_ss_icmax_q6 MAX mfq_ic_q6 from=2e-08 to=4e-08
meas tran mf_ss_icmin_q6 MIN mfq_ic_q6 from=2e-08 to=4e-08
meas tran mf_su_sinkmin_tail MIN v(tail) from=0.0 to=2e-08
meas tran mf_ss_sinkmin_tail MIN v(tail) from=2e-08 to=4e-08
print mf_su_vcemax_q1
print mf_su_vcemin_q1
print mf_ss_vcemax_q1
print mf_ss_vcemin_q1
print mf_su_vbemax_q1
print mf_su_vbemin_q1
print mf_ss_vbemax_q1
print mf_ss_vbemin_q1
print mf_su_icmax_q1
print mf_su_icmin_q1
print mf_ss_icmax_q1
print mf_ss_icmin_q1
print mf_su_vcemax_q2
print mf_su_vcemin_q2
print mf_ss_vcemax_q2
print mf_ss_vcemin_q2
print mf_su_vbemax_q2
print mf_su_vbemin_q2
print mf_ss_vbemax_q2
print mf_ss_vbemin_q2
print mf_su_icmax_q2
print mf_su_icmin_q2
print mf_ss_icmax_q2
print mf_ss_icmin_q2
print mf_su_vcemax_q3
print mf_su_vcemin_q3
print mf_ss_vcemax_q3
print mf_ss_vcemin_q3
print mf_su_vbemax_q3
print mf_su_vbemin_q3
print mf_ss_vbemax_q3
print mf_ss_vbemin_q3
print mf_su_icmax_q3
print mf_su_icmin_q3
print mf_ss_icmax_q3
print mf_ss_icmin_q3
print mf_su_vcemax_q4
print mf_su_vcemin_q4
print mf_ss_vcemax_q4
print mf_ss_vcemin_q4
print mf_su_vbemax_q4
print mf_su_vbemin_q4
print mf_ss_vbemax_q4
print mf_ss_vbemin_q4
print mf_su_icmax_q4
print mf_su_icmin_q4
print mf_ss_icmax_q4
print mf_ss_icmin_q4
print mf_su_vcemax_q5
print mf_su_vcemin_q5
print mf_ss_vcemax_q5
print mf_ss_vcemin_q5
print mf_su_vbemax_q5
print mf_su_vbemin_q5
print mf_ss_vbemax_q5
print mf_ss_vbemin_q5
print mf_su_icmax_q5
print mf_su_icmin_q5
print mf_ss_icmax_q5
print mf_ss_icmin_q5
print mf_su_vcemax_q6
print mf_su_vcemin_q6
print mf_ss_vcemax_q6
print mf_ss_vcemin_q6
print mf_su_vbemax_q6
print mf_su_vbemin_q6
print mf_ss_vbemax_q6
print mf_ss_vbemin_q6
print mf_su_icmax_q6
print mf_su_icmin_q6
print mf_ss_icmax_q6
print mf_ss_icmin_q6
print mf_su_sinkmin_tail
print mf_ss_sinkmin_tail
linearize
let mf_l = length(time)
let mfw = (time ge 1.99995e-08) * (time lt 3.99995e-08)
let mf_n = mean(mfw) * mf_l
let mfs = mf_l / mf_n
let mf_prail = mean(v(vdd) * (0 - i(vdd)) * mfw) * mfs
let mfph = 2 * pi * 18450000000.0 * (time - 2e-08)
let mf_lodiff_re = 2 * mean((v(lo_p)-v(lo_n)) * mfw * cos(mfph)) * mfs
let mf_lodiff_im = 2 * mean((v(lo_p)-v(lo_n)) * mfw * sin(mfph)) * mfs
let mfph = 2 * pi * 1000000000.0 * (time - 2e-08)
let mf_if_re = 2 * mean((v(if_out)) * mfw * cos(mfph)) * mfs
let mf_if_im = 2 * mean((v(if_out)) * mfw * sin(mfph)) * mfs
let mfph = 2 * pi * 18450000000.0 * (time - 2e-08)
let mf_loif_re = 2 * mean((v(if_out)) * mfw * cos(mfph)) * mfs
let mf_loif_im = 2 * mean((v(if_out)) * mfw * sin(mfph)) * mfs
let mfph = 2 * pi * 18450000000.0 * (time - 2e-08)
let mf_lorf_re = 2 * mean((v(rf_port)) * mfw * cos(mfph)) * mfs
let mf_lorf_im = 2 * mean((v(rf_port)) * mfw * sin(mfph)) * mfs
let mfph = 2 * pi * 950000000.0 * (time - 2e-08)
let mf_flifa_re = 2 * mean((v(if_out)) * mfw * cos(mfph)) * mfs
let mf_flifa_im = 2 * mean((v(if_out)) * mfw * sin(mfph)) * mfs
let mfph = 2 * pi * 1050000000.0 * (time - 2e-08)
let mf_flifb_re = 2 * mean((v(if_out)) * mfw * cos(mfph)) * mfs
let mf_flifb_im = 2 * mean((v(if_out)) * mfw * sin(mfph)) * mfs
let mfph = 2 * pi * 18500000000.0 * (time - 2e-08)
let mf_fllorf_re = 2 * mean((v(rf_port)) * mfw * cos(mfph)) * mfs
let mf_fllorf_im = 2 * mean((v(rf_port)) * mfw * sin(mfph)) * mfs
let mfph = 2 * pi * 18500000000.0 * (time - 2e-08)
let mf_flloif_re = 2 * mean((v(if_out)) * mfw * cos(mfph)) * mfs
let mf_flloif_im = 2 * mean((v(if_out)) * mfw * sin(mfph)) * mfs
print mf_l
print mf_n
print mf_prail
print mf_lodiff_re
print mf_lodiff_im
print mf_if_re
print mf_if_im
print mf_loif_re
print mf_loif_im
print mf_lorf_re
print mf_lorf_im
print mf_flifa_re
print mf_flifa_im
print mf_flifb_re
print mf_flifb_im
print mf_fllorf_re
print mf_fllorf_im
print mf_flloif_re
print mf_flloif_im
destroy all
echo "MFEND ls_f19p45_m6_rf66"
echo "MFRUN ls_f19p45_m3_rf60"
alterparam f1 = 19450000000.0
alterparam f2 = 19450000000.0
alterparam flo = 18450000000.0
alterparam vrf1 = 0.0006324555320336759
alterparam vrf2 = 0.0
alterparam vlo = 0.6332059593069366
reset
op
let mf_dcirail = 0 - i(vdd)
let mf_dc_vce_q1 = v(c_q1)-v(e_q1)
let mf_dc_vbe_q1 = v(b_q1)-v(e_q1)
let mf_dc_ic_q1 = i(vic_q1)
let mf_dc_vce_q2 = v(c_q2)-v(e_q2)
let mf_dc_vbe_q2 = v(b_q2)-v(e_q2)
let mf_dc_ic_q2 = i(vic_q2)
let mf_dc_vce_q3 = v(c_q3)-v(x1)
let mf_dc_vbe_q3 = v(lo_p)-v(x1)
let mf_dc_ic_q3 = i(vic_q3)
let mf_dc_vce_q4 = v(c_q4)-v(x1)
let mf_dc_vbe_q4 = v(lo_n)-v(x1)
let mf_dc_ic_q4 = i(vic_q4)
let mf_dc_vce_q5 = v(c_q5)-v(x2)
let mf_dc_vbe_q5 = v(lo_p)-v(x2)
let mf_dc_ic_q5 = i(vic_q5)
let mf_dc_vce_q6 = v(c_q6)-v(x2)
let mf_dc_vbe_q6 = v(lo_n)-v(x2)
let mf_dc_ic_q6 = i(vic_q6)
let mf_dc_sink_tail = v(tail)
print mf_dcirail
print mf_dc_vce_q1
print mf_dc_vbe_q1
print mf_dc_ic_q1
print mf_dc_vce_q2
print mf_dc_vbe_q2
print mf_dc_ic_q2
print mf_dc_vce_q3
print mf_dc_vbe_q3
print mf_dc_ic_q3
print mf_dc_vce_q4
print mf_dc_vbe_q4
print mf_dc_ic_q4
print mf_dc_vce_q5
print mf_dc_vbe_q5
print mf_dc_ic_q5
print mf_dc_vce_q6
print mf_dc_vbe_q6
print mf_dc_ic_q6
print mf_dc_sink_tail
tran 1e-12 4e-08 0 1e-12
let mfq_vce_q1 = v(c_q1)-v(e_q1)
meas tran mf_su_vcemax_q1 MAX mfq_vce_q1 from=0.0 to=2e-08
meas tran mf_su_vcemin_q1 MIN mfq_vce_q1 from=0.0 to=2e-08
meas tran mf_ss_vcemax_q1 MAX mfq_vce_q1 from=2e-08 to=4e-08
meas tran mf_ss_vcemin_q1 MIN mfq_vce_q1 from=2e-08 to=4e-08
let mfq_vbe_q1 = v(b_q1)-v(e_q1)
meas tran mf_su_vbemax_q1 MAX mfq_vbe_q1 from=0.0 to=2e-08
meas tran mf_su_vbemin_q1 MIN mfq_vbe_q1 from=0.0 to=2e-08
meas tran mf_ss_vbemax_q1 MAX mfq_vbe_q1 from=2e-08 to=4e-08
meas tran mf_ss_vbemin_q1 MIN mfq_vbe_q1 from=2e-08 to=4e-08
let mfq_ic_q1 = i(vic_q1)
meas tran mf_su_icmax_q1 MAX mfq_ic_q1 from=0.0 to=2e-08
meas tran mf_su_icmin_q1 MIN mfq_ic_q1 from=0.0 to=2e-08
meas tran mf_ss_icmax_q1 MAX mfq_ic_q1 from=2e-08 to=4e-08
meas tran mf_ss_icmin_q1 MIN mfq_ic_q1 from=2e-08 to=4e-08
let mfq_vce_q2 = v(c_q2)-v(e_q2)
meas tran mf_su_vcemax_q2 MAX mfq_vce_q2 from=0.0 to=2e-08
meas tran mf_su_vcemin_q2 MIN mfq_vce_q2 from=0.0 to=2e-08
meas tran mf_ss_vcemax_q2 MAX mfq_vce_q2 from=2e-08 to=4e-08
meas tran mf_ss_vcemin_q2 MIN mfq_vce_q2 from=2e-08 to=4e-08
let mfq_vbe_q2 = v(b_q2)-v(e_q2)
meas tran mf_su_vbemax_q2 MAX mfq_vbe_q2 from=0.0 to=2e-08
meas tran mf_su_vbemin_q2 MIN mfq_vbe_q2 from=0.0 to=2e-08
meas tran mf_ss_vbemax_q2 MAX mfq_vbe_q2 from=2e-08 to=4e-08
meas tran mf_ss_vbemin_q2 MIN mfq_vbe_q2 from=2e-08 to=4e-08
let mfq_ic_q2 = i(vic_q2)
meas tran mf_su_icmax_q2 MAX mfq_ic_q2 from=0.0 to=2e-08
meas tran mf_su_icmin_q2 MIN mfq_ic_q2 from=0.0 to=2e-08
meas tran mf_ss_icmax_q2 MAX mfq_ic_q2 from=2e-08 to=4e-08
meas tran mf_ss_icmin_q2 MIN mfq_ic_q2 from=2e-08 to=4e-08
let mfq_vce_q3 = v(c_q3)-v(x1)
meas tran mf_su_vcemax_q3 MAX mfq_vce_q3 from=0.0 to=2e-08
meas tran mf_su_vcemin_q3 MIN mfq_vce_q3 from=0.0 to=2e-08
meas tran mf_ss_vcemax_q3 MAX mfq_vce_q3 from=2e-08 to=4e-08
meas tran mf_ss_vcemin_q3 MIN mfq_vce_q3 from=2e-08 to=4e-08
let mfq_vbe_q3 = v(lo_p)-v(x1)
meas tran mf_su_vbemax_q3 MAX mfq_vbe_q3 from=0.0 to=2e-08
meas tran mf_su_vbemin_q3 MIN mfq_vbe_q3 from=0.0 to=2e-08
meas tran mf_ss_vbemax_q3 MAX mfq_vbe_q3 from=2e-08 to=4e-08
meas tran mf_ss_vbemin_q3 MIN mfq_vbe_q3 from=2e-08 to=4e-08
let mfq_ic_q3 = i(vic_q3)
meas tran mf_su_icmax_q3 MAX mfq_ic_q3 from=0.0 to=2e-08
meas tran mf_su_icmin_q3 MIN mfq_ic_q3 from=0.0 to=2e-08
meas tran mf_ss_icmax_q3 MAX mfq_ic_q3 from=2e-08 to=4e-08
meas tran mf_ss_icmin_q3 MIN mfq_ic_q3 from=2e-08 to=4e-08
let mfq_vce_q4 = v(c_q4)-v(x1)
meas tran mf_su_vcemax_q4 MAX mfq_vce_q4 from=0.0 to=2e-08
meas tran mf_su_vcemin_q4 MIN mfq_vce_q4 from=0.0 to=2e-08
meas tran mf_ss_vcemax_q4 MAX mfq_vce_q4 from=2e-08 to=4e-08
meas tran mf_ss_vcemin_q4 MIN mfq_vce_q4 from=2e-08 to=4e-08
let mfq_vbe_q4 = v(lo_n)-v(x1)
meas tran mf_su_vbemax_q4 MAX mfq_vbe_q4 from=0.0 to=2e-08
meas tran mf_su_vbemin_q4 MIN mfq_vbe_q4 from=0.0 to=2e-08
meas tran mf_ss_vbemax_q4 MAX mfq_vbe_q4 from=2e-08 to=4e-08
meas tran mf_ss_vbemin_q4 MIN mfq_vbe_q4 from=2e-08 to=4e-08
let mfq_ic_q4 = i(vic_q4)
meas tran mf_su_icmax_q4 MAX mfq_ic_q4 from=0.0 to=2e-08
meas tran mf_su_icmin_q4 MIN mfq_ic_q4 from=0.0 to=2e-08
meas tran mf_ss_icmax_q4 MAX mfq_ic_q4 from=2e-08 to=4e-08
meas tran mf_ss_icmin_q4 MIN mfq_ic_q4 from=2e-08 to=4e-08
let mfq_vce_q5 = v(c_q5)-v(x2)
meas tran mf_su_vcemax_q5 MAX mfq_vce_q5 from=0.0 to=2e-08
meas tran mf_su_vcemin_q5 MIN mfq_vce_q5 from=0.0 to=2e-08
meas tran mf_ss_vcemax_q5 MAX mfq_vce_q5 from=2e-08 to=4e-08
meas tran mf_ss_vcemin_q5 MIN mfq_vce_q5 from=2e-08 to=4e-08
let mfq_vbe_q5 = v(lo_p)-v(x2)
meas tran mf_su_vbemax_q5 MAX mfq_vbe_q5 from=0.0 to=2e-08
meas tran mf_su_vbemin_q5 MIN mfq_vbe_q5 from=0.0 to=2e-08
meas tran mf_ss_vbemax_q5 MAX mfq_vbe_q5 from=2e-08 to=4e-08
meas tran mf_ss_vbemin_q5 MIN mfq_vbe_q5 from=2e-08 to=4e-08
let mfq_ic_q5 = i(vic_q5)
meas tran mf_su_icmax_q5 MAX mfq_ic_q5 from=0.0 to=2e-08
meas tran mf_su_icmin_q5 MIN mfq_ic_q5 from=0.0 to=2e-08
meas tran mf_ss_icmax_q5 MAX mfq_ic_q5 from=2e-08 to=4e-08
meas tran mf_ss_icmin_q5 MIN mfq_ic_q5 from=2e-08 to=4e-08
let mfq_vce_q6 = v(c_q6)-v(x2)
meas tran mf_su_vcemax_q6 MAX mfq_vce_q6 from=0.0 to=2e-08
meas tran mf_su_vcemin_q6 MIN mfq_vce_q6 from=0.0 to=2e-08
meas tran mf_ss_vcemax_q6 MAX mfq_vce_q6 from=2e-08 to=4e-08
meas tran mf_ss_vcemin_q6 MIN mfq_vce_q6 from=2e-08 to=4e-08
let mfq_vbe_q6 = v(lo_n)-v(x2)
meas tran mf_su_vbemax_q6 MAX mfq_vbe_q6 from=0.0 to=2e-08
meas tran mf_su_vbemin_q6 MIN mfq_vbe_q6 from=0.0 to=2e-08
meas tran mf_ss_vbemax_q6 MAX mfq_vbe_q6 from=2e-08 to=4e-08
meas tran mf_ss_vbemin_q6 MIN mfq_vbe_q6 from=2e-08 to=4e-08
let mfq_ic_q6 = i(vic_q6)
meas tran mf_su_icmax_q6 MAX mfq_ic_q6 from=0.0 to=2e-08
meas tran mf_su_icmin_q6 MIN mfq_ic_q6 from=0.0 to=2e-08
meas tran mf_ss_icmax_q6 MAX mfq_ic_q6 from=2e-08 to=4e-08
meas tran mf_ss_icmin_q6 MIN mfq_ic_q6 from=2e-08 to=4e-08
meas tran mf_su_sinkmin_tail MIN v(tail) from=0.0 to=2e-08
meas tran mf_ss_sinkmin_tail MIN v(tail) from=2e-08 to=4e-08
print mf_su_vcemax_q1
print mf_su_vcemin_q1
print mf_ss_vcemax_q1
print mf_ss_vcemin_q1
print mf_su_vbemax_q1
print mf_su_vbemin_q1
print mf_ss_vbemax_q1
print mf_ss_vbemin_q1
print mf_su_icmax_q1
print mf_su_icmin_q1
print mf_ss_icmax_q1
print mf_ss_icmin_q1
print mf_su_vcemax_q2
print mf_su_vcemin_q2
print mf_ss_vcemax_q2
print mf_ss_vcemin_q2
print mf_su_vbemax_q2
print mf_su_vbemin_q2
print mf_ss_vbemax_q2
print mf_ss_vbemin_q2
print mf_su_icmax_q2
print mf_su_icmin_q2
print mf_ss_icmax_q2
print mf_ss_icmin_q2
print mf_su_vcemax_q3
print mf_su_vcemin_q3
print mf_ss_vcemax_q3
print mf_ss_vcemin_q3
print mf_su_vbemax_q3
print mf_su_vbemin_q3
print mf_ss_vbemax_q3
print mf_ss_vbemin_q3
print mf_su_icmax_q3
print mf_su_icmin_q3
print mf_ss_icmax_q3
print mf_ss_icmin_q3
print mf_su_vcemax_q4
print mf_su_vcemin_q4
print mf_ss_vcemax_q4
print mf_ss_vcemin_q4
print mf_su_vbemax_q4
print mf_su_vbemin_q4
print mf_ss_vbemax_q4
print mf_ss_vbemin_q4
print mf_su_icmax_q4
print mf_su_icmin_q4
print mf_ss_icmax_q4
print mf_ss_icmin_q4
print mf_su_vcemax_q5
print mf_su_vcemin_q5
print mf_ss_vcemax_q5
print mf_ss_vcemin_q5
print mf_su_vbemax_q5
print mf_su_vbemin_q5
print mf_ss_vbemax_q5
print mf_ss_vbemin_q5
print mf_su_icmax_q5
print mf_su_icmin_q5
print mf_ss_icmax_q5
print mf_ss_icmin_q5
print mf_su_vcemax_q6
print mf_su_vcemin_q6
print mf_ss_vcemax_q6
print mf_ss_vcemin_q6
print mf_su_vbemax_q6
print mf_su_vbemin_q6
print mf_ss_vbemax_q6
print mf_ss_vbemin_q6
print mf_su_icmax_q6
print mf_su_icmin_q6
print mf_ss_icmax_q6
print mf_ss_icmin_q6
print mf_su_sinkmin_tail
print mf_ss_sinkmin_tail
linearize
let mf_l = length(time)
let mfw = (time ge 1.99995e-08) * (time lt 3.99995e-08)
let mf_n = mean(mfw) * mf_l
let mfs = mf_l / mf_n
let mf_prail = mean(v(vdd) * (0 - i(vdd)) * mfw) * mfs
let mfph = 2 * pi * 18450000000.0 * (time - 2e-08)
let mf_lodiff_re = 2 * mean((v(lo_p)-v(lo_n)) * mfw * cos(mfph)) * mfs
let mf_lodiff_im = 2 * mean((v(lo_p)-v(lo_n)) * mfw * sin(mfph)) * mfs
let mfph = 2 * pi * 1000000000.0 * (time - 2e-08)
let mf_if_re = 2 * mean((v(if_out)) * mfw * cos(mfph)) * mfs
let mf_if_im = 2 * mean((v(if_out)) * mfw * sin(mfph)) * mfs
let mfph = 2 * pi * 18450000000.0 * (time - 2e-08)
let mf_loif_re = 2 * mean((v(if_out)) * mfw * cos(mfph)) * mfs
let mf_loif_im = 2 * mean((v(if_out)) * mfw * sin(mfph)) * mfs
let mfph = 2 * pi * 18450000000.0 * (time - 2e-08)
let mf_lorf_re = 2 * mean((v(rf_port)) * mfw * cos(mfph)) * mfs
let mf_lorf_im = 2 * mean((v(rf_port)) * mfw * sin(mfph)) * mfs
let mfph = 2 * pi * 950000000.0 * (time - 2e-08)
let mf_flifa_re = 2 * mean((v(if_out)) * mfw * cos(mfph)) * mfs
let mf_flifa_im = 2 * mean((v(if_out)) * mfw * sin(mfph)) * mfs
let mfph = 2 * pi * 1050000000.0 * (time - 2e-08)
let mf_flifb_re = 2 * mean((v(if_out)) * mfw * cos(mfph)) * mfs
let mf_flifb_im = 2 * mean((v(if_out)) * mfw * sin(mfph)) * mfs
let mfph = 2 * pi * 18500000000.0 * (time - 2e-08)
let mf_fllorf_re = 2 * mean((v(rf_port)) * mfw * cos(mfph)) * mfs
let mf_fllorf_im = 2 * mean((v(rf_port)) * mfw * sin(mfph)) * mfs
let mfph = 2 * pi * 18500000000.0 * (time - 2e-08)
let mf_flloif_re = 2 * mean((v(if_out)) * mfw * cos(mfph)) * mfs
let mf_flloif_im = 2 * mean((v(if_out)) * mfw * sin(mfph)) * mfs
print mf_l
print mf_n
print mf_prail
print mf_lodiff_re
print mf_lodiff_im
print mf_if_re
print mf_if_im
print mf_loif_re
print mf_loif_im
print mf_lorf_re
print mf_lorf_im
print mf_flifa_re
print mf_flifa_im
print mf_flifb_re
print mf_flifb_im
print mf_fllorf_re
print mf_fllorf_im
print mf_flloif_re
print mf_flloif_im
destroy all
echo "MFEND ls_f19p45_m3_rf60"
echo "MFRUN ls_f19p45_m3_rf66"
alterparam f1 = 19450000000.0
alterparam f2 = 19450000000.0
alterparam flo = 18450000000.0
alterparam vrf1 = 0.00031697863849222284
alterparam vrf2 = 0.0
alterparam vlo = 0.6332059593069366
reset
op
let mf_dcirail = 0 - i(vdd)
let mf_dc_vce_q1 = v(c_q1)-v(e_q1)
let mf_dc_vbe_q1 = v(b_q1)-v(e_q1)
let mf_dc_ic_q1 = i(vic_q1)
let mf_dc_vce_q2 = v(c_q2)-v(e_q2)
let mf_dc_vbe_q2 = v(b_q2)-v(e_q2)
let mf_dc_ic_q2 = i(vic_q2)
let mf_dc_vce_q3 = v(c_q3)-v(x1)
let mf_dc_vbe_q3 = v(lo_p)-v(x1)
let mf_dc_ic_q3 = i(vic_q3)
let mf_dc_vce_q4 = v(c_q4)-v(x1)
let mf_dc_vbe_q4 = v(lo_n)-v(x1)
let mf_dc_ic_q4 = i(vic_q4)
let mf_dc_vce_q5 = v(c_q5)-v(x2)
let mf_dc_vbe_q5 = v(lo_p)-v(x2)
let mf_dc_ic_q5 = i(vic_q5)
let mf_dc_vce_q6 = v(c_q6)-v(x2)
let mf_dc_vbe_q6 = v(lo_n)-v(x2)
let mf_dc_ic_q6 = i(vic_q6)
let mf_dc_sink_tail = v(tail)
print mf_dcirail
print mf_dc_vce_q1
print mf_dc_vbe_q1
print mf_dc_ic_q1
print mf_dc_vce_q2
print mf_dc_vbe_q2
print mf_dc_ic_q2
print mf_dc_vce_q3
print mf_dc_vbe_q3
print mf_dc_ic_q3
print mf_dc_vce_q4
print mf_dc_vbe_q4
print mf_dc_ic_q4
print mf_dc_vce_q5
print mf_dc_vbe_q5
print mf_dc_ic_q5
print mf_dc_vce_q6
print mf_dc_vbe_q6
print mf_dc_ic_q6
print mf_dc_sink_tail
tran 1e-12 4e-08 0 1e-12
let mfq_vce_q1 = v(c_q1)-v(e_q1)
meas tran mf_su_vcemax_q1 MAX mfq_vce_q1 from=0.0 to=2e-08
meas tran mf_su_vcemin_q1 MIN mfq_vce_q1 from=0.0 to=2e-08
meas tran mf_ss_vcemax_q1 MAX mfq_vce_q1 from=2e-08 to=4e-08
meas tran mf_ss_vcemin_q1 MIN mfq_vce_q1 from=2e-08 to=4e-08
let mfq_vbe_q1 = v(b_q1)-v(e_q1)
meas tran mf_su_vbemax_q1 MAX mfq_vbe_q1 from=0.0 to=2e-08
meas tran mf_su_vbemin_q1 MIN mfq_vbe_q1 from=0.0 to=2e-08
meas tran mf_ss_vbemax_q1 MAX mfq_vbe_q1 from=2e-08 to=4e-08
meas tran mf_ss_vbemin_q1 MIN mfq_vbe_q1 from=2e-08 to=4e-08
let mfq_ic_q1 = i(vic_q1)
meas tran mf_su_icmax_q1 MAX mfq_ic_q1 from=0.0 to=2e-08
meas tran mf_su_icmin_q1 MIN mfq_ic_q1 from=0.0 to=2e-08
meas tran mf_ss_icmax_q1 MAX mfq_ic_q1 from=2e-08 to=4e-08
meas tran mf_ss_icmin_q1 MIN mfq_ic_q1 from=2e-08 to=4e-08
let mfq_vce_q2 = v(c_q2)-v(e_q2)
meas tran mf_su_vcemax_q2 MAX mfq_vce_q2 from=0.0 to=2e-08
meas tran mf_su_vcemin_q2 MIN mfq_vce_q2 from=0.0 to=2e-08
meas tran mf_ss_vcemax_q2 MAX mfq_vce_q2 from=2e-08 to=4e-08
meas tran mf_ss_vcemin_q2 MIN mfq_vce_q2 from=2e-08 to=4e-08
let mfq_vbe_q2 = v(b_q2)-v(e_q2)
meas tran mf_su_vbemax_q2 MAX mfq_vbe_q2 from=0.0 to=2e-08
meas tran mf_su_vbemin_q2 MIN mfq_vbe_q2 from=0.0 to=2e-08
meas tran mf_ss_vbemax_q2 MAX mfq_vbe_q2 from=2e-08 to=4e-08
meas tran mf_ss_vbemin_q2 MIN mfq_vbe_q2 from=2e-08 to=4e-08
let mfq_ic_q2 = i(vic_q2)
meas tran mf_su_icmax_q2 MAX mfq_ic_q2 from=0.0 to=2e-08
meas tran mf_su_icmin_q2 MIN mfq_ic_q2 from=0.0 to=2e-08
meas tran mf_ss_icmax_q2 MAX mfq_ic_q2 from=2e-08 to=4e-08
meas tran mf_ss_icmin_q2 MIN mfq_ic_q2 from=2e-08 to=4e-08
let mfq_vce_q3 = v(c_q3)-v(x1)
meas tran mf_su_vcemax_q3 MAX mfq_vce_q3 from=0.0 to=2e-08
meas tran mf_su_vcemin_q3 MIN mfq_vce_q3 from=0.0 to=2e-08
meas tran mf_ss_vcemax_q3 MAX mfq_vce_q3 from=2e-08 to=4e-08
meas tran mf_ss_vcemin_q3 MIN mfq_vce_q3 from=2e-08 to=4e-08
let mfq_vbe_q3 = v(lo_p)-v(x1)
meas tran mf_su_vbemax_q3 MAX mfq_vbe_q3 from=0.0 to=2e-08
meas tran mf_su_vbemin_q3 MIN mfq_vbe_q3 from=0.0 to=2e-08
meas tran mf_ss_vbemax_q3 MAX mfq_vbe_q3 from=2e-08 to=4e-08
meas tran mf_ss_vbemin_q3 MIN mfq_vbe_q3 from=2e-08 to=4e-08
let mfq_ic_q3 = i(vic_q3)
meas tran mf_su_icmax_q3 MAX mfq_ic_q3 from=0.0 to=2e-08
meas tran mf_su_icmin_q3 MIN mfq_ic_q3 from=0.0 to=2e-08
meas tran mf_ss_icmax_q3 MAX mfq_ic_q3 from=2e-08 to=4e-08
meas tran mf_ss_icmin_q3 MIN mfq_ic_q3 from=2e-08 to=4e-08
let mfq_vce_q4 = v(c_q4)-v(x1)
meas tran mf_su_vcemax_q4 MAX mfq_vce_q4 from=0.0 to=2e-08
meas tran mf_su_vcemin_q4 MIN mfq_vce_q4 from=0.0 to=2e-08
meas tran mf_ss_vcemax_q4 MAX mfq_vce_q4 from=2e-08 to=4e-08
meas tran mf_ss_vcemin_q4 MIN mfq_vce_q4 from=2e-08 to=4e-08
let mfq_vbe_q4 = v(lo_n)-v(x1)
meas tran mf_su_vbemax_q4 MAX mfq_vbe_q4 from=0.0 to=2e-08
meas tran mf_su_vbemin_q4 MIN mfq_vbe_q4 from=0.0 to=2e-08
meas tran mf_ss_vbemax_q4 MAX mfq_vbe_q4 from=2e-08 to=4e-08
meas tran mf_ss_vbemin_q4 MIN mfq_vbe_q4 from=2e-08 to=4e-08
let mfq_ic_q4 = i(vic_q4)
meas tran mf_su_icmax_q4 MAX mfq_ic_q4 from=0.0 to=2e-08
meas tran mf_su_icmin_q4 MIN mfq_ic_q4 from=0.0 to=2e-08
meas tran mf_ss_icmax_q4 MAX mfq_ic_q4 from=2e-08 to=4e-08
meas tran mf_ss_icmin_q4 MIN mfq_ic_q4 from=2e-08 to=4e-08
let mfq_vce_q5 = v(c_q5)-v(x2)
meas tran mf_su_vcemax_q5 MAX mfq_vce_q5 from=0.0 to=2e-08
meas tran mf_su_vcemin_q5 MIN mfq_vce_q5 from=0.0 to=2e-08
meas tran mf_ss_vcemax_q5 MAX mfq_vce_q5 from=2e-08 to=4e-08
meas tran mf_ss_vcemin_q5 MIN mfq_vce_q5 from=2e-08 to=4e-08
let mfq_vbe_q5 = v(lo_p)-v(x2)
meas tran mf_su_vbemax_q5 MAX mfq_vbe_q5 from=0.0 to=2e-08
meas tran mf_su_vbemin_q5 MIN mfq_vbe_q5 from=0.0 to=2e-08
meas tran mf_ss_vbemax_q5 MAX mfq_vbe_q5 from=2e-08 to=4e-08
meas tran mf_ss_vbemin_q5 MIN mfq_vbe_q5 from=2e-08 to=4e-08
let mfq_ic_q5 = i(vic_q5)
meas tran mf_su_icmax_q5 MAX mfq_ic_q5 from=0.0 to=2e-08
meas tran mf_su_icmin_q5 MIN mfq_ic_q5 from=0.0 to=2e-08
meas tran mf_ss_icmax_q5 MAX mfq_ic_q5 from=2e-08 to=4e-08
meas tran mf_ss_icmin_q5 MIN mfq_ic_q5 from=2e-08 to=4e-08
let mfq_vce_q6 = v(c_q6)-v(x2)
meas tran mf_su_vcemax_q6 MAX mfq_vce_q6 from=0.0 to=2e-08
meas tran mf_su_vcemin_q6 MIN mfq_vce_q6 from=0.0 to=2e-08
meas tran mf_ss_vcemax_q6 MAX mfq_vce_q6 from=2e-08 to=4e-08
meas tran mf_ss_vcemin_q6 MIN mfq_vce_q6 from=2e-08 to=4e-08
let mfq_vbe_q6 = v(lo_n)-v(x2)
meas tran mf_su_vbemax_q6 MAX mfq_vbe_q6 from=0.0 to=2e-08
meas tran mf_su_vbemin_q6 MIN mfq_vbe_q6 from=0.0 to=2e-08
meas tran mf_ss_vbemax_q6 MAX mfq_vbe_q6 from=2e-08 to=4e-08
meas tran mf_ss_vbemin_q6 MIN mfq_vbe_q6 from=2e-08 to=4e-08
let mfq_ic_q6 = i(vic_q6)
meas tran mf_su_icmax_q6 MAX mfq_ic_q6 from=0.0 to=2e-08
meas tran mf_su_icmin_q6 MIN mfq_ic_q6 from=0.0 to=2e-08
meas tran mf_ss_icmax_q6 MAX mfq_ic_q6 from=2e-08 to=4e-08
meas tran mf_ss_icmin_q6 MIN mfq_ic_q6 from=2e-08 to=4e-08
meas tran mf_su_sinkmin_tail MIN v(tail) from=0.0 to=2e-08
meas tran mf_ss_sinkmin_tail MIN v(tail) from=2e-08 to=4e-08
print mf_su_vcemax_q1
print mf_su_vcemin_q1
print mf_ss_vcemax_q1
print mf_ss_vcemin_q1
print mf_su_vbemax_q1
print mf_su_vbemin_q1
print mf_ss_vbemax_q1
print mf_ss_vbemin_q1
print mf_su_icmax_q1
print mf_su_icmin_q1
print mf_ss_icmax_q1
print mf_ss_icmin_q1
print mf_su_vcemax_q2
print mf_su_vcemin_q2
print mf_ss_vcemax_q2
print mf_ss_vcemin_q2
print mf_su_vbemax_q2
print mf_su_vbemin_q2
print mf_ss_vbemax_q2
print mf_ss_vbemin_q2
print mf_su_icmax_q2
print mf_su_icmin_q2
print mf_ss_icmax_q2
print mf_ss_icmin_q2
print mf_su_vcemax_q3
print mf_su_vcemin_q3
print mf_ss_vcemax_q3
print mf_ss_vcemin_q3
print mf_su_vbemax_q3
print mf_su_vbemin_q3
print mf_ss_vbemax_q3
print mf_ss_vbemin_q3
print mf_su_icmax_q3
print mf_su_icmin_q3
print mf_ss_icmax_q3
print mf_ss_icmin_q3
print mf_su_vcemax_q4
print mf_su_vcemin_q4
print mf_ss_vcemax_q4
print mf_ss_vcemin_q4
print mf_su_vbemax_q4
print mf_su_vbemin_q4
print mf_ss_vbemax_q4
print mf_ss_vbemin_q4
print mf_su_icmax_q4
print mf_su_icmin_q4
print mf_ss_icmax_q4
print mf_ss_icmin_q4
print mf_su_vcemax_q5
print mf_su_vcemin_q5
print mf_ss_vcemax_q5
print mf_ss_vcemin_q5
print mf_su_vbemax_q5
print mf_su_vbemin_q5
print mf_ss_vbemax_q5
print mf_ss_vbemin_q5
print mf_su_icmax_q5
print mf_su_icmin_q5
print mf_ss_icmax_q5
print mf_ss_icmin_q5
print mf_su_vcemax_q6
print mf_su_vcemin_q6
print mf_ss_vcemax_q6
print mf_ss_vcemin_q6
print mf_su_vbemax_q6
print mf_su_vbemin_q6
print mf_ss_vbemax_q6
print mf_ss_vbemin_q6
print mf_su_icmax_q6
print mf_su_icmin_q6
print mf_ss_icmax_q6
print mf_ss_icmin_q6
print mf_su_sinkmin_tail
print mf_ss_sinkmin_tail
linearize
let mf_l = length(time)
let mfw = (time ge 1.99995e-08) * (time lt 3.99995e-08)
let mf_n = mean(mfw) * mf_l
let mfs = mf_l / mf_n
let mf_prail = mean(v(vdd) * (0 - i(vdd)) * mfw) * mfs
let mfph = 2 * pi * 18450000000.0 * (time - 2e-08)
let mf_lodiff_re = 2 * mean((v(lo_p)-v(lo_n)) * mfw * cos(mfph)) * mfs
let mf_lodiff_im = 2 * mean((v(lo_p)-v(lo_n)) * mfw * sin(mfph)) * mfs
let mfph = 2 * pi * 1000000000.0 * (time - 2e-08)
let mf_if_re = 2 * mean((v(if_out)) * mfw * cos(mfph)) * mfs
let mf_if_im = 2 * mean((v(if_out)) * mfw * sin(mfph)) * mfs
let mfph = 2 * pi * 18450000000.0 * (time - 2e-08)
let mf_loif_re = 2 * mean((v(if_out)) * mfw * cos(mfph)) * mfs
let mf_loif_im = 2 * mean((v(if_out)) * mfw * sin(mfph)) * mfs
let mfph = 2 * pi * 18450000000.0 * (time - 2e-08)
let mf_lorf_re = 2 * mean((v(rf_port)) * mfw * cos(mfph)) * mfs
let mf_lorf_im = 2 * mean((v(rf_port)) * mfw * sin(mfph)) * mfs
let mfph = 2 * pi * 950000000.0 * (time - 2e-08)
let mf_flifa_re = 2 * mean((v(if_out)) * mfw * cos(mfph)) * mfs
let mf_flifa_im = 2 * mean((v(if_out)) * mfw * sin(mfph)) * mfs
let mfph = 2 * pi * 1050000000.0 * (time - 2e-08)
let mf_flifb_re = 2 * mean((v(if_out)) * mfw * cos(mfph)) * mfs
let mf_flifb_im = 2 * mean((v(if_out)) * mfw * sin(mfph)) * mfs
let mfph = 2 * pi * 18500000000.0 * (time - 2e-08)
let mf_fllorf_re = 2 * mean((v(rf_port)) * mfw * cos(mfph)) * mfs
let mf_fllorf_im = 2 * mean((v(rf_port)) * mfw * sin(mfph)) * mfs
let mfph = 2 * pi * 18500000000.0 * (time - 2e-08)
let mf_flloif_re = 2 * mean((v(if_out)) * mfw * cos(mfph)) * mfs
let mf_flloif_im = 2 * mean((v(if_out)) * mfw * sin(mfph)) * mfs
print mf_l
print mf_n
print mf_prail
print mf_lodiff_re
print mf_lodiff_im
print mf_if_re
print mf_if_im
print mf_loif_re
print mf_loif_im
print mf_lorf_re
print mf_lorf_im
print mf_flifa_re
print mf_flifa_im
print mf_flifb_re
print mf_flifb_im
print mf_fllorf_re
print mf_fllorf_im
print mf_flloif_re
print mf_flloif_im
destroy all
echo "MFEND ls_f19p45_m3_rf66"
echo "MFRUN ls_f19p45_p0_rf60"
alterparam f1 = 19450000000.0
alterparam f2 = 19450000000.0
alterparam flo = 18450000000.0
alterparam vrf1 = 0.0006324555320336759
alterparam vrf2 = 0.0
alterparam vlo = 0.8944271909999159
reset
op
let mf_dcirail = 0 - i(vdd)
let mf_dc_vce_q1 = v(c_q1)-v(e_q1)
let mf_dc_vbe_q1 = v(b_q1)-v(e_q1)
let mf_dc_ic_q1 = i(vic_q1)
let mf_dc_vce_q2 = v(c_q2)-v(e_q2)
let mf_dc_vbe_q2 = v(b_q2)-v(e_q2)
let mf_dc_ic_q2 = i(vic_q2)
let mf_dc_vce_q3 = v(c_q3)-v(x1)
let mf_dc_vbe_q3 = v(lo_p)-v(x1)
let mf_dc_ic_q3 = i(vic_q3)
let mf_dc_vce_q4 = v(c_q4)-v(x1)
let mf_dc_vbe_q4 = v(lo_n)-v(x1)
let mf_dc_ic_q4 = i(vic_q4)
let mf_dc_vce_q5 = v(c_q5)-v(x2)
let mf_dc_vbe_q5 = v(lo_p)-v(x2)
let mf_dc_ic_q5 = i(vic_q5)
let mf_dc_vce_q6 = v(c_q6)-v(x2)
let mf_dc_vbe_q6 = v(lo_n)-v(x2)
let mf_dc_ic_q6 = i(vic_q6)
let mf_dc_sink_tail = v(tail)
print mf_dcirail
print mf_dc_vce_q1
print mf_dc_vbe_q1
print mf_dc_ic_q1
print mf_dc_vce_q2
print mf_dc_vbe_q2
print mf_dc_ic_q2
print mf_dc_vce_q3
print mf_dc_vbe_q3
print mf_dc_ic_q3
print mf_dc_vce_q4
print mf_dc_vbe_q4
print mf_dc_ic_q4
print mf_dc_vce_q5
print mf_dc_vbe_q5
print mf_dc_ic_q5
print mf_dc_vce_q6
print mf_dc_vbe_q6
print mf_dc_ic_q6
print mf_dc_sink_tail
tran 1e-12 4e-08 0 1e-12
let mfq_vce_q1 = v(c_q1)-v(e_q1)
meas tran mf_su_vcemax_q1 MAX mfq_vce_q1 from=0.0 to=2e-08
meas tran mf_su_vcemin_q1 MIN mfq_vce_q1 from=0.0 to=2e-08
meas tran mf_ss_vcemax_q1 MAX mfq_vce_q1 from=2e-08 to=4e-08
meas tran mf_ss_vcemin_q1 MIN mfq_vce_q1 from=2e-08 to=4e-08
let mfq_vbe_q1 = v(b_q1)-v(e_q1)
meas tran mf_su_vbemax_q1 MAX mfq_vbe_q1 from=0.0 to=2e-08
meas tran mf_su_vbemin_q1 MIN mfq_vbe_q1 from=0.0 to=2e-08
meas tran mf_ss_vbemax_q1 MAX mfq_vbe_q1 from=2e-08 to=4e-08
meas tran mf_ss_vbemin_q1 MIN mfq_vbe_q1 from=2e-08 to=4e-08
let mfq_ic_q1 = i(vic_q1)
meas tran mf_su_icmax_q1 MAX mfq_ic_q1 from=0.0 to=2e-08
meas tran mf_su_icmin_q1 MIN mfq_ic_q1 from=0.0 to=2e-08
meas tran mf_ss_icmax_q1 MAX mfq_ic_q1 from=2e-08 to=4e-08
meas tran mf_ss_icmin_q1 MIN mfq_ic_q1 from=2e-08 to=4e-08
let mfq_vce_q2 = v(c_q2)-v(e_q2)
meas tran mf_su_vcemax_q2 MAX mfq_vce_q2 from=0.0 to=2e-08
meas tran mf_su_vcemin_q2 MIN mfq_vce_q2 from=0.0 to=2e-08
meas tran mf_ss_vcemax_q2 MAX mfq_vce_q2 from=2e-08 to=4e-08
meas tran mf_ss_vcemin_q2 MIN mfq_vce_q2 from=2e-08 to=4e-08
let mfq_vbe_q2 = v(b_q2)-v(e_q2)
meas tran mf_su_vbemax_q2 MAX mfq_vbe_q2 from=0.0 to=2e-08
meas tran mf_su_vbemin_q2 MIN mfq_vbe_q2 from=0.0 to=2e-08
meas tran mf_ss_vbemax_q2 MAX mfq_vbe_q2 from=2e-08 to=4e-08
meas tran mf_ss_vbemin_q2 MIN mfq_vbe_q2 from=2e-08 to=4e-08
let mfq_ic_q2 = i(vic_q2)
meas tran mf_su_icmax_q2 MAX mfq_ic_q2 from=0.0 to=2e-08
meas tran mf_su_icmin_q2 MIN mfq_ic_q2 from=0.0 to=2e-08
meas tran mf_ss_icmax_q2 MAX mfq_ic_q2 from=2e-08 to=4e-08
meas tran mf_ss_icmin_q2 MIN mfq_ic_q2 from=2e-08 to=4e-08
let mfq_vce_q3 = v(c_q3)-v(x1)
meas tran mf_su_vcemax_q3 MAX mfq_vce_q3 from=0.0 to=2e-08
meas tran mf_su_vcemin_q3 MIN mfq_vce_q3 from=0.0 to=2e-08
meas tran mf_ss_vcemax_q3 MAX mfq_vce_q3 from=2e-08 to=4e-08
meas tran mf_ss_vcemin_q3 MIN mfq_vce_q3 from=2e-08 to=4e-08
let mfq_vbe_q3 = v(lo_p)-v(x1)
meas tran mf_su_vbemax_q3 MAX mfq_vbe_q3 from=0.0 to=2e-08
meas tran mf_su_vbemin_q3 MIN mfq_vbe_q3 from=0.0 to=2e-08
meas tran mf_ss_vbemax_q3 MAX mfq_vbe_q3 from=2e-08 to=4e-08
meas tran mf_ss_vbemin_q3 MIN mfq_vbe_q3 from=2e-08 to=4e-08
let mfq_ic_q3 = i(vic_q3)
meas tran mf_su_icmax_q3 MAX mfq_ic_q3 from=0.0 to=2e-08
meas tran mf_su_icmin_q3 MIN mfq_ic_q3 from=0.0 to=2e-08
meas tran mf_ss_icmax_q3 MAX mfq_ic_q3 from=2e-08 to=4e-08
meas tran mf_ss_icmin_q3 MIN mfq_ic_q3 from=2e-08 to=4e-08
let mfq_vce_q4 = v(c_q4)-v(x1)
meas tran mf_su_vcemax_q4 MAX mfq_vce_q4 from=0.0 to=2e-08
meas tran mf_su_vcemin_q4 MIN mfq_vce_q4 from=0.0 to=2e-08
meas tran mf_ss_vcemax_q4 MAX mfq_vce_q4 from=2e-08 to=4e-08
meas tran mf_ss_vcemin_q4 MIN mfq_vce_q4 from=2e-08 to=4e-08
let mfq_vbe_q4 = v(lo_n)-v(x1)
meas tran mf_su_vbemax_q4 MAX mfq_vbe_q4 from=0.0 to=2e-08
meas tran mf_su_vbemin_q4 MIN mfq_vbe_q4 from=0.0 to=2e-08
meas tran mf_ss_vbemax_q4 MAX mfq_vbe_q4 from=2e-08 to=4e-08
meas tran mf_ss_vbemin_q4 MIN mfq_vbe_q4 from=2e-08 to=4e-08
let mfq_ic_q4 = i(vic_q4)
meas tran mf_su_icmax_q4 MAX mfq_ic_q4 from=0.0 to=2e-08
meas tran mf_su_icmin_q4 MIN mfq_ic_q4 from=0.0 to=2e-08
meas tran mf_ss_icmax_q4 MAX mfq_ic_q4 from=2e-08 to=4e-08
meas tran mf_ss_icmin_q4 MIN mfq_ic_q4 from=2e-08 to=4e-08
let mfq_vce_q5 = v(c_q5)-v(x2)
meas tran mf_su_vcemax_q5 MAX mfq_vce_q5 from=0.0 to=2e-08
meas tran mf_su_vcemin_q5 MIN mfq_vce_q5 from=0.0 to=2e-08
meas tran mf_ss_vcemax_q5 MAX mfq_vce_q5 from=2e-08 to=4e-08
meas tran mf_ss_vcemin_q5 MIN mfq_vce_q5 from=2e-08 to=4e-08
let mfq_vbe_q5 = v(lo_p)-v(x2)
meas tran mf_su_vbemax_q5 MAX mfq_vbe_q5 from=0.0 to=2e-08
meas tran mf_su_vbemin_q5 MIN mfq_vbe_q5 from=0.0 to=2e-08
meas tran mf_ss_vbemax_q5 MAX mfq_vbe_q5 from=2e-08 to=4e-08
meas tran mf_ss_vbemin_q5 MIN mfq_vbe_q5 from=2e-08 to=4e-08
let mfq_ic_q5 = i(vic_q5)
meas tran mf_su_icmax_q5 MAX mfq_ic_q5 from=0.0 to=2e-08
meas tran mf_su_icmin_q5 MIN mfq_ic_q5 from=0.0 to=2e-08
meas tran mf_ss_icmax_q5 MAX mfq_ic_q5 from=2e-08 to=4e-08
meas tran mf_ss_icmin_q5 MIN mfq_ic_q5 from=2e-08 to=4e-08
let mfq_vce_q6 = v(c_q6)-v(x2)
meas tran mf_su_vcemax_q6 MAX mfq_vce_q6 from=0.0 to=2e-08
meas tran mf_su_vcemin_q6 MIN mfq_vce_q6 from=0.0 to=2e-08
meas tran mf_ss_vcemax_q6 MAX mfq_vce_q6 from=2e-08 to=4e-08
meas tran mf_ss_vcemin_q6 MIN mfq_vce_q6 from=2e-08 to=4e-08
let mfq_vbe_q6 = v(lo_n)-v(x2)
meas tran mf_su_vbemax_q6 MAX mfq_vbe_q6 from=0.0 to=2e-08
meas tran mf_su_vbemin_q6 MIN mfq_vbe_q6 from=0.0 to=2e-08
meas tran mf_ss_vbemax_q6 MAX mfq_vbe_q6 from=2e-08 to=4e-08
meas tran mf_ss_vbemin_q6 MIN mfq_vbe_q6 from=2e-08 to=4e-08
let mfq_ic_q6 = i(vic_q6)
meas tran mf_su_icmax_q6 MAX mfq_ic_q6 from=0.0 to=2e-08
meas tran mf_su_icmin_q6 MIN mfq_ic_q6 from=0.0 to=2e-08
meas tran mf_ss_icmax_q6 MAX mfq_ic_q6 from=2e-08 to=4e-08
meas tran mf_ss_icmin_q6 MIN mfq_ic_q6 from=2e-08 to=4e-08
meas tran mf_su_sinkmin_tail MIN v(tail) from=0.0 to=2e-08
meas tran mf_ss_sinkmin_tail MIN v(tail) from=2e-08 to=4e-08
print mf_su_vcemax_q1
print mf_su_vcemin_q1
print mf_ss_vcemax_q1
print mf_ss_vcemin_q1
print mf_su_vbemax_q1
print mf_su_vbemin_q1
print mf_ss_vbemax_q1
print mf_ss_vbemin_q1
print mf_su_icmax_q1
print mf_su_icmin_q1
print mf_ss_icmax_q1
print mf_ss_icmin_q1
print mf_su_vcemax_q2
print mf_su_vcemin_q2
print mf_ss_vcemax_q2
print mf_ss_vcemin_q2
print mf_su_vbemax_q2
print mf_su_vbemin_q2
print mf_ss_vbemax_q2
print mf_ss_vbemin_q2
print mf_su_icmax_q2
print mf_su_icmin_q2
print mf_ss_icmax_q2
print mf_ss_icmin_q2
print mf_su_vcemax_q3
print mf_su_vcemin_q3
print mf_ss_vcemax_q3
print mf_ss_vcemin_q3
print mf_su_vbemax_q3
print mf_su_vbemin_q3
print mf_ss_vbemax_q3
print mf_ss_vbemin_q3
print mf_su_icmax_q3
print mf_su_icmin_q3
print mf_ss_icmax_q3
print mf_ss_icmin_q3
print mf_su_vcemax_q4
print mf_su_vcemin_q4
print mf_ss_vcemax_q4
print mf_ss_vcemin_q4
print mf_su_vbemax_q4
print mf_su_vbemin_q4
print mf_ss_vbemax_q4
print mf_ss_vbemin_q4
print mf_su_icmax_q4
print mf_su_icmin_q4
print mf_ss_icmax_q4
print mf_ss_icmin_q4
print mf_su_vcemax_q5
print mf_su_vcemin_q5
print mf_ss_vcemax_q5
print mf_ss_vcemin_q5
print mf_su_vbemax_q5
print mf_su_vbemin_q5
print mf_ss_vbemax_q5
print mf_ss_vbemin_q5
print mf_su_icmax_q5
print mf_su_icmin_q5
print mf_ss_icmax_q5
print mf_ss_icmin_q5
print mf_su_vcemax_q6
print mf_su_vcemin_q6
print mf_ss_vcemax_q6
print mf_ss_vcemin_q6
print mf_su_vbemax_q6
print mf_su_vbemin_q6
print mf_ss_vbemax_q6
print mf_ss_vbemin_q6
print mf_su_icmax_q6
print mf_su_icmin_q6
print mf_ss_icmax_q6
print mf_ss_icmin_q6
print mf_su_sinkmin_tail
print mf_ss_sinkmin_tail
linearize
let mf_l = length(time)
let mfw = (time ge 1.99995e-08) * (time lt 3.99995e-08)
let mf_n = mean(mfw) * mf_l
let mfs = mf_l / mf_n
let mf_prail = mean(v(vdd) * (0 - i(vdd)) * mfw) * mfs
let mfph = 2 * pi * 18450000000.0 * (time - 2e-08)
let mf_lodiff_re = 2 * mean((v(lo_p)-v(lo_n)) * mfw * cos(mfph)) * mfs
let mf_lodiff_im = 2 * mean((v(lo_p)-v(lo_n)) * mfw * sin(mfph)) * mfs
let mfph = 2 * pi * 1000000000.0 * (time - 2e-08)
let mf_if_re = 2 * mean((v(if_out)) * mfw * cos(mfph)) * mfs
let mf_if_im = 2 * mean((v(if_out)) * mfw * sin(mfph)) * mfs
let mfph = 2 * pi * 18450000000.0 * (time - 2e-08)
let mf_loif_re = 2 * mean((v(if_out)) * mfw * cos(mfph)) * mfs
let mf_loif_im = 2 * mean((v(if_out)) * mfw * sin(mfph)) * mfs
let mfph = 2 * pi * 18450000000.0 * (time - 2e-08)
let mf_lorf_re = 2 * mean((v(rf_port)) * mfw * cos(mfph)) * mfs
let mf_lorf_im = 2 * mean((v(rf_port)) * mfw * sin(mfph)) * mfs
let mfph = 2 * pi * 950000000.0 * (time - 2e-08)
let mf_flifa_re = 2 * mean((v(if_out)) * mfw * cos(mfph)) * mfs
let mf_flifa_im = 2 * mean((v(if_out)) * mfw * sin(mfph)) * mfs
let mfph = 2 * pi * 1050000000.0 * (time - 2e-08)
let mf_flifb_re = 2 * mean((v(if_out)) * mfw * cos(mfph)) * mfs
let mf_flifb_im = 2 * mean((v(if_out)) * mfw * sin(mfph)) * mfs
let mfph = 2 * pi * 18500000000.0 * (time - 2e-08)
let mf_fllorf_re = 2 * mean((v(rf_port)) * mfw * cos(mfph)) * mfs
let mf_fllorf_im = 2 * mean((v(rf_port)) * mfw * sin(mfph)) * mfs
let mfph = 2 * pi * 18500000000.0 * (time - 2e-08)
let mf_flloif_re = 2 * mean((v(if_out)) * mfw * cos(mfph)) * mfs
let mf_flloif_im = 2 * mean((v(if_out)) * mfw * sin(mfph)) * mfs
print mf_l
print mf_n
print mf_prail
print mf_lodiff_re
print mf_lodiff_im
print mf_if_re
print mf_if_im
print mf_loif_re
print mf_loif_im
print mf_lorf_re
print mf_lorf_im
print mf_flifa_re
print mf_flifa_im
print mf_flifb_re
print mf_flifb_im
print mf_fllorf_re
print mf_fllorf_im
print mf_flloif_re
print mf_flloif_im
destroy all
echo "MFEND ls_f19p45_p0_rf60"
echo "MFRUN ls_f19p45_p0_rf66"
alterparam f1 = 19450000000.0
alterparam f2 = 19450000000.0
alterparam flo = 18450000000.0
alterparam vrf1 = 0.00031697863849222284
alterparam vrf2 = 0.0
alterparam vlo = 0.8944271909999159
reset
op
let mf_dcirail = 0 - i(vdd)
let mf_dc_vce_q1 = v(c_q1)-v(e_q1)
let mf_dc_vbe_q1 = v(b_q1)-v(e_q1)
let mf_dc_ic_q1 = i(vic_q1)
let mf_dc_vce_q2 = v(c_q2)-v(e_q2)
let mf_dc_vbe_q2 = v(b_q2)-v(e_q2)
let mf_dc_ic_q2 = i(vic_q2)
let mf_dc_vce_q3 = v(c_q3)-v(x1)
let mf_dc_vbe_q3 = v(lo_p)-v(x1)
let mf_dc_ic_q3 = i(vic_q3)
let mf_dc_vce_q4 = v(c_q4)-v(x1)
let mf_dc_vbe_q4 = v(lo_n)-v(x1)
let mf_dc_ic_q4 = i(vic_q4)
let mf_dc_vce_q5 = v(c_q5)-v(x2)
let mf_dc_vbe_q5 = v(lo_p)-v(x2)
let mf_dc_ic_q5 = i(vic_q5)
let mf_dc_vce_q6 = v(c_q6)-v(x2)
let mf_dc_vbe_q6 = v(lo_n)-v(x2)
let mf_dc_ic_q6 = i(vic_q6)
let mf_dc_sink_tail = v(tail)
print mf_dcirail
print mf_dc_vce_q1
print mf_dc_vbe_q1
print mf_dc_ic_q1
print mf_dc_vce_q2
print mf_dc_vbe_q2
print mf_dc_ic_q2
print mf_dc_vce_q3
print mf_dc_vbe_q3
print mf_dc_ic_q3
print mf_dc_vce_q4
print mf_dc_vbe_q4
print mf_dc_ic_q4
print mf_dc_vce_q5
print mf_dc_vbe_q5
print mf_dc_ic_q5
print mf_dc_vce_q6
print mf_dc_vbe_q6
print mf_dc_ic_q6
print mf_dc_sink_tail
tran 1e-12 4e-08 0 1e-12
let mfq_vce_q1 = v(c_q1)-v(e_q1)
meas tran mf_su_vcemax_q1 MAX mfq_vce_q1 from=0.0 to=2e-08
meas tran mf_su_vcemin_q1 MIN mfq_vce_q1 from=0.0 to=2e-08
meas tran mf_ss_vcemax_q1 MAX mfq_vce_q1 from=2e-08 to=4e-08
meas tran mf_ss_vcemin_q1 MIN mfq_vce_q1 from=2e-08 to=4e-08
let mfq_vbe_q1 = v(b_q1)-v(e_q1)
meas tran mf_su_vbemax_q1 MAX mfq_vbe_q1 from=0.0 to=2e-08
meas tran mf_su_vbemin_q1 MIN mfq_vbe_q1 from=0.0 to=2e-08
meas tran mf_ss_vbemax_q1 MAX mfq_vbe_q1 from=2e-08 to=4e-08
meas tran mf_ss_vbemin_q1 MIN mfq_vbe_q1 from=2e-08 to=4e-08
let mfq_ic_q1 = i(vic_q1)
meas tran mf_su_icmax_q1 MAX mfq_ic_q1 from=0.0 to=2e-08
meas tran mf_su_icmin_q1 MIN mfq_ic_q1 from=0.0 to=2e-08
meas tran mf_ss_icmax_q1 MAX mfq_ic_q1 from=2e-08 to=4e-08
meas tran mf_ss_icmin_q1 MIN mfq_ic_q1 from=2e-08 to=4e-08
let mfq_vce_q2 = v(c_q2)-v(e_q2)
meas tran mf_su_vcemax_q2 MAX mfq_vce_q2 from=0.0 to=2e-08
meas tran mf_su_vcemin_q2 MIN mfq_vce_q2 from=0.0 to=2e-08
meas tran mf_ss_vcemax_q2 MAX mfq_vce_q2 from=2e-08 to=4e-08
meas tran mf_ss_vcemin_q2 MIN mfq_vce_q2 from=2e-08 to=4e-08
let mfq_vbe_q2 = v(b_q2)-v(e_q2)
meas tran mf_su_vbemax_q2 MAX mfq_vbe_q2 from=0.0 to=2e-08
meas tran mf_su_vbemin_q2 MIN mfq_vbe_q2 from=0.0 to=2e-08
meas tran mf_ss_vbemax_q2 MAX mfq_vbe_q2 from=2e-08 to=4e-08
meas tran mf_ss_vbemin_q2 MIN mfq_vbe_q2 from=2e-08 to=4e-08
let mfq_ic_q2 = i(vic_q2)
meas tran mf_su_icmax_q2 MAX mfq_ic_q2 from=0.0 to=2e-08
meas tran mf_su_icmin_q2 MIN mfq_ic_q2 from=0.0 to=2e-08
meas tran mf_ss_icmax_q2 MAX mfq_ic_q2 from=2e-08 to=4e-08
meas tran mf_ss_icmin_q2 MIN mfq_ic_q2 from=2e-08 to=4e-08
let mfq_vce_q3 = v(c_q3)-v(x1)
meas tran mf_su_vcemax_q3 MAX mfq_vce_q3 from=0.0 to=2e-08
meas tran mf_su_vcemin_q3 MIN mfq_vce_q3 from=0.0 to=2e-08
meas tran mf_ss_vcemax_q3 MAX mfq_vce_q3 from=2e-08 to=4e-08
meas tran mf_ss_vcemin_q3 MIN mfq_vce_q3 from=2e-08 to=4e-08
let mfq_vbe_q3 = v(lo_p)-v(x1)
meas tran mf_su_vbemax_q3 MAX mfq_vbe_q3 from=0.0 to=2e-08
meas tran mf_su_vbemin_q3 MIN mfq_vbe_q3 from=0.0 to=2e-08
meas tran mf_ss_vbemax_q3 MAX mfq_vbe_q3 from=2e-08 to=4e-08
meas tran mf_ss_vbemin_q3 MIN mfq_vbe_q3 from=2e-08 to=4e-08
let mfq_ic_q3 = i(vic_q3)
meas tran mf_su_icmax_q3 MAX mfq_ic_q3 from=0.0 to=2e-08
meas tran mf_su_icmin_q3 MIN mfq_ic_q3 from=0.0 to=2e-08
meas tran mf_ss_icmax_q3 MAX mfq_ic_q3 from=2e-08 to=4e-08
meas tran mf_ss_icmin_q3 MIN mfq_ic_q3 from=2e-08 to=4e-08
let mfq_vce_q4 = v(c_q4)-v(x1)
meas tran mf_su_vcemax_q4 MAX mfq_vce_q4 from=0.0 to=2e-08
meas tran mf_su_vcemin_q4 MIN mfq_vce_q4 from=0.0 to=2e-08
meas tran mf_ss_vcemax_q4 MAX mfq_vce_q4 from=2e-08 to=4e-08
meas tran mf_ss_vcemin_q4 MIN mfq_vce_q4 from=2e-08 to=4e-08
let mfq_vbe_q4 = v(lo_n)-v(x1)
meas tran mf_su_vbemax_q4 MAX mfq_vbe_q4 from=0.0 to=2e-08
meas tran mf_su_vbemin_q4 MIN mfq_vbe_q4 from=0.0 to=2e-08
meas tran mf_ss_vbemax_q4 MAX mfq_vbe_q4 from=2e-08 to=4e-08
meas tran mf_ss_vbemin_q4 MIN mfq_vbe_q4 from=2e-08 to=4e-08
let mfq_ic_q4 = i(vic_q4)
meas tran mf_su_icmax_q4 MAX mfq_ic_q4 from=0.0 to=2e-08
meas tran mf_su_icmin_q4 MIN mfq_ic_q4 from=0.0 to=2e-08
meas tran mf_ss_icmax_q4 MAX mfq_ic_q4 from=2e-08 to=4e-08
meas tran mf_ss_icmin_q4 MIN mfq_ic_q4 from=2e-08 to=4e-08
let mfq_vce_q5 = v(c_q5)-v(x2)
meas tran mf_su_vcemax_q5 MAX mfq_vce_q5 from=0.0 to=2e-08
meas tran mf_su_vcemin_q5 MIN mfq_vce_q5 from=0.0 to=2e-08
meas tran mf_ss_vcemax_q5 MAX mfq_vce_q5 from=2e-08 to=4e-08
meas tran mf_ss_vcemin_q5 MIN mfq_vce_q5 from=2e-08 to=4e-08
let mfq_vbe_q5 = v(lo_p)-v(x2)
meas tran mf_su_vbemax_q5 MAX mfq_vbe_q5 from=0.0 to=2e-08
meas tran mf_su_vbemin_q5 MIN mfq_vbe_q5 from=0.0 to=2e-08
meas tran mf_ss_vbemax_q5 MAX mfq_vbe_q5 from=2e-08 to=4e-08
meas tran mf_ss_vbemin_q5 MIN mfq_vbe_q5 from=2e-08 to=4e-08
let mfq_ic_q5 = i(vic_q5)
meas tran mf_su_icmax_q5 MAX mfq_ic_q5 from=0.0 to=2e-08
meas tran mf_su_icmin_q5 MIN mfq_ic_q5 from=0.0 to=2e-08
meas tran mf_ss_icmax_q5 MAX mfq_ic_q5 from=2e-08 to=4e-08
meas tran mf_ss_icmin_q5 MIN mfq_ic_q5 from=2e-08 to=4e-08
let mfq_vce_q6 = v(c_q6)-v(x2)
meas tran mf_su_vcemax_q6 MAX mfq_vce_q6 from=0.0 to=2e-08
meas tran mf_su_vcemin_q6 MIN mfq_vce_q6 from=0.0 to=2e-08
meas tran mf_ss_vcemax_q6 MAX mfq_vce_q6 from=2e-08 to=4e-08
meas tran mf_ss_vcemin_q6 MIN mfq_vce_q6 from=2e-08 to=4e-08
let mfq_vbe_q6 = v(lo_n)-v(x2)
meas tran mf_su_vbemax_q6 MAX mfq_vbe_q6 from=0.0 to=2e-08
meas tran mf_su_vbemin_q6 MIN mfq_vbe_q6 from=0.0 to=2e-08
meas tran mf_ss_vbemax_q6 MAX mfq_vbe_q6 from=2e-08 to=4e-08
meas tran mf_ss_vbemin_q6 MIN mfq_vbe_q6 from=2e-08 to=4e-08
let mfq_ic_q6 = i(vic_q6)
meas tran mf_su_icmax_q6 MAX mfq_ic_q6 from=0.0 to=2e-08
meas tran mf_su_icmin_q6 MIN mfq_ic_q6 from=0.0 to=2e-08
meas tran mf_ss_icmax_q6 MAX mfq_ic_q6 from=2e-08 to=4e-08
meas tran mf_ss_icmin_q6 MIN mfq_ic_q6 from=2e-08 to=4e-08
meas tran mf_su_sinkmin_tail MIN v(tail) from=0.0 to=2e-08
meas tran mf_ss_sinkmin_tail MIN v(tail) from=2e-08 to=4e-08
print mf_su_vcemax_q1
print mf_su_vcemin_q1
print mf_ss_vcemax_q1
print mf_ss_vcemin_q1
print mf_su_vbemax_q1
print mf_su_vbemin_q1
print mf_ss_vbemax_q1
print mf_ss_vbemin_q1
print mf_su_icmax_q1
print mf_su_icmin_q1
print mf_ss_icmax_q1
print mf_ss_icmin_q1
print mf_su_vcemax_q2
print mf_su_vcemin_q2
print mf_ss_vcemax_q2
print mf_ss_vcemin_q2
print mf_su_vbemax_q2
print mf_su_vbemin_q2
print mf_ss_vbemax_q2
print mf_ss_vbemin_q2
print mf_su_icmax_q2
print mf_su_icmin_q2
print mf_ss_icmax_q2
print mf_ss_icmin_q2
print mf_su_vcemax_q3
print mf_su_vcemin_q3
print mf_ss_vcemax_q3
print mf_ss_vcemin_q3
print mf_su_vbemax_q3
print mf_su_vbemin_q3
print mf_ss_vbemax_q3
print mf_ss_vbemin_q3
print mf_su_icmax_q3
print mf_su_icmin_q3
print mf_ss_icmax_q3
print mf_ss_icmin_q3
print mf_su_vcemax_q4
print mf_su_vcemin_q4
print mf_ss_vcemax_q4
print mf_ss_vcemin_q4
print mf_su_vbemax_q4
print mf_su_vbemin_q4
print mf_ss_vbemax_q4
print mf_ss_vbemin_q4
print mf_su_icmax_q4
print mf_su_icmin_q4
print mf_ss_icmax_q4
print mf_ss_icmin_q4
print mf_su_vcemax_q5
print mf_su_vcemin_q5
print mf_ss_vcemax_q5
print mf_ss_vcemin_q5
print mf_su_vbemax_q5
print mf_su_vbemin_q5
print mf_ss_vbemax_q5
print mf_ss_vbemin_q5
print mf_su_icmax_q5
print mf_su_icmin_q5
print mf_ss_icmax_q5
print mf_ss_icmin_q5
print mf_su_vcemax_q6
print mf_su_vcemin_q6
print mf_ss_vcemax_q6
print mf_ss_vcemin_q6
print mf_su_vbemax_q6
print mf_su_vbemin_q6
print mf_ss_vbemax_q6
print mf_ss_vbemin_q6
print mf_su_icmax_q6
print mf_su_icmin_q6
print mf_ss_icmax_q6
print mf_ss_icmin_q6
print mf_su_sinkmin_tail
print mf_ss_sinkmin_tail
linearize
let mf_l = length(time)
let mfw = (time ge 1.99995e-08) * (time lt 3.99995e-08)
let mf_n = mean(mfw) * mf_l
let mfs = mf_l / mf_n
let mf_prail = mean(v(vdd) * (0 - i(vdd)) * mfw) * mfs
let mfph = 2 * pi * 18450000000.0 * (time - 2e-08)
let mf_lodiff_re = 2 * mean((v(lo_p)-v(lo_n)) * mfw * cos(mfph)) * mfs
let mf_lodiff_im = 2 * mean((v(lo_p)-v(lo_n)) * mfw * sin(mfph)) * mfs
let mfph = 2 * pi * 1000000000.0 * (time - 2e-08)
let mf_if_re = 2 * mean((v(if_out)) * mfw * cos(mfph)) * mfs
let mf_if_im = 2 * mean((v(if_out)) * mfw * sin(mfph)) * mfs
let mfph = 2 * pi * 18450000000.0 * (time - 2e-08)
let mf_loif_re = 2 * mean((v(if_out)) * mfw * cos(mfph)) * mfs
let mf_loif_im = 2 * mean((v(if_out)) * mfw * sin(mfph)) * mfs
let mfph = 2 * pi * 18450000000.0 * (time - 2e-08)
let mf_lorf_re = 2 * mean((v(rf_port)) * mfw * cos(mfph)) * mfs
let mf_lorf_im = 2 * mean((v(rf_port)) * mfw * sin(mfph)) * mfs
let mfph = 2 * pi * 950000000.0 * (time - 2e-08)
let mf_flifa_re = 2 * mean((v(if_out)) * mfw * cos(mfph)) * mfs
let mf_flifa_im = 2 * mean((v(if_out)) * mfw * sin(mfph)) * mfs
let mfph = 2 * pi * 1050000000.0 * (time - 2e-08)
let mf_flifb_re = 2 * mean((v(if_out)) * mfw * cos(mfph)) * mfs
let mf_flifb_im = 2 * mean((v(if_out)) * mfw * sin(mfph)) * mfs
let mfph = 2 * pi * 18500000000.0 * (time - 2e-08)
let mf_fllorf_re = 2 * mean((v(rf_port)) * mfw * cos(mfph)) * mfs
let mf_fllorf_im = 2 * mean((v(rf_port)) * mfw * sin(mfph)) * mfs
let mfph = 2 * pi * 18500000000.0 * (time - 2e-08)
let mf_flloif_re = 2 * mean((v(if_out)) * mfw * cos(mfph)) * mfs
let mf_flloif_im = 2 * mean((v(if_out)) * mfw * sin(mfph)) * mfs
print mf_l
print mf_n
print mf_prail
print mf_lodiff_re
print mf_lodiff_im
print mf_if_re
print mf_if_im
print mf_loif_re
print mf_loif_im
print mf_lorf_re
print mf_lorf_im
print mf_flifa_re
print mf_flifa_im
print mf_flifb_re
print mf_flifb_im
print mf_fllorf_re
print mf_fllorf_im
print mf_flloif_re
print mf_flloif_im
destroy all
echo "MFEND ls_f19p45_p0_rf66"
echo "MFRUN ls_f19p45_p3_rf60"
alterparam f1 = 19450000000.0
alterparam f2 = 19450000000.0
alterparam flo = 18450000000.0
alterparam vrf1 = 0.0006324555320336759
alterparam vrf2 = 0.0
alterparam vlo = 1.2634119882188484
reset
op
let mf_dcirail = 0 - i(vdd)
let mf_dc_vce_q1 = v(c_q1)-v(e_q1)
let mf_dc_vbe_q1 = v(b_q1)-v(e_q1)
let mf_dc_ic_q1 = i(vic_q1)
let mf_dc_vce_q2 = v(c_q2)-v(e_q2)
let mf_dc_vbe_q2 = v(b_q2)-v(e_q2)
let mf_dc_ic_q2 = i(vic_q2)
let mf_dc_vce_q3 = v(c_q3)-v(x1)
let mf_dc_vbe_q3 = v(lo_p)-v(x1)
let mf_dc_ic_q3 = i(vic_q3)
let mf_dc_vce_q4 = v(c_q4)-v(x1)
let mf_dc_vbe_q4 = v(lo_n)-v(x1)
let mf_dc_ic_q4 = i(vic_q4)
let mf_dc_vce_q5 = v(c_q5)-v(x2)
let mf_dc_vbe_q5 = v(lo_p)-v(x2)
let mf_dc_ic_q5 = i(vic_q5)
let mf_dc_vce_q6 = v(c_q6)-v(x2)
let mf_dc_vbe_q6 = v(lo_n)-v(x2)
let mf_dc_ic_q6 = i(vic_q6)
let mf_dc_sink_tail = v(tail)
print mf_dcirail
print mf_dc_vce_q1
print mf_dc_vbe_q1
print mf_dc_ic_q1
print mf_dc_vce_q2
print mf_dc_vbe_q2
print mf_dc_ic_q2
print mf_dc_vce_q3
print mf_dc_vbe_q3
print mf_dc_ic_q3
print mf_dc_vce_q4
print mf_dc_vbe_q4
print mf_dc_ic_q4
print mf_dc_vce_q5
print mf_dc_vbe_q5
print mf_dc_ic_q5
print mf_dc_vce_q6
print mf_dc_vbe_q6
print mf_dc_ic_q6
print mf_dc_sink_tail
tran 1e-12 4e-08 0 1e-12
let mfq_vce_q1 = v(c_q1)-v(e_q1)
meas tran mf_su_vcemax_q1 MAX mfq_vce_q1 from=0.0 to=2e-08
meas tran mf_su_vcemin_q1 MIN mfq_vce_q1 from=0.0 to=2e-08
meas tran mf_ss_vcemax_q1 MAX mfq_vce_q1 from=2e-08 to=4e-08
meas tran mf_ss_vcemin_q1 MIN mfq_vce_q1 from=2e-08 to=4e-08
let mfq_vbe_q1 = v(b_q1)-v(e_q1)
meas tran mf_su_vbemax_q1 MAX mfq_vbe_q1 from=0.0 to=2e-08
meas tran mf_su_vbemin_q1 MIN mfq_vbe_q1 from=0.0 to=2e-08
meas tran mf_ss_vbemax_q1 MAX mfq_vbe_q1 from=2e-08 to=4e-08
meas tran mf_ss_vbemin_q1 MIN mfq_vbe_q1 from=2e-08 to=4e-08
let mfq_ic_q1 = i(vic_q1)
meas tran mf_su_icmax_q1 MAX mfq_ic_q1 from=0.0 to=2e-08
meas tran mf_su_icmin_q1 MIN mfq_ic_q1 from=0.0 to=2e-08
meas tran mf_ss_icmax_q1 MAX mfq_ic_q1 from=2e-08 to=4e-08
meas tran mf_ss_icmin_q1 MIN mfq_ic_q1 from=2e-08 to=4e-08
let mfq_vce_q2 = v(c_q2)-v(e_q2)
meas tran mf_su_vcemax_q2 MAX mfq_vce_q2 from=0.0 to=2e-08
meas tran mf_su_vcemin_q2 MIN mfq_vce_q2 from=0.0 to=2e-08
meas tran mf_ss_vcemax_q2 MAX mfq_vce_q2 from=2e-08 to=4e-08
meas tran mf_ss_vcemin_q2 MIN mfq_vce_q2 from=2e-08 to=4e-08
let mfq_vbe_q2 = v(b_q2)-v(e_q2)
meas tran mf_su_vbemax_q2 MAX mfq_vbe_q2 from=0.0 to=2e-08
meas tran mf_su_vbemin_q2 MIN mfq_vbe_q2 from=0.0 to=2e-08
meas tran mf_ss_vbemax_q2 MAX mfq_vbe_q2 from=2e-08 to=4e-08
meas tran mf_ss_vbemin_q2 MIN mfq_vbe_q2 from=2e-08 to=4e-08
let mfq_ic_q2 = i(vic_q2)
meas tran mf_su_icmax_q2 MAX mfq_ic_q2 from=0.0 to=2e-08
meas tran mf_su_icmin_q2 MIN mfq_ic_q2 from=0.0 to=2e-08
meas tran mf_ss_icmax_q2 MAX mfq_ic_q2 from=2e-08 to=4e-08
meas tran mf_ss_icmin_q2 MIN mfq_ic_q2 from=2e-08 to=4e-08
let mfq_vce_q3 = v(c_q3)-v(x1)
meas tran mf_su_vcemax_q3 MAX mfq_vce_q3 from=0.0 to=2e-08
meas tran mf_su_vcemin_q3 MIN mfq_vce_q3 from=0.0 to=2e-08
meas tran mf_ss_vcemax_q3 MAX mfq_vce_q3 from=2e-08 to=4e-08
meas tran mf_ss_vcemin_q3 MIN mfq_vce_q3 from=2e-08 to=4e-08
let mfq_vbe_q3 = v(lo_p)-v(x1)
meas tran mf_su_vbemax_q3 MAX mfq_vbe_q3 from=0.0 to=2e-08
meas tran mf_su_vbemin_q3 MIN mfq_vbe_q3 from=0.0 to=2e-08
meas tran mf_ss_vbemax_q3 MAX mfq_vbe_q3 from=2e-08 to=4e-08
meas tran mf_ss_vbemin_q3 MIN mfq_vbe_q3 from=2e-08 to=4e-08
let mfq_ic_q3 = i(vic_q3)
meas tran mf_su_icmax_q3 MAX mfq_ic_q3 from=0.0 to=2e-08
meas tran mf_su_icmin_q3 MIN mfq_ic_q3 from=0.0 to=2e-08
meas tran mf_ss_icmax_q3 MAX mfq_ic_q3 from=2e-08 to=4e-08
meas tran mf_ss_icmin_q3 MIN mfq_ic_q3 from=2e-08 to=4e-08
let mfq_vce_q4 = v(c_q4)-v(x1)
meas tran mf_su_vcemax_q4 MAX mfq_vce_q4 from=0.0 to=2e-08
meas tran mf_su_vcemin_q4 MIN mfq_vce_q4 from=0.0 to=2e-08
meas tran mf_ss_vcemax_q4 MAX mfq_vce_q4 from=2e-08 to=4e-08
meas tran mf_ss_vcemin_q4 MIN mfq_vce_q4 from=2e-08 to=4e-08
let mfq_vbe_q4 = v(lo_n)-v(x1)
meas tran mf_su_vbemax_q4 MAX mfq_vbe_q4 from=0.0 to=2e-08
meas tran mf_su_vbemin_q4 MIN mfq_vbe_q4 from=0.0 to=2e-08
meas tran mf_ss_vbemax_q4 MAX mfq_vbe_q4 from=2e-08 to=4e-08
meas tran mf_ss_vbemin_q4 MIN mfq_vbe_q4 from=2e-08 to=4e-08
let mfq_ic_q4 = i(vic_q4)
meas tran mf_su_icmax_q4 MAX mfq_ic_q4 from=0.0 to=2e-08
meas tran mf_su_icmin_q4 MIN mfq_ic_q4 from=0.0 to=2e-08
meas tran mf_ss_icmax_q4 MAX mfq_ic_q4 from=2e-08 to=4e-08
meas tran mf_ss_icmin_q4 MIN mfq_ic_q4 from=2e-08 to=4e-08
let mfq_vce_q5 = v(c_q5)-v(x2)
meas tran mf_su_vcemax_q5 MAX mfq_vce_q5 from=0.0 to=2e-08
meas tran mf_su_vcemin_q5 MIN mfq_vce_q5 from=0.0 to=2e-08
meas tran mf_ss_vcemax_q5 MAX mfq_vce_q5 from=2e-08 to=4e-08
meas tran mf_ss_vcemin_q5 MIN mfq_vce_q5 from=2e-08 to=4e-08
let mfq_vbe_q5 = v(lo_p)-v(x2)
meas tran mf_su_vbemax_q5 MAX mfq_vbe_q5 from=0.0 to=2e-08
meas tran mf_su_vbemin_q5 MIN mfq_vbe_q5 from=0.0 to=2e-08
meas tran mf_ss_vbemax_q5 MAX mfq_vbe_q5 from=2e-08 to=4e-08
meas tran mf_ss_vbemin_q5 MIN mfq_vbe_q5 from=2e-08 to=4e-08
let mfq_ic_q5 = i(vic_q5)
meas tran mf_su_icmax_q5 MAX mfq_ic_q5 from=0.0 to=2e-08
meas tran mf_su_icmin_q5 MIN mfq_ic_q5 from=0.0 to=2e-08
meas tran mf_ss_icmax_q5 MAX mfq_ic_q5 from=2e-08 to=4e-08
meas tran mf_ss_icmin_q5 MIN mfq_ic_q5 from=2e-08 to=4e-08
let mfq_vce_q6 = v(c_q6)-v(x2)
meas tran mf_su_vcemax_q6 MAX mfq_vce_q6 from=0.0 to=2e-08
meas tran mf_su_vcemin_q6 MIN mfq_vce_q6 from=0.0 to=2e-08
meas tran mf_ss_vcemax_q6 MAX mfq_vce_q6 from=2e-08 to=4e-08
meas tran mf_ss_vcemin_q6 MIN mfq_vce_q6 from=2e-08 to=4e-08
let mfq_vbe_q6 = v(lo_n)-v(x2)
meas tran mf_su_vbemax_q6 MAX mfq_vbe_q6 from=0.0 to=2e-08
meas tran mf_su_vbemin_q6 MIN mfq_vbe_q6 from=0.0 to=2e-08
meas tran mf_ss_vbemax_q6 MAX mfq_vbe_q6 from=2e-08 to=4e-08
meas tran mf_ss_vbemin_q6 MIN mfq_vbe_q6 from=2e-08 to=4e-08
let mfq_ic_q6 = i(vic_q6)
meas tran mf_su_icmax_q6 MAX mfq_ic_q6 from=0.0 to=2e-08
meas tran mf_su_icmin_q6 MIN mfq_ic_q6 from=0.0 to=2e-08
meas tran mf_ss_icmax_q6 MAX mfq_ic_q6 from=2e-08 to=4e-08
meas tran mf_ss_icmin_q6 MIN mfq_ic_q6 from=2e-08 to=4e-08
meas tran mf_su_sinkmin_tail MIN v(tail) from=0.0 to=2e-08
meas tran mf_ss_sinkmin_tail MIN v(tail) from=2e-08 to=4e-08
print mf_su_vcemax_q1
print mf_su_vcemin_q1
print mf_ss_vcemax_q1
print mf_ss_vcemin_q1
print mf_su_vbemax_q1
print mf_su_vbemin_q1
print mf_ss_vbemax_q1
print mf_ss_vbemin_q1
print mf_su_icmax_q1
print mf_su_icmin_q1
print mf_ss_icmax_q1
print mf_ss_icmin_q1
print mf_su_vcemax_q2
print mf_su_vcemin_q2
print mf_ss_vcemax_q2
print mf_ss_vcemin_q2
print mf_su_vbemax_q2
print mf_su_vbemin_q2
print mf_ss_vbemax_q2
print mf_ss_vbemin_q2
print mf_su_icmax_q2
print mf_su_icmin_q2
print mf_ss_icmax_q2
print mf_ss_icmin_q2
print mf_su_vcemax_q3
print mf_su_vcemin_q3
print mf_ss_vcemax_q3
print mf_ss_vcemin_q3
print mf_su_vbemax_q3
print mf_su_vbemin_q3
print mf_ss_vbemax_q3
print mf_ss_vbemin_q3
print mf_su_icmax_q3
print mf_su_icmin_q3
print mf_ss_icmax_q3
print mf_ss_icmin_q3
print mf_su_vcemax_q4
print mf_su_vcemin_q4
print mf_ss_vcemax_q4
print mf_ss_vcemin_q4
print mf_su_vbemax_q4
print mf_su_vbemin_q4
print mf_ss_vbemax_q4
print mf_ss_vbemin_q4
print mf_su_icmax_q4
print mf_su_icmin_q4
print mf_ss_icmax_q4
print mf_ss_icmin_q4
print mf_su_vcemax_q5
print mf_su_vcemin_q5
print mf_ss_vcemax_q5
print mf_ss_vcemin_q5
print mf_su_vbemax_q5
print mf_su_vbemin_q5
print mf_ss_vbemax_q5
print mf_ss_vbemin_q5
print mf_su_icmax_q5
print mf_su_icmin_q5
print mf_ss_icmax_q5
print mf_ss_icmin_q5
print mf_su_vcemax_q6
print mf_su_vcemin_q6
print mf_ss_vcemax_q6
print mf_ss_vcemin_q6
print mf_su_vbemax_q6
print mf_su_vbemin_q6
print mf_ss_vbemax_q6
print mf_ss_vbemin_q6
print mf_su_icmax_q6
print mf_su_icmin_q6
print mf_ss_icmax_q6
print mf_ss_icmin_q6
print mf_su_sinkmin_tail
print mf_ss_sinkmin_tail
linearize
let mf_l = length(time)
let mfw = (time ge 1.99995e-08) * (time lt 3.99995e-08)
let mf_n = mean(mfw) * mf_l
let mfs = mf_l / mf_n
let mf_prail = mean(v(vdd) * (0 - i(vdd)) * mfw) * mfs
let mfph = 2 * pi * 18450000000.0 * (time - 2e-08)
let mf_lodiff_re = 2 * mean((v(lo_p)-v(lo_n)) * mfw * cos(mfph)) * mfs
let mf_lodiff_im = 2 * mean((v(lo_p)-v(lo_n)) * mfw * sin(mfph)) * mfs
let mfph = 2 * pi * 1000000000.0 * (time - 2e-08)
let mf_if_re = 2 * mean((v(if_out)) * mfw * cos(mfph)) * mfs
let mf_if_im = 2 * mean((v(if_out)) * mfw * sin(mfph)) * mfs
let mfph = 2 * pi * 18450000000.0 * (time - 2e-08)
let mf_loif_re = 2 * mean((v(if_out)) * mfw * cos(mfph)) * mfs
let mf_loif_im = 2 * mean((v(if_out)) * mfw * sin(mfph)) * mfs
let mfph = 2 * pi * 18450000000.0 * (time - 2e-08)
let mf_lorf_re = 2 * mean((v(rf_port)) * mfw * cos(mfph)) * mfs
let mf_lorf_im = 2 * mean((v(rf_port)) * mfw * sin(mfph)) * mfs
let mfph = 2 * pi * 950000000.0 * (time - 2e-08)
let mf_flifa_re = 2 * mean((v(if_out)) * mfw * cos(mfph)) * mfs
let mf_flifa_im = 2 * mean((v(if_out)) * mfw * sin(mfph)) * mfs
let mfph = 2 * pi * 1050000000.0 * (time - 2e-08)
let mf_flifb_re = 2 * mean((v(if_out)) * mfw * cos(mfph)) * mfs
let mf_flifb_im = 2 * mean((v(if_out)) * mfw * sin(mfph)) * mfs
let mfph = 2 * pi * 18500000000.0 * (time - 2e-08)
let mf_fllorf_re = 2 * mean((v(rf_port)) * mfw * cos(mfph)) * mfs
let mf_fllorf_im = 2 * mean((v(rf_port)) * mfw * sin(mfph)) * mfs
let mfph = 2 * pi * 18500000000.0 * (time - 2e-08)
let mf_flloif_re = 2 * mean((v(if_out)) * mfw * cos(mfph)) * mfs
let mf_flloif_im = 2 * mean((v(if_out)) * mfw * sin(mfph)) * mfs
print mf_l
print mf_n
print mf_prail
print mf_lodiff_re
print mf_lodiff_im
print mf_if_re
print mf_if_im
print mf_loif_re
print mf_loif_im
print mf_lorf_re
print mf_lorf_im
print mf_flifa_re
print mf_flifa_im
print mf_flifb_re
print mf_flifb_im
print mf_fllorf_re
print mf_fllorf_im
print mf_flloif_re
print mf_flloif_im
destroy all
echo "MFEND ls_f19p45_p3_rf60"
echo "MFRUN ls_f19p45_p3_rf66"
alterparam f1 = 19450000000.0
alterparam f2 = 19450000000.0
alterparam flo = 18450000000.0
alterparam vrf1 = 0.00031697863849222284
alterparam vrf2 = 0.0
alterparam vlo = 1.2634119882188484
reset
op
let mf_dcirail = 0 - i(vdd)
let mf_dc_vce_q1 = v(c_q1)-v(e_q1)
let mf_dc_vbe_q1 = v(b_q1)-v(e_q1)
let mf_dc_ic_q1 = i(vic_q1)
let mf_dc_vce_q2 = v(c_q2)-v(e_q2)
let mf_dc_vbe_q2 = v(b_q2)-v(e_q2)
let mf_dc_ic_q2 = i(vic_q2)
let mf_dc_vce_q3 = v(c_q3)-v(x1)
let mf_dc_vbe_q3 = v(lo_p)-v(x1)
let mf_dc_ic_q3 = i(vic_q3)
let mf_dc_vce_q4 = v(c_q4)-v(x1)
let mf_dc_vbe_q4 = v(lo_n)-v(x1)
let mf_dc_ic_q4 = i(vic_q4)
let mf_dc_vce_q5 = v(c_q5)-v(x2)
let mf_dc_vbe_q5 = v(lo_p)-v(x2)
let mf_dc_ic_q5 = i(vic_q5)
let mf_dc_vce_q6 = v(c_q6)-v(x2)
let mf_dc_vbe_q6 = v(lo_n)-v(x2)
let mf_dc_ic_q6 = i(vic_q6)
let mf_dc_sink_tail = v(tail)
print mf_dcirail
print mf_dc_vce_q1
print mf_dc_vbe_q1
print mf_dc_ic_q1
print mf_dc_vce_q2
print mf_dc_vbe_q2
print mf_dc_ic_q2
print mf_dc_vce_q3
print mf_dc_vbe_q3
print mf_dc_ic_q3
print mf_dc_vce_q4
print mf_dc_vbe_q4
print mf_dc_ic_q4
print mf_dc_vce_q5
print mf_dc_vbe_q5
print mf_dc_ic_q5
print mf_dc_vce_q6
print mf_dc_vbe_q6
print mf_dc_ic_q6
print mf_dc_sink_tail
tran 1e-12 4e-08 0 1e-12
let mfq_vce_q1 = v(c_q1)-v(e_q1)
meas tran mf_su_vcemax_q1 MAX mfq_vce_q1 from=0.0 to=2e-08
meas tran mf_su_vcemin_q1 MIN mfq_vce_q1 from=0.0 to=2e-08
meas tran mf_ss_vcemax_q1 MAX mfq_vce_q1 from=2e-08 to=4e-08
meas tran mf_ss_vcemin_q1 MIN mfq_vce_q1 from=2e-08 to=4e-08
let mfq_vbe_q1 = v(b_q1)-v(e_q1)
meas tran mf_su_vbemax_q1 MAX mfq_vbe_q1 from=0.0 to=2e-08
meas tran mf_su_vbemin_q1 MIN mfq_vbe_q1 from=0.0 to=2e-08
meas tran mf_ss_vbemax_q1 MAX mfq_vbe_q1 from=2e-08 to=4e-08
meas tran mf_ss_vbemin_q1 MIN mfq_vbe_q1 from=2e-08 to=4e-08
let mfq_ic_q1 = i(vic_q1)
meas tran mf_su_icmax_q1 MAX mfq_ic_q1 from=0.0 to=2e-08
meas tran mf_su_icmin_q1 MIN mfq_ic_q1 from=0.0 to=2e-08
meas tran mf_ss_icmax_q1 MAX mfq_ic_q1 from=2e-08 to=4e-08
meas tran mf_ss_icmin_q1 MIN mfq_ic_q1 from=2e-08 to=4e-08
let mfq_vce_q2 = v(c_q2)-v(e_q2)
meas tran mf_su_vcemax_q2 MAX mfq_vce_q2 from=0.0 to=2e-08
meas tran mf_su_vcemin_q2 MIN mfq_vce_q2 from=0.0 to=2e-08
meas tran mf_ss_vcemax_q2 MAX mfq_vce_q2 from=2e-08 to=4e-08
meas tran mf_ss_vcemin_q2 MIN mfq_vce_q2 from=2e-08 to=4e-08
let mfq_vbe_q2 = v(b_q2)-v(e_q2)
meas tran mf_su_vbemax_q2 MAX mfq_vbe_q2 from=0.0 to=2e-08
meas tran mf_su_vbemin_q2 MIN mfq_vbe_q2 from=0.0 to=2e-08
meas tran mf_ss_vbemax_q2 MAX mfq_vbe_q2 from=2e-08 to=4e-08
meas tran mf_ss_vbemin_q2 MIN mfq_vbe_q2 from=2e-08 to=4e-08
let mfq_ic_q2 = i(vic_q2)
meas tran mf_su_icmax_q2 MAX mfq_ic_q2 from=0.0 to=2e-08
meas tran mf_su_icmin_q2 MIN mfq_ic_q2 from=0.0 to=2e-08
meas tran mf_ss_icmax_q2 MAX mfq_ic_q2 from=2e-08 to=4e-08
meas tran mf_ss_icmin_q2 MIN mfq_ic_q2 from=2e-08 to=4e-08
let mfq_vce_q3 = v(c_q3)-v(x1)
meas tran mf_su_vcemax_q3 MAX mfq_vce_q3 from=0.0 to=2e-08
meas tran mf_su_vcemin_q3 MIN mfq_vce_q3 from=0.0 to=2e-08
meas tran mf_ss_vcemax_q3 MAX mfq_vce_q3 from=2e-08 to=4e-08
meas tran mf_ss_vcemin_q3 MIN mfq_vce_q3 from=2e-08 to=4e-08
let mfq_vbe_q3 = v(lo_p)-v(x1)
meas tran mf_su_vbemax_q3 MAX mfq_vbe_q3 from=0.0 to=2e-08
meas tran mf_su_vbemin_q3 MIN mfq_vbe_q3 from=0.0 to=2e-08
meas tran mf_ss_vbemax_q3 MAX mfq_vbe_q3 from=2e-08 to=4e-08
meas tran mf_ss_vbemin_q3 MIN mfq_vbe_q3 from=2e-08 to=4e-08
let mfq_ic_q3 = i(vic_q3)
meas tran mf_su_icmax_q3 MAX mfq_ic_q3 from=0.0 to=2e-08
meas tran mf_su_icmin_q3 MIN mfq_ic_q3 from=0.0 to=2e-08
meas tran mf_ss_icmax_q3 MAX mfq_ic_q3 from=2e-08 to=4e-08
meas tran mf_ss_icmin_q3 MIN mfq_ic_q3 from=2e-08 to=4e-08
let mfq_vce_q4 = v(c_q4)-v(x1)
meas tran mf_su_vcemax_q4 MAX mfq_vce_q4 from=0.0 to=2e-08
meas tran mf_su_vcemin_q4 MIN mfq_vce_q4 from=0.0 to=2e-08
meas tran mf_ss_vcemax_q4 MAX mfq_vce_q4 from=2e-08 to=4e-08
meas tran mf_ss_vcemin_q4 MIN mfq_vce_q4 from=2e-08 to=4e-08
let mfq_vbe_q4 = v(lo_n)-v(x1)
meas tran mf_su_vbemax_q4 MAX mfq_vbe_q4 from=0.0 to=2e-08
meas tran mf_su_vbemin_q4 MIN mfq_vbe_q4 from=0.0 to=2e-08
meas tran mf_ss_vbemax_q4 MAX mfq_vbe_q4 from=2e-08 to=4e-08
meas tran mf_ss_vbemin_q4 MIN mfq_vbe_q4 from=2e-08 to=4e-08
let mfq_ic_q4 = i(vic_q4)
meas tran mf_su_icmax_q4 MAX mfq_ic_q4 from=0.0 to=2e-08
meas tran mf_su_icmin_q4 MIN mfq_ic_q4 from=0.0 to=2e-08
meas tran mf_ss_icmax_q4 MAX mfq_ic_q4 from=2e-08 to=4e-08
meas tran mf_ss_icmin_q4 MIN mfq_ic_q4 from=2e-08 to=4e-08
let mfq_vce_q5 = v(c_q5)-v(x2)
meas tran mf_su_vcemax_q5 MAX mfq_vce_q5 from=0.0 to=2e-08
meas tran mf_su_vcemin_q5 MIN mfq_vce_q5 from=0.0 to=2e-08
meas tran mf_ss_vcemax_q5 MAX mfq_vce_q5 from=2e-08 to=4e-08
meas tran mf_ss_vcemin_q5 MIN mfq_vce_q5 from=2e-08 to=4e-08
let mfq_vbe_q5 = v(lo_p)-v(x2)
meas tran mf_su_vbemax_q5 MAX mfq_vbe_q5 from=0.0 to=2e-08
meas tran mf_su_vbemin_q5 MIN mfq_vbe_q5 from=0.0 to=2e-08
meas tran mf_ss_vbemax_q5 MAX mfq_vbe_q5 from=2e-08 to=4e-08
meas tran mf_ss_vbemin_q5 MIN mfq_vbe_q5 from=2e-08 to=4e-08
let mfq_ic_q5 = i(vic_q5)
meas tran mf_su_icmax_q5 MAX mfq_ic_q5 from=0.0 to=2e-08
meas tran mf_su_icmin_q5 MIN mfq_ic_q5 from=0.0 to=2e-08
meas tran mf_ss_icmax_q5 MAX mfq_ic_q5 from=2e-08 to=4e-08
meas tran mf_ss_icmin_q5 MIN mfq_ic_q5 from=2e-08 to=4e-08
let mfq_vce_q6 = v(c_q6)-v(x2)
meas tran mf_su_vcemax_q6 MAX mfq_vce_q6 from=0.0 to=2e-08
meas tran mf_su_vcemin_q6 MIN mfq_vce_q6 from=0.0 to=2e-08
meas tran mf_ss_vcemax_q6 MAX mfq_vce_q6 from=2e-08 to=4e-08
meas tran mf_ss_vcemin_q6 MIN mfq_vce_q6 from=2e-08 to=4e-08
let mfq_vbe_q6 = v(lo_n)-v(x2)
meas tran mf_su_vbemax_q6 MAX mfq_vbe_q6 from=0.0 to=2e-08
meas tran mf_su_vbemin_q6 MIN mfq_vbe_q6 from=0.0 to=2e-08
meas tran mf_ss_vbemax_q6 MAX mfq_vbe_q6 from=2e-08 to=4e-08
meas tran mf_ss_vbemin_q6 MIN mfq_vbe_q6 from=2e-08 to=4e-08
let mfq_ic_q6 = i(vic_q6)
meas tran mf_su_icmax_q6 MAX mfq_ic_q6 from=0.0 to=2e-08
meas tran mf_su_icmin_q6 MIN mfq_ic_q6 from=0.0 to=2e-08
meas tran mf_ss_icmax_q6 MAX mfq_ic_q6 from=2e-08 to=4e-08
meas tran mf_ss_icmin_q6 MIN mfq_ic_q6 from=2e-08 to=4e-08
meas tran mf_su_sinkmin_tail MIN v(tail) from=0.0 to=2e-08
meas tran mf_ss_sinkmin_tail MIN v(tail) from=2e-08 to=4e-08
print mf_su_vcemax_q1
print mf_su_vcemin_q1
print mf_ss_vcemax_q1
print mf_ss_vcemin_q1
print mf_su_vbemax_q1
print mf_su_vbemin_q1
print mf_ss_vbemax_q1
print mf_ss_vbemin_q1
print mf_su_icmax_q1
print mf_su_icmin_q1
print mf_ss_icmax_q1
print mf_ss_icmin_q1
print mf_su_vcemax_q2
print mf_su_vcemin_q2
print mf_ss_vcemax_q2
print mf_ss_vcemin_q2
print mf_su_vbemax_q2
print mf_su_vbemin_q2
print mf_ss_vbemax_q2
print mf_ss_vbemin_q2
print mf_su_icmax_q2
print mf_su_icmin_q2
print mf_ss_icmax_q2
print mf_ss_icmin_q2
print mf_su_vcemax_q3
print mf_su_vcemin_q3
print mf_ss_vcemax_q3
print mf_ss_vcemin_q3
print mf_su_vbemax_q3
print mf_su_vbemin_q3
print mf_ss_vbemax_q3
print mf_ss_vbemin_q3
print mf_su_icmax_q3
print mf_su_icmin_q3
print mf_ss_icmax_q3
print mf_ss_icmin_q3
print mf_su_vcemax_q4
print mf_su_vcemin_q4
print mf_ss_vcemax_q4
print mf_ss_vcemin_q4
print mf_su_vbemax_q4
print mf_su_vbemin_q4
print mf_ss_vbemax_q4
print mf_ss_vbemin_q4
print mf_su_icmax_q4
print mf_su_icmin_q4
print mf_ss_icmax_q4
print mf_ss_icmin_q4
print mf_su_vcemax_q5
print mf_su_vcemin_q5
print mf_ss_vcemax_q5
print mf_ss_vcemin_q5
print mf_su_vbemax_q5
print mf_su_vbemin_q5
print mf_ss_vbemax_q5
print mf_ss_vbemin_q5
print mf_su_icmax_q5
print mf_su_icmin_q5
print mf_ss_icmax_q5
print mf_ss_icmin_q5
print mf_su_vcemax_q6
print mf_su_vcemin_q6
print mf_ss_vcemax_q6
print mf_ss_vcemin_q6
print mf_su_vbemax_q6
print mf_su_vbemin_q6
print mf_ss_vbemax_q6
print mf_ss_vbemin_q6
print mf_su_icmax_q6
print mf_su_icmin_q6
print mf_ss_icmax_q6
print mf_ss_icmin_q6
print mf_su_sinkmin_tail
print mf_ss_sinkmin_tail
linearize
let mf_l = length(time)
let mfw = (time ge 1.99995e-08) * (time lt 3.99995e-08)
let mf_n = mean(mfw) * mf_l
let mfs = mf_l / mf_n
let mf_prail = mean(v(vdd) * (0 - i(vdd)) * mfw) * mfs
let mfph = 2 * pi * 18450000000.0 * (time - 2e-08)
let mf_lodiff_re = 2 * mean((v(lo_p)-v(lo_n)) * mfw * cos(mfph)) * mfs
let mf_lodiff_im = 2 * mean((v(lo_p)-v(lo_n)) * mfw * sin(mfph)) * mfs
let mfph = 2 * pi * 1000000000.0 * (time - 2e-08)
let mf_if_re = 2 * mean((v(if_out)) * mfw * cos(mfph)) * mfs
let mf_if_im = 2 * mean((v(if_out)) * mfw * sin(mfph)) * mfs
let mfph = 2 * pi * 18450000000.0 * (time - 2e-08)
let mf_loif_re = 2 * mean((v(if_out)) * mfw * cos(mfph)) * mfs
let mf_loif_im = 2 * mean((v(if_out)) * mfw * sin(mfph)) * mfs
let mfph = 2 * pi * 18450000000.0 * (time - 2e-08)
let mf_lorf_re = 2 * mean((v(rf_port)) * mfw * cos(mfph)) * mfs
let mf_lorf_im = 2 * mean((v(rf_port)) * mfw * sin(mfph)) * mfs
let mfph = 2 * pi * 950000000.0 * (time - 2e-08)
let mf_flifa_re = 2 * mean((v(if_out)) * mfw * cos(mfph)) * mfs
let mf_flifa_im = 2 * mean((v(if_out)) * mfw * sin(mfph)) * mfs
let mfph = 2 * pi * 1050000000.0 * (time - 2e-08)
let mf_flifb_re = 2 * mean((v(if_out)) * mfw * cos(mfph)) * mfs
let mf_flifb_im = 2 * mean((v(if_out)) * mfw * sin(mfph)) * mfs
let mfph = 2 * pi * 18500000000.0 * (time - 2e-08)
let mf_fllorf_re = 2 * mean((v(rf_port)) * mfw * cos(mfph)) * mfs
let mf_fllorf_im = 2 * mean((v(rf_port)) * mfw * sin(mfph)) * mfs
let mfph = 2 * pi * 18500000000.0 * (time - 2e-08)
let mf_flloif_re = 2 * mean((v(if_out)) * mfw * cos(mfph)) * mfs
let mf_flloif_im = 2 * mean((v(if_out)) * mfw * sin(mfph)) * mfs
print mf_l
print mf_n
print mf_prail
print mf_lodiff_re
print mf_lodiff_im
print mf_if_re
print mf_if_im
print mf_loif_re
print mf_loif_im
print mf_lorf_re
print mf_lorf_im
print mf_flifa_re
print mf_flifa_im
print mf_flifb_re
print mf_flifb_im
print mf_fllorf_re
print mf_fllorf_im
print mf_flloif_re
print mf_flloif_im
destroy all
echo "MFEND ls_f19p45_p3_rf66"
echo "MFRUN ls_f19p45_p6_rf60"
alterparam f1 = 19450000000.0
alterparam f2 = 19450000000.0
alterparam flo = 18450000000.0
alterparam vrf1 = 0.0006324555320336759
alterparam vrf2 = 0.0
alterparam vlo = 1.7846168676856045
reset
op
let mf_dcirail = 0 - i(vdd)
let mf_dc_vce_q1 = v(c_q1)-v(e_q1)
let mf_dc_vbe_q1 = v(b_q1)-v(e_q1)
let mf_dc_ic_q1 = i(vic_q1)
let mf_dc_vce_q2 = v(c_q2)-v(e_q2)
let mf_dc_vbe_q2 = v(b_q2)-v(e_q2)
let mf_dc_ic_q2 = i(vic_q2)
let mf_dc_vce_q3 = v(c_q3)-v(x1)
let mf_dc_vbe_q3 = v(lo_p)-v(x1)
let mf_dc_ic_q3 = i(vic_q3)
let mf_dc_vce_q4 = v(c_q4)-v(x1)
let mf_dc_vbe_q4 = v(lo_n)-v(x1)
let mf_dc_ic_q4 = i(vic_q4)
let mf_dc_vce_q5 = v(c_q5)-v(x2)
let mf_dc_vbe_q5 = v(lo_p)-v(x2)
let mf_dc_ic_q5 = i(vic_q5)
let mf_dc_vce_q6 = v(c_q6)-v(x2)
let mf_dc_vbe_q6 = v(lo_n)-v(x2)
let mf_dc_ic_q6 = i(vic_q6)
let mf_dc_sink_tail = v(tail)
print mf_dcirail
print mf_dc_vce_q1
print mf_dc_vbe_q1
print mf_dc_ic_q1
print mf_dc_vce_q2
print mf_dc_vbe_q2
print mf_dc_ic_q2
print mf_dc_vce_q3
print mf_dc_vbe_q3
print mf_dc_ic_q3
print mf_dc_vce_q4
print mf_dc_vbe_q4
print mf_dc_ic_q4
print mf_dc_vce_q5
print mf_dc_vbe_q5
print mf_dc_ic_q5
print mf_dc_vce_q6
print mf_dc_vbe_q6
print mf_dc_ic_q6
print mf_dc_sink_tail
tran 1e-12 4e-08 0 1e-12
let mfq_vce_q1 = v(c_q1)-v(e_q1)
meas tran mf_su_vcemax_q1 MAX mfq_vce_q1 from=0.0 to=2e-08
meas tran mf_su_vcemin_q1 MIN mfq_vce_q1 from=0.0 to=2e-08
meas tran mf_ss_vcemax_q1 MAX mfq_vce_q1 from=2e-08 to=4e-08
meas tran mf_ss_vcemin_q1 MIN mfq_vce_q1 from=2e-08 to=4e-08
let mfq_vbe_q1 = v(b_q1)-v(e_q1)
meas tran mf_su_vbemax_q1 MAX mfq_vbe_q1 from=0.0 to=2e-08
meas tran mf_su_vbemin_q1 MIN mfq_vbe_q1 from=0.0 to=2e-08
meas tran mf_ss_vbemax_q1 MAX mfq_vbe_q1 from=2e-08 to=4e-08
meas tran mf_ss_vbemin_q1 MIN mfq_vbe_q1 from=2e-08 to=4e-08
let mfq_ic_q1 = i(vic_q1)
meas tran mf_su_icmax_q1 MAX mfq_ic_q1 from=0.0 to=2e-08
meas tran mf_su_icmin_q1 MIN mfq_ic_q1 from=0.0 to=2e-08
meas tran mf_ss_icmax_q1 MAX mfq_ic_q1 from=2e-08 to=4e-08
meas tran mf_ss_icmin_q1 MIN mfq_ic_q1 from=2e-08 to=4e-08
let mfq_vce_q2 = v(c_q2)-v(e_q2)
meas tran mf_su_vcemax_q2 MAX mfq_vce_q2 from=0.0 to=2e-08
meas tran mf_su_vcemin_q2 MIN mfq_vce_q2 from=0.0 to=2e-08
meas tran mf_ss_vcemax_q2 MAX mfq_vce_q2 from=2e-08 to=4e-08
meas tran mf_ss_vcemin_q2 MIN mfq_vce_q2 from=2e-08 to=4e-08
let mfq_vbe_q2 = v(b_q2)-v(e_q2)
meas tran mf_su_vbemax_q2 MAX mfq_vbe_q2 from=0.0 to=2e-08
meas tran mf_su_vbemin_q2 MIN mfq_vbe_q2 from=0.0 to=2e-08
meas tran mf_ss_vbemax_q2 MAX mfq_vbe_q2 from=2e-08 to=4e-08
meas tran mf_ss_vbemin_q2 MIN mfq_vbe_q2 from=2e-08 to=4e-08
let mfq_ic_q2 = i(vic_q2)
meas tran mf_su_icmax_q2 MAX mfq_ic_q2 from=0.0 to=2e-08
meas tran mf_su_icmin_q2 MIN mfq_ic_q2 from=0.0 to=2e-08
meas tran mf_ss_icmax_q2 MAX mfq_ic_q2 from=2e-08 to=4e-08
meas tran mf_ss_icmin_q2 MIN mfq_ic_q2 from=2e-08 to=4e-08
let mfq_vce_q3 = v(c_q3)-v(x1)
meas tran mf_su_vcemax_q3 MAX mfq_vce_q3 from=0.0 to=2e-08
meas tran mf_su_vcemin_q3 MIN mfq_vce_q3 from=0.0 to=2e-08
meas tran mf_ss_vcemax_q3 MAX mfq_vce_q3 from=2e-08 to=4e-08
meas tran mf_ss_vcemin_q3 MIN mfq_vce_q3 from=2e-08 to=4e-08
let mfq_vbe_q3 = v(lo_p)-v(x1)
meas tran mf_su_vbemax_q3 MAX mfq_vbe_q3 from=0.0 to=2e-08
meas tran mf_su_vbemin_q3 MIN mfq_vbe_q3 from=0.0 to=2e-08
meas tran mf_ss_vbemax_q3 MAX mfq_vbe_q3 from=2e-08 to=4e-08
meas tran mf_ss_vbemin_q3 MIN mfq_vbe_q3 from=2e-08 to=4e-08
let mfq_ic_q3 = i(vic_q3)
meas tran mf_su_icmax_q3 MAX mfq_ic_q3 from=0.0 to=2e-08
meas tran mf_su_icmin_q3 MIN mfq_ic_q3 from=0.0 to=2e-08
meas tran mf_ss_icmax_q3 MAX mfq_ic_q3 from=2e-08 to=4e-08
meas tran mf_ss_icmin_q3 MIN mfq_ic_q3 from=2e-08 to=4e-08
let mfq_vce_q4 = v(c_q4)-v(x1)
meas tran mf_su_vcemax_q4 MAX mfq_vce_q4 from=0.0 to=2e-08
meas tran mf_su_vcemin_q4 MIN mfq_vce_q4 from=0.0 to=2e-08
meas tran mf_ss_vcemax_q4 MAX mfq_vce_q4 from=2e-08 to=4e-08
meas tran mf_ss_vcemin_q4 MIN mfq_vce_q4 from=2e-08 to=4e-08
let mfq_vbe_q4 = v(lo_n)-v(x1)
meas tran mf_su_vbemax_q4 MAX mfq_vbe_q4 from=0.0 to=2e-08
meas tran mf_su_vbemin_q4 MIN mfq_vbe_q4 from=0.0 to=2e-08
meas tran mf_ss_vbemax_q4 MAX mfq_vbe_q4 from=2e-08 to=4e-08
meas tran mf_ss_vbemin_q4 MIN mfq_vbe_q4 from=2e-08 to=4e-08
let mfq_ic_q4 = i(vic_q4)
meas tran mf_su_icmax_q4 MAX mfq_ic_q4 from=0.0 to=2e-08
meas tran mf_su_icmin_q4 MIN mfq_ic_q4 from=0.0 to=2e-08
meas tran mf_ss_icmax_q4 MAX mfq_ic_q4 from=2e-08 to=4e-08
meas tran mf_ss_icmin_q4 MIN mfq_ic_q4 from=2e-08 to=4e-08
let mfq_vce_q5 = v(c_q5)-v(x2)
meas tran mf_su_vcemax_q5 MAX mfq_vce_q5 from=0.0 to=2e-08
meas tran mf_su_vcemin_q5 MIN mfq_vce_q5 from=0.0 to=2e-08
meas tran mf_ss_vcemax_q5 MAX mfq_vce_q5 from=2e-08 to=4e-08
meas tran mf_ss_vcemin_q5 MIN mfq_vce_q5 from=2e-08 to=4e-08
let mfq_vbe_q5 = v(lo_p)-v(x2)
meas tran mf_su_vbemax_q5 MAX mfq_vbe_q5 from=0.0 to=2e-08
meas tran mf_su_vbemin_q5 MIN mfq_vbe_q5 from=0.0 to=2e-08
meas tran mf_ss_vbemax_q5 MAX mfq_vbe_q5 from=2e-08 to=4e-08
meas tran mf_ss_vbemin_q5 MIN mfq_vbe_q5 from=2e-08 to=4e-08
let mfq_ic_q5 = i(vic_q5)
meas tran mf_su_icmax_q5 MAX mfq_ic_q5 from=0.0 to=2e-08
meas tran mf_su_icmin_q5 MIN mfq_ic_q5 from=0.0 to=2e-08
meas tran mf_ss_icmax_q5 MAX mfq_ic_q5 from=2e-08 to=4e-08
meas tran mf_ss_icmin_q5 MIN mfq_ic_q5 from=2e-08 to=4e-08
let mfq_vce_q6 = v(c_q6)-v(x2)
meas tran mf_su_vcemax_q6 MAX mfq_vce_q6 from=0.0 to=2e-08
meas tran mf_su_vcemin_q6 MIN mfq_vce_q6 from=0.0 to=2e-08
meas tran mf_ss_vcemax_q6 MAX mfq_vce_q6 from=2e-08 to=4e-08
meas tran mf_ss_vcemin_q6 MIN mfq_vce_q6 from=2e-08 to=4e-08
let mfq_vbe_q6 = v(lo_n)-v(x2)
meas tran mf_su_vbemax_q6 MAX mfq_vbe_q6 from=0.0 to=2e-08
meas tran mf_su_vbemin_q6 MIN mfq_vbe_q6 from=0.0 to=2e-08
meas tran mf_ss_vbemax_q6 MAX mfq_vbe_q6 from=2e-08 to=4e-08
meas tran mf_ss_vbemin_q6 MIN mfq_vbe_q6 from=2e-08 to=4e-08
let mfq_ic_q6 = i(vic_q6)
meas tran mf_su_icmax_q6 MAX mfq_ic_q6 from=0.0 to=2e-08
meas tran mf_su_icmin_q6 MIN mfq_ic_q6 from=0.0 to=2e-08
meas tran mf_ss_icmax_q6 MAX mfq_ic_q6 from=2e-08 to=4e-08
meas tran mf_ss_icmin_q6 MIN mfq_ic_q6 from=2e-08 to=4e-08
meas tran mf_su_sinkmin_tail MIN v(tail) from=0.0 to=2e-08
meas tran mf_ss_sinkmin_tail MIN v(tail) from=2e-08 to=4e-08
print mf_su_vcemax_q1
print mf_su_vcemin_q1
print mf_ss_vcemax_q1
print mf_ss_vcemin_q1
print mf_su_vbemax_q1
print mf_su_vbemin_q1
print mf_ss_vbemax_q1
print mf_ss_vbemin_q1
print mf_su_icmax_q1
print mf_su_icmin_q1
print mf_ss_icmax_q1
print mf_ss_icmin_q1
print mf_su_vcemax_q2
print mf_su_vcemin_q2
print mf_ss_vcemax_q2
print mf_ss_vcemin_q2
print mf_su_vbemax_q2
print mf_su_vbemin_q2
print mf_ss_vbemax_q2
print mf_ss_vbemin_q2
print mf_su_icmax_q2
print mf_su_icmin_q2
print mf_ss_icmax_q2
print mf_ss_icmin_q2
print mf_su_vcemax_q3
print mf_su_vcemin_q3
print mf_ss_vcemax_q3
print mf_ss_vcemin_q3
print mf_su_vbemax_q3
print mf_su_vbemin_q3
print mf_ss_vbemax_q3
print mf_ss_vbemin_q3
print mf_su_icmax_q3
print mf_su_icmin_q3
print mf_ss_icmax_q3
print mf_ss_icmin_q3
print mf_su_vcemax_q4
print mf_su_vcemin_q4
print mf_ss_vcemax_q4
print mf_ss_vcemin_q4
print mf_su_vbemax_q4
print mf_su_vbemin_q4
print mf_ss_vbemax_q4
print mf_ss_vbemin_q4
print mf_su_icmax_q4
print mf_su_icmin_q4
print mf_ss_icmax_q4
print mf_ss_icmin_q4
print mf_su_vcemax_q5
print mf_su_vcemin_q5
print mf_ss_vcemax_q5
print mf_ss_vcemin_q5
print mf_su_vbemax_q5
print mf_su_vbemin_q5
print mf_ss_vbemax_q5
print mf_ss_vbemin_q5
print mf_su_icmax_q5
print mf_su_icmin_q5
print mf_ss_icmax_q5
print mf_ss_icmin_q5
print mf_su_vcemax_q6
print mf_su_vcemin_q6
print mf_ss_vcemax_q6
print mf_ss_vcemin_q6
print mf_su_vbemax_q6
print mf_su_vbemin_q6
print mf_ss_vbemax_q6
print mf_ss_vbemin_q6
print mf_su_icmax_q6
print mf_su_icmin_q6
print mf_ss_icmax_q6
print mf_ss_icmin_q6
print mf_su_sinkmin_tail
print mf_ss_sinkmin_tail
linearize
let mf_l = length(time)
let mfw = (time ge 1.99995e-08) * (time lt 3.99995e-08)
let mf_n = mean(mfw) * mf_l
let mfs = mf_l / mf_n
let mf_prail = mean(v(vdd) * (0 - i(vdd)) * mfw) * mfs
let mfph = 2 * pi * 18450000000.0 * (time - 2e-08)
let mf_lodiff_re = 2 * mean((v(lo_p)-v(lo_n)) * mfw * cos(mfph)) * mfs
let mf_lodiff_im = 2 * mean((v(lo_p)-v(lo_n)) * mfw * sin(mfph)) * mfs
let mfph = 2 * pi * 1000000000.0 * (time - 2e-08)
let mf_if_re = 2 * mean((v(if_out)) * mfw * cos(mfph)) * mfs
let mf_if_im = 2 * mean((v(if_out)) * mfw * sin(mfph)) * mfs
let mfph = 2 * pi * 18450000000.0 * (time - 2e-08)
let mf_loif_re = 2 * mean((v(if_out)) * mfw * cos(mfph)) * mfs
let mf_loif_im = 2 * mean((v(if_out)) * mfw * sin(mfph)) * mfs
let mfph = 2 * pi * 18450000000.0 * (time - 2e-08)
let mf_lorf_re = 2 * mean((v(rf_port)) * mfw * cos(mfph)) * mfs
let mf_lorf_im = 2 * mean((v(rf_port)) * mfw * sin(mfph)) * mfs
let mfph = 2 * pi * 950000000.0 * (time - 2e-08)
let mf_flifa_re = 2 * mean((v(if_out)) * mfw * cos(mfph)) * mfs
let mf_flifa_im = 2 * mean((v(if_out)) * mfw * sin(mfph)) * mfs
let mfph = 2 * pi * 1050000000.0 * (time - 2e-08)
let mf_flifb_re = 2 * mean((v(if_out)) * mfw * cos(mfph)) * mfs
let mf_flifb_im = 2 * mean((v(if_out)) * mfw * sin(mfph)) * mfs
let mfph = 2 * pi * 18500000000.0 * (time - 2e-08)
let mf_fllorf_re = 2 * mean((v(rf_port)) * mfw * cos(mfph)) * mfs
let mf_fllorf_im = 2 * mean((v(rf_port)) * mfw * sin(mfph)) * mfs
let mfph = 2 * pi * 18500000000.0 * (time - 2e-08)
let mf_flloif_re = 2 * mean((v(if_out)) * mfw * cos(mfph)) * mfs
let mf_flloif_im = 2 * mean((v(if_out)) * mfw * sin(mfph)) * mfs
print mf_l
print mf_n
print mf_prail
print mf_lodiff_re
print mf_lodiff_im
print mf_if_re
print mf_if_im
print mf_loif_re
print mf_loif_im
print mf_lorf_re
print mf_lorf_im
print mf_flifa_re
print mf_flifa_im
print mf_flifb_re
print mf_flifb_im
print mf_fllorf_re
print mf_fllorf_im
print mf_flloif_re
print mf_flloif_im
destroy all
echo "MFEND ls_f19p45_p6_rf60"
echo "MFRUN ls_f19p45_p6_rf66"
alterparam f1 = 19450000000.0
alterparam f2 = 19450000000.0
alterparam flo = 18450000000.0
alterparam vrf1 = 0.00031697863849222284
alterparam vrf2 = 0.0
alterparam vlo = 1.7846168676856045
reset
op
let mf_dcirail = 0 - i(vdd)
let mf_dc_vce_q1 = v(c_q1)-v(e_q1)
let mf_dc_vbe_q1 = v(b_q1)-v(e_q1)
let mf_dc_ic_q1 = i(vic_q1)
let mf_dc_vce_q2 = v(c_q2)-v(e_q2)
let mf_dc_vbe_q2 = v(b_q2)-v(e_q2)
let mf_dc_ic_q2 = i(vic_q2)
let mf_dc_vce_q3 = v(c_q3)-v(x1)
let mf_dc_vbe_q3 = v(lo_p)-v(x1)
let mf_dc_ic_q3 = i(vic_q3)
let mf_dc_vce_q4 = v(c_q4)-v(x1)
let mf_dc_vbe_q4 = v(lo_n)-v(x1)
let mf_dc_ic_q4 = i(vic_q4)
let mf_dc_vce_q5 = v(c_q5)-v(x2)
let mf_dc_vbe_q5 = v(lo_p)-v(x2)
let mf_dc_ic_q5 = i(vic_q5)
let mf_dc_vce_q6 = v(c_q6)-v(x2)
let mf_dc_vbe_q6 = v(lo_n)-v(x2)
let mf_dc_ic_q6 = i(vic_q6)
let mf_dc_sink_tail = v(tail)
print mf_dcirail
print mf_dc_vce_q1
print mf_dc_vbe_q1
print mf_dc_ic_q1
print mf_dc_vce_q2
print mf_dc_vbe_q2
print mf_dc_ic_q2
print mf_dc_vce_q3
print mf_dc_vbe_q3
print mf_dc_ic_q3
print mf_dc_vce_q4
print mf_dc_vbe_q4
print mf_dc_ic_q4
print mf_dc_vce_q5
print mf_dc_vbe_q5
print mf_dc_ic_q5
print mf_dc_vce_q6
print mf_dc_vbe_q6
print mf_dc_ic_q6
print mf_dc_sink_tail
tran 1e-12 4e-08 0 1e-12
let mfq_vce_q1 = v(c_q1)-v(e_q1)
meas tran mf_su_vcemax_q1 MAX mfq_vce_q1 from=0.0 to=2e-08
meas tran mf_su_vcemin_q1 MIN mfq_vce_q1 from=0.0 to=2e-08
meas tran mf_ss_vcemax_q1 MAX mfq_vce_q1 from=2e-08 to=4e-08
meas tran mf_ss_vcemin_q1 MIN mfq_vce_q1 from=2e-08 to=4e-08
let mfq_vbe_q1 = v(b_q1)-v(e_q1)
meas tran mf_su_vbemax_q1 MAX mfq_vbe_q1 from=0.0 to=2e-08
meas tran mf_su_vbemin_q1 MIN mfq_vbe_q1 from=0.0 to=2e-08
meas tran mf_ss_vbemax_q1 MAX mfq_vbe_q1 from=2e-08 to=4e-08
meas tran mf_ss_vbemin_q1 MIN mfq_vbe_q1 from=2e-08 to=4e-08
let mfq_ic_q1 = i(vic_q1)
meas tran mf_su_icmax_q1 MAX mfq_ic_q1 from=0.0 to=2e-08
meas tran mf_su_icmin_q1 MIN mfq_ic_q1 from=0.0 to=2e-08
meas tran mf_ss_icmax_q1 MAX mfq_ic_q1 from=2e-08 to=4e-08
meas tran mf_ss_icmin_q1 MIN mfq_ic_q1 from=2e-08 to=4e-08
let mfq_vce_q2 = v(c_q2)-v(e_q2)
meas tran mf_su_vcemax_q2 MAX mfq_vce_q2 from=0.0 to=2e-08
meas tran mf_su_vcemin_q2 MIN mfq_vce_q2 from=0.0 to=2e-08
meas tran mf_ss_vcemax_q2 MAX mfq_vce_q2 from=2e-08 to=4e-08
meas tran mf_ss_vcemin_q2 MIN mfq_vce_q2 from=2e-08 to=4e-08
let mfq_vbe_q2 = v(b_q2)-v(e_q2)
meas tran mf_su_vbemax_q2 MAX mfq_vbe_q2 from=0.0 to=2e-08
meas tran mf_su_vbemin_q2 MIN mfq_vbe_q2 from=0.0 to=2e-08
meas tran mf_ss_vbemax_q2 MAX mfq_vbe_q2 from=2e-08 to=4e-08
meas tran mf_ss_vbemin_q2 MIN mfq_vbe_q2 from=2e-08 to=4e-08
let mfq_ic_q2 = i(vic_q2)
meas tran mf_su_icmax_q2 MAX mfq_ic_q2 from=0.0 to=2e-08
meas tran mf_su_icmin_q2 MIN mfq_ic_q2 from=0.0 to=2e-08
meas tran mf_ss_icmax_q2 MAX mfq_ic_q2 from=2e-08 to=4e-08
meas tran mf_ss_icmin_q2 MIN mfq_ic_q2 from=2e-08 to=4e-08
let mfq_vce_q3 = v(c_q3)-v(x1)
meas tran mf_su_vcemax_q3 MAX mfq_vce_q3 from=0.0 to=2e-08
meas tran mf_su_vcemin_q3 MIN mfq_vce_q3 from=0.0 to=2e-08
meas tran mf_ss_vcemax_q3 MAX mfq_vce_q3 from=2e-08 to=4e-08
meas tran mf_ss_vcemin_q3 MIN mfq_vce_q3 from=2e-08 to=4e-08
let mfq_vbe_q3 = v(lo_p)-v(x1)
meas tran mf_su_vbemax_q3 MAX mfq_vbe_q3 from=0.0 to=2e-08
meas tran mf_su_vbemin_q3 MIN mfq_vbe_q3 from=0.0 to=2e-08
meas tran mf_ss_vbemax_q3 MAX mfq_vbe_q3 from=2e-08 to=4e-08
meas tran mf_ss_vbemin_q3 MIN mfq_vbe_q3 from=2e-08 to=4e-08
let mfq_ic_q3 = i(vic_q3)
meas tran mf_su_icmax_q3 MAX mfq_ic_q3 from=0.0 to=2e-08
meas tran mf_su_icmin_q3 MIN mfq_ic_q3 from=0.0 to=2e-08
meas tran mf_ss_icmax_q3 MAX mfq_ic_q3 from=2e-08 to=4e-08
meas tran mf_ss_icmin_q3 MIN mfq_ic_q3 from=2e-08 to=4e-08
let mfq_vce_q4 = v(c_q4)-v(x1)
meas tran mf_su_vcemax_q4 MAX mfq_vce_q4 from=0.0 to=2e-08
meas tran mf_su_vcemin_q4 MIN mfq_vce_q4 from=0.0 to=2e-08
meas tran mf_ss_vcemax_q4 MAX mfq_vce_q4 from=2e-08 to=4e-08
meas tran mf_ss_vcemin_q4 MIN mfq_vce_q4 from=2e-08 to=4e-08
let mfq_vbe_q4 = v(lo_n)-v(x1)
meas tran mf_su_vbemax_q4 MAX mfq_vbe_q4 from=0.0 to=2e-08
meas tran mf_su_vbemin_q4 MIN mfq_vbe_q4 from=0.0 to=2e-08
meas tran mf_ss_vbemax_q4 MAX mfq_vbe_q4 from=2e-08 to=4e-08
meas tran mf_ss_vbemin_q4 MIN mfq_vbe_q4 from=2e-08 to=4e-08
let mfq_ic_q4 = i(vic_q4)
meas tran mf_su_icmax_q4 MAX mfq_ic_q4 from=0.0 to=2e-08
meas tran mf_su_icmin_q4 MIN mfq_ic_q4 from=0.0 to=2e-08
meas tran mf_ss_icmax_q4 MAX mfq_ic_q4 from=2e-08 to=4e-08
meas tran mf_ss_icmin_q4 MIN mfq_ic_q4 from=2e-08 to=4e-08
let mfq_vce_q5 = v(c_q5)-v(x2)
meas tran mf_su_vcemax_q5 MAX mfq_vce_q5 from=0.0 to=2e-08
meas tran mf_su_vcemin_q5 MIN mfq_vce_q5 from=0.0 to=2e-08
meas tran mf_ss_vcemax_q5 MAX mfq_vce_q5 from=2e-08 to=4e-08
meas tran mf_ss_vcemin_q5 MIN mfq_vce_q5 from=2e-08 to=4e-08
let mfq_vbe_q5 = v(lo_p)-v(x2)
meas tran mf_su_vbemax_q5 MAX mfq_vbe_q5 from=0.0 to=2e-08
meas tran mf_su_vbemin_q5 MIN mfq_vbe_q5 from=0.0 to=2e-08
meas tran mf_ss_vbemax_q5 MAX mfq_vbe_q5 from=2e-08 to=4e-08
meas tran mf_ss_vbemin_q5 MIN mfq_vbe_q5 from=2e-08 to=4e-08
let mfq_ic_q5 = i(vic_q5)
meas tran mf_su_icmax_q5 MAX mfq_ic_q5 from=0.0 to=2e-08
meas tran mf_su_icmin_q5 MIN mfq_ic_q5 from=0.0 to=2e-08
meas tran mf_ss_icmax_q5 MAX mfq_ic_q5 from=2e-08 to=4e-08
meas tran mf_ss_icmin_q5 MIN mfq_ic_q5 from=2e-08 to=4e-08
let mfq_vce_q6 = v(c_q6)-v(x2)
meas tran mf_su_vcemax_q6 MAX mfq_vce_q6 from=0.0 to=2e-08
meas tran mf_su_vcemin_q6 MIN mfq_vce_q6 from=0.0 to=2e-08
meas tran mf_ss_vcemax_q6 MAX mfq_vce_q6 from=2e-08 to=4e-08
meas tran mf_ss_vcemin_q6 MIN mfq_vce_q6 from=2e-08 to=4e-08
let mfq_vbe_q6 = v(lo_n)-v(x2)
meas tran mf_su_vbemax_q6 MAX mfq_vbe_q6 from=0.0 to=2e-08
meas tran mf_su_vbemin_q6 MIN mfq_vbe_q6 from=0.0 to=2e-08
meas tran mf_ss_vbemax_q6 MAX mfq_vbe_q6 from=2e-08 to=4e-08
meas tran mf_ss_vbemin_q6 MIN mfq_vbe_q6 from=2e-08 to=4e-08
let mfq_ic_q6 = i(vic_q6)
meas tran mf_su_icmax_q6 MAX mfq_ic_q6 from=0.0 to=2e-08
meas tran mf_su_icmin_q6 MIN mfq_ic_q6 from=0.0 to=2e-08
meas tran mf_ss_icmax_q6 MAX mfq_ic_q6 from=2e-08 to=4e-08
meas tran mf_ss_icmin_q6 MIN mfq_ic_q6 from=2e-08 to=4e-08
meas tran mf_su_sinkmin_tail MIN v(tail) from=0.0 to=2e-08
meas tran mf_ss_sinkmin_tail MIN v(tail) from=2e-08 to=4e-08
print mf_su_vcemax_q1
print mf_su_vcemin_q1
print mf_ss_vcemax_q1
print mf_ss_vcemin_q1
print mf_su_vbemax_q1
print mf_su_vbemin_q1
print mf_ss_vbemax_q1
print mf_ss_vbemin_q1
print mf_su_icmax_q1
print mf_su_icmin_q1
print mf_ss_icmax_q1
print mf_ss_icmin_q1
print mf_su_vcemax_q2
print mf_su_vcemin_q2
print mf_ss_vcemax_q2
print mf_ss_vcemin_q2
print mf_su_vbemax_q2
print mf_su_vbemin_q2
print mf_ss_vbemax_q2
print mf_ss_vbemin_q2
print mf_su_icmax_q2
print mf_su_icmin_q2
print mf_ss_icmax_q2
print mf_ss_icmin_q2
print mf_su_vcemax_q3
print mf_su_vcemin_q3
print mf_ss_vcemax_q3
print mf_ss_vcemin_q3
print mf_su_vbemax_q3
print mf_su_vbemin_q3
print mf_ss_vbemax_q3
print mf_ss_vbemin_q3
print mf_su_icmax_q3
print mf_su_icmin_q3
print mf_ss_icmax_q3
print mf_ss_icmin_q3
print mf_su_vcemax_q4
print mf_su_vcemin_q4
print mf_ss_vcemax_q4
print mf_ss_vcemin_q4
print mf_su_vbemax_q4
print mf_su_vbemin_q4
print mf_ss_vbemax_q4
print mf_ss_vbemin_q4
print mf_su_icmax_q4
print mf_su_icmin_q4
print mf_ss_icmax_q4
print mf_ss_icmin_q4
print mf_su_vcemax_q5
print mf_su_vcemin_q5
print mf_ss_vcemax_q5
print mf_ss_vcemin_q5
print mf_su_vbemax_q5
print mf_su_vbemin_q5
print mf_ss_vbemax_q5
print mf_ss_vbemin_q5
print mf_su_icmax_q5
print mf_su_icmin_q5
print mf_ss_icmax_q5
print mf_ss_icmin_q5
print mf_su_vcemax_q6
print mf_su_vcemin_q6
print mf_ss_vcemax_q6
print mf_ss_vcemin_q6
print mf_su_vbemax_q6
print mf_su_vbemin_q6
print mf_ss_vbemax_q6
print mf_ss_vbemin_q6
print mf_su_icmax_q6
print mf_su_icmin_q6
print mf_ss_icmax_q6
print mf_ss_icmin_q6
print mf_su_sinkmin_tail
print mf_ss_sinkmin_tail
linearize
let mf_l = length(time)
let mfw = (time ge 1.99995e-08) * (time lt 3.99995e-08)
let mf_n = mean(mfw) * mf_l
let mfs = mf_l / mf_n
let mf_prail = mean(v(vdd) * (0 - i(vdd)) * mfw) * mfs
let mfph = 2 * pi * 18450000000.0 * (time - 2e-08)
let mf_lodiff_re = 2 * mean((v(lo_p)-v(lo_n)) * mfw * cos(mfph)) * mfs
let mf_lodiff_im = 2 * mean((v(lo_p)-v(lo_n)) * mfw * sin(mfph)) * mfs
let mfph = 2 * pi * 1000000000.0 * (time - 2e-08)
let mf_if_re = 2 * mean((v(if_out)) * mfw * cos(mfph)) * mfs
let mf_if_im = 2 * mean((v(if_out)) * mfw * sin(mfph)) * mfs
let mfph = 2 * pi * 18450000000.0 * (time - 2e-08)
let mf_loif_re = 2 * mean((v(if_out)) * mfw * cos(mfph)) * mfs
let mf_loif_im = 2 * mean((v(if_out)) * mfw * sin(mfph)) * mfs
let mfph = 2 * pi * 18450000000.0 * (time - 2e-08)
let mf_lorf_re = 2 * mean((v(rf_port)) * mfw * cos(mfph)) * mfs
let mf_lorf_im = 2 * mean((v(rf_port)) * mfw * sin(mfph)) * mfs
let mfph = 2 * pi * 950000000.0 * (time - 2e-08)
let mf_flifa_re = 2 * mean((v(if_out)) * mfw * cos(mfph)) * mfs
let mf_flifa_im = 2 * mean((v(if_out)) * mfw * sin(mfph)) * mfs
let mfph = 2 * pi * 1050000000.0 * (time - 2e-08)
let mf_flifb_re = 2 * mean((v(if_out)) * mfw * cos(mfph)) * mfs
let mf_flifb_im = 2 * mean((v(if_out)) * mfw * sin(mfph)) * mfs
let mfph = 2 * pi * 18500000000.0 * (time - 2e-08)
let mf_fllorf_re = 2 * mean((v(rf_port)) * mfw * cos(mfph)) * mfs
let mf_fllorf_im = 2 * mean((v(rf_port)) * mfw * sin(mfph)) * mfs
let mfph = 2 * pi * 18500000000.0 * (time - 2e-08)
let mf_flloif_re = 2 * mean((v(if_out)) * mfw * cos(mfph)) * mfs
let mf_flloif_im = 2 * mean((v(if_out)) * mfw * sin(mfph)) * mfs
print mf_l
print mf_n
print mf_prail
print mf_lodiff_re
print mf_lodiff_im
print mf_if_re
print mf_if_im
print mf_loif_re
print mf_loif_im
print mf_lorf_re
print mf_lorf_im
print mf_flifa_re
print mf_flifa_im
print mf_flifb_re
print mf_flifb_im
print mf_fllorf_re
print mf_fllorf_im
print mf_flloif_re
print mf_flloif_im
destroy all
echo "MFEND ls_f19p45_p6_rf66"
echo "MFRUN ls_f21p20_m30_rf60"
alterparam f1 = 21200000000.0
alterparam f2 = 21200000000.0
alterparam flo = 20200000000.0
alterparam vrf1 = 0.0006324555320336759
alterparam vrf2 = 0.0
alterparam vlo = 0.0282842712474619
reset
op
let mf_dcirail = 0 - i(vdd)
let mf_dc_vce_q1 = v(c_q1)-v(e_q1)
let mf_dc_vbe_q1 = v(b_q1)-v(e_q1)
let mf_dc_ic_q1 = i(vic_q1)
let mf_dc_vce_q2 = v(c_q2)-v(e_q2)
let mf_dc_vbe_q2 = v(b_q2)-v(e_q2)
let mf_dc_ic_q2 = i(vic_q2)
let mf_dc_vce_q3 = v(c_q3)-v(x1)
let mf_dc_vbe_q3 = v(lo_p)-v(x1)
let mf_dc_ic_q3 = i(vic_q3)
let mf_dc_vce_q4 = v(c_q4)-v(x1)
let mf_dc_vbe_q4 = v(lo_n)-v(x1)
let mf_dc_ic_q4 = i(vic_q4)
let mf_dc_vce_q5 = v(c_q5)-v(x2)
let mf_dc_vbe_q5 = v(lo_p)-v(x2)
let mf_dc_ic_q5 = i(vic_q5)
let mf_dc_vce_q6 = v(c_q6)-v(x2)
let mf_dc_vbe_q6 = v(lo_n)-v(x2)
let mf_dc_ic_q6 = i(vic_q6)
let mf_dc_sink_tail = v(tail)
print mf_dcirail
print mf_dc_vce_q1
print mf_dc_vbe_q1
print mf_dc_ic_q1
print mf_dc_vce_q2
print mf_dc_vbe_q2
print mf_dc_ic_q2
print mf_dc_vce_q3
print mf_dc_vbe_q3
print mf_dc_ic_q3
print mf_dc_vce_q4
print mf_dc_vbe_q4
print mf_dc_ic_q4
print mf_dc_vce_q5
print mf_dc_vbe_q5
print mf_dc_ic_q5
print mf_dc_vce_q6
print mf_dc_vbe_q6
print mf_dc_ic_q6
print mf_dc_sink_tail
tran 1e-12 4e-08 0 1e-12
let mfq_vce_q1 = v(c_q1)-v(e_q1)
meas tran mf_su_vcemax_q1 MAX mfq_vce_q1 from=0.0 to=2e-08
meas tran mf_su_vcemin_q1 MIN mfq_vce_q1 from=0.0 to=2e-08
meas tran mf_ss_vcemax_q1 MAX mfq_vce_q1 from=2e-08 to=4e-08
meas tran mf_ss_vcemin_q1 MIN mfq_vce_q1 from=2e-08 to=4e-08
let mfq_vbe_q1 = v(b_q1)-v(e_q1)
meas tran mf_su_vbemax_q1 MAX mfq_vbe_q1 from=0.0 to=2e-08
meas tran mf_su_vbemin_q1 MIN mfq_vbe_q1 from=0.0 to=2e-08
meas tran mf_ss_vbemax_q1 MAX mfq_vbe_q1 from=2e-08 to=4e-08
meas tran mf_ss_vbemin_q1 MIN mfq_vbe_q1 from=2e-08 to=4e-08
let mfq_ic_q1 = i(vic_q1)
meas tran mf_su_icmax_q1 MAX mfq_ic_q1 from=0.0 to=2e-08
meas tran mf_su_icmin_q1 MIN mfq_ic_q1 from=0.0 to=2e-08
meas tran mf_ss_icmax_q1 MAX mfq_ic_q1 from=2e-08 to=4e-08
meas tran mf_ss_icmin_q1 MIN mfq_ic_q1 from=2e-08 to=4e-08
let mfq_vce_q2 = v(c_q2)-v(e_q2)
meas tran mf_su_vcemax_q2 MAX mfq_vce_q2 from=0.0 to=2e-08
meas tran mf_su_vcemin_q2 MIN mfq_vce_q2 from=0.0 to=2e-08
meas tran mf_ss_vcemax_q2 MAX mfq_vce_q2 from=2e-08 to=4e-08
meas tran mf_ss_vcemin_q2 MIN mfq_vce_q2 from=2e-08 to=4e-08
let mfq_vbe_q2 = v(b_q2)-v(e_q2)
meas tran mf_su_vbemax_q2 MAX mfq_vbe_q2 from=0.0 to=2e-08
meas tran mf_su_vbemin_q2 MIN mfq_vbe_q2 from=0.0 to=2e-08
meas tran mf_ss_vbemax_q2 MAX mfq_vbe_q2 from=2e-08 to=4e-08
meas tran mf_ss_vbemin_q2 MIN mfq_vbe_q2 from=2e-08 to=4e-08
let mfq_ic_q2 = i(vic_q2)
meas tran mf_su_icmax_q2 MAX mfq_ic_q2 from=0.0 to=2e-08
meas tran mf_su_icmin_q2 MIN mfq_ic_q2 from=0.0 to=2e-08
meas tran mf_ss_icmax_q2 MAX mfq_ic_q2 from=2e-08 to=4e-08
meas tran mf_ss_icmin_q2 MIN mfq_ic_q2 from=2e-08 to=4e-08
let mfq_vce_q3 = v(c_q3)-v(x1)
meas tran mf_su_vcemax_q3 MAX mfq_vce_q3 from=0.0 to=2e-08
meas tran mf_su_vcemin_q3 MIN mfq_vce_q3 from=0.0 to=2e-08
meas tran mf_ss_vcemax_q3 MAX mfq_vce_q3 from=2e-08 to=4e-08
meas tran mf_ss_vcemin_q3 MIN mfq_vce_q3 from=2e-08 to=4e-08
let mfq_vbe_q3 = v(lo_p)-v(x1)
meas tran mf_su_vbemax_q3 MAX mfq_vbe_q3 from=0.0 to=2e-08
meas tran mf_su_vbemin_q3 MIN mfq_vbe_q3 from=0.0 to=2e-08
meas tran mf_ss_vbemax_q3 MAX mfq_vbe_q3 from=2e-08 to=4e-08
meas tran mf_ss_vbemin_q3 MIN mfq_vbe_q3 from=2e-08 to=4e-08
let mfq_ic_q3 = i(vic_q3)
meas tran mf_su_icmax_q3 MAX mfq_ic_q3 from=0.0 to=2e-08
meas tran mf_su_icmin_q3 MIN mfq_ic_q3 from=0.0 to=2e-08
meas tran mf_ss_icmax_q3 MAX mfq_ic_q3 from=2e-08 to=4e-08
meas tran mf_ss_icmin_q3 MIN mfq_ic_q3 from=2e-08 to=4e-08
let mfq_vce_q4 = v(c_q4)-v(x1)
meas tran mf_su_vcemax_q4 MAX mfq_vce_q4 from=0.0 to=2e-08
meas tran mf_su_vcemin_q4 MIN mfq_vce_q4 from=0.0 to=2e-08
meas tran mf_ss_vcemax_q4 MAX mfq_vce_q4 from=2e-08 to=4e-08
meas tran mf_ss_vcemin_q4 MIN mfq_vce_q4 from=2e-08 to=4e-08
let mfq_vbe_q4 = v(lo_n)-v(x1)
meas tran mf_su_vbemax_q4 MAX mfq_vbe_q4 from=0.0 to=2e-08
meas tran mf_su_vbemin_q4 MIN mfq_vbe_q4 from=0.0 to=2e-08
meas tran mf_ss_vbemax_q4 MAX mfq_vbe_q4 from=2e-08 to=4e-08
meas tran mf_ss_vbemin_q4 MIN mfq_vbe_q4 from=2e-08 to=4e-08
let mfq_ic_q4 = i(vic_q4)
meas tran mf_su_icmax_q4 MAX mfq_ic_q4 from=0.0 to=2e-08
meas tran mf_su_icmin_q4 MIN mfq_ic_q4 from=0.0 to=2e-08
meas tran mf_ss_icmax_q4 MAX mfq_ic_q4 from=2e-08 to=4e-08
meas tran mf_ss_icmin_q4 MIN mfq_ic_q4 from=2e-08 to=4e-08
let mfq_vce_q5 = v(c_q5)-v(x2)
meas tran mf_su_vcemax_q5 MAX mfq_vce_q5 from=0.0 to=2e-08
meas tran mf_su_vcemin_q5 MIN mfq_vce_q5 from=0.0 to=2e-08
meas tran mf_ss_vcemax_q5 MAX mfq_vce_q5 from=2e-08 to=4e-08
meas tran mf_ss_vcemin_q5 MIN mfq_vce_q5 from=2e-08 to=4e-08
let mfq_vbe_q5 = v(lo_p)-v(x2)
meas tran mf_su_vbemax_q5 MAX mfq_vbe_q5 from=0.0 to=2e-08
meas tran mf_su_vbemin_q5 MIN mfq_vbe_q5 from=0.0 to=2e-08
meas tran mf_ss_vbemax_q5 MAX mfq_vbe_q5 from=2e-08 to=4e-08
meas tran mf_ss_vbemin_q5 MIN mfq_vbe_q5 from=2e-08 to=4e-08
let mfq_ic_q5 = i(vic_q5)
meas tran mf_su_icmax_q5 MAX mfq_ic_q5 from=0.0 to=2e-08
meas tran mf_su_icmin_q5 MIN mfq_ic_q5 from=0.0 to=2e-08
meas tran mf_ss_icmax_q5 MAX mfq_ic_q5 from=2e-08 to=4e-08
meas tran mf_ss_icmin_q5 MIN mfq_ic_q5 from=2e-08 to=4e-08
let mfq_vce_q6 = v(c_q6)-v(x2)
meas tran mf_su_vcemax_q6 MAX mfq_vce_q6 from=0.0 to=2e-08
meas tran mf_su_vcemin_q6 MIN mfq_vce_q6 from=0.0 to=2e-08
meas tran mf_ss_vcemax_q6 MAX mfq_vce_q6 from=2e-08 to=4e-08
meas tran mf_ss_vcemin_q6 MIN mfq_vce_q6 from=2e-08 to=4e-08
let mfq_vbe_q6 = v(lo_n)-v(x2)
meas tran mf_su_vbemax_q6 MAX mfq_vbe_q6 from=0.0 to=2e-08
meas tran mf_su_vbemin_q6 MIN mfq_vbe_q6 from=0.0 to=2e-08
meas tran mf_ss_vbemax_q6 MAX mfq_vbe_q6 from=2e-08 to=4e-08
meas tran mf_ss_vbemin_q6 MIN mfq_vbe_q6 from=2e-08 to=4e-08
let mfq_ic_q6 = i(vic_q6)
meas tran mf_su_icmax_q6 MAX mfq_ic_q6 from=0.0 to=2e-08
meas tran mf_su_icmin_q6 MIN mfq_ic_q6 from=0.0 to=2e-08
meas tran mf_ss_icmax_q6 MAX mfq_ic_q6 from=2e-08 to=4e-08
meas tran mf_ss_icmin_q6 MIN mfq_ic_q6 from=2e-08 to=4e-08
meas tran mf_su_sinkmin_tail MIN v(tail) from=0.0 to=2e-08
meas tran mf_ss_sinkmin_tail MIN v(tail) from=2e-08 to=4e-08
print mf_su_vcemax_q1
print mf_su_vcemin_q1
print mf_ss_vcemax_q1
print mf_ss_vcemin_q1
print mf_su_vbemax_q1
print mf_su_vbemin_q1
print mf_ss_vbemax_q1
print mf_ss_vbemin_q1
print mf_su_icmax_q1
print mf_su_icmin_q1
print mf_ss_icmax_q1
print mf_ss_icmin_q1
print mf_su_vcemax_q2
print mf_su_vcemin_q2
print mf_ss_vcemax_q2
print mf_ss_vcemin_q2
print mf_su_vbemax_q2
print mf_su_vbemin_q2
print mf_ss_vbemax_q2
print mf_ss_vbemin_q2
print mf_su_icmax_q2
print mf_su_icmin_q2
print mf_ss_icmax_q2
print mf_ss_icmin_q2
print mf_su_vcemax_q3
print mf_su_vcemin_q3
print mf_ss_vcemax_q3
print mf_ss_vcemin_q3
print mf_su_vbemax_q3
print mf_su_vbemin_q3
print mf_ss_vbemax_q3
print mf_ss_vbemin_q3
print mf_su_icmax_q3
print mf_su_icmin_q3
print mf_ss_icmax_q3
print mf_ss_icmin_q3
print mf_su_vcemax_q4
print mf_su_vcemin_q4
print mf_ss_vcemax_q4
print mf_ss_vcemin_q4
print mf_su_vbemax_q4
print mf_su_vbemin_q4
print mf_ss_vbemax_q4
print mf_ss_vbemin_q4
print mf_su_icmax_q4
print mf_su_icmin_q4
print mf_ss_icmax_q4
print mf_ss_icmin_q4
print mf_su_vcemax_q5
print mf_su_vcemin_q5
print mf_ss_vcemax_q5
print mf_ss_vcemin_q5
print mf_su_vbemax_q5
print mf_su_vbemin_q5
print mf_ss_vbemax_q5
print mf_ss_vbemin_q5
print mf_su_icmax_q5
print mf_su_icmin_q5
print mf_ss_icmax_q5
print mf_ss_icmin_q5
print mf_su_vcemax_q6
print mf_su_vcemin_q6
print mf_ss_vcemax_q6
print mf_ss_vcemin_q6
print mf_su_vbemax_q6
print mf_su_vbemin_q6
print mf_ss_vbemax_q6
print mf_ss_vbemin_q6
print mf_su_icmax_q6
print mf_su_icmin_q6
print mf_ss_icmax_q6
print mf_ss_icmin_q6
print mf_su_sinkmin_tail
print mf_ss_sinkmin_tail
linearize
let mf_l = length(time)
let mfw = (time ge 1.99995e-08) * (time lt 3.99995e-08)
let mf_n = mean(mfw) * mf_l
let mfs = mf_l / mf_n
let mf_prail = mean(v(vdd) * (0 - i(vdd)) * mfw) * mfs
let mfph = 2 * pi * 20200000000.0 * (time - 2e-08)
let mf_lodiff_re = 2 * mean((v(lo_p)-v(lo_n)) * mfw * cos(mfph)) * mfs
let mf_lodiff_im = 2 * mean((v(lo_p)-v(lo_n)) * mfw * sin(mfph)) * mfs
let mfph = 2 * pi * 1000000000.0 * (time - 2e-08)
let mf_if_re = 2 * mean((v(if_out)) * mfw * cos(mfph)) * mfs
let mf_if_im = 2 * mean((v(if_out)) * mfw * sin(mfph)) * mfs
let mfph = 2 * pi * 20200000000.0 * (time - 2e-08)
let mf_loif_re = 2 * mean((v(if_out)) * mfw * cos(mfph)) * mfs
let mf_loif_im = 2 * mean((v(if_out)) * mfw * sin(mfph)) * mfs
let mfph = 2 * pi * 20200000000.0 * (time - 2e-08)
let mf_lorf_re = 2 * mean((v(rf_port)) * mfw * cos(mfph)) * mfs
let mf_lorf_im = 2 * mean((v(rf_port)) * mfw * sin(mfph)) * mfs
let mfph = 2 * pi * 950000000.0 * (time - 2e-08)
let mf_flifa_re = 2 * mean((v(if_out)) * mfw * cos(mfph)) * mfs
let mf_flifa_im = 2 * mean((v(if_out)) * mfw * sin(mfph)) * mfs
let mfph = 2 * pi * 1050000000.0 * (time - 2e-08)
let mf_flifb_re = 2 * mean((v(if_out)) * mfw * cos(mfph)) * mfs
let mf_flifb_im = 2 * mean((v(if_out)) * mfw * sin(mfph)) * mfs
let mfph = 2 * pi * 20250000000.0 * (time - 2e-08)
let mf_fllorf_re = 2 * mean((v(rf_port)) * mfw * cos(mfph)) * mfs
let mf_fllorf_im = 2 * mean((v(rf_port)) * mfw * sin(mfph)) * mfs
let mfph = 2 * pi * 20250000000.0 * (time - 2e-08)
let mf_flloif_re = 2 * mean((v(if_out)) * mfw * cos(mfph)) * mfs
let mf_flloif_im = 2 * mean((v(if_out)) * mfw * sin(mfph)) * mfs
print mf_l
print mf_n
print mf_prail
print mf_lodiff_re
print mf_lodiff_im
print mf_if_re
print mf_if_im
print mf_loif_re
print mf_loif_im
print mf_lorf_re
print mf_lorf_im
print mf_flifa_re
print mf_flifa_im
print mf_flifb_re
print mf_flifb_im
print mf_fllorf_re
print mf_fllorf_im
print mf_flloif_re
print mf_flloif_im
destroy all
echo "MFEND ls_f21p20_m30_rf60"
echo "MFRUN ls_f21p20_m30_rf66"
alterparam f1 = 21200000000.0
alterparam f2 = 21200000000.0
alterparam flo = 20200000000.0
alterparam vrf1 = 0.00031697863849222284
alterparam vrf2 = 0.0
alterparam vlo = 0.0282842712474619
reset
op
let mf_dcirail = 0 - i(vdd)
let mf_dc_vce_q1 = v(c_q1)-v(e_q1)
let mf_dc_vbe_q1 = v(b_q1)-v(e_q1)
let mf_dc_ic_q1 = i(vic_q1)
let mf_dc_vce_q2 = v(c_q2)-v(e_q2)
let mf_dc_vbe_q2 = v(b_q2)-v(e_q2)
let mf_dc_ic_q2 = i(vic_q2)
let mf_dc_vce_q3 = v(c_q3)-v(x1)
let mf_dc_vbe_q3 = v(lo_p)-v(x1)
let mf_dc_ic_q3 = i(vic_q3)
let mf_dc_vce_q4 = v(c_q4)-v(x1)
let mf_dc_vbe_q4 = v(lo_n)-v(x1)
let mf_dc_ic_q4 = i(vic_q4)
let mf_dc_vce_q5 = v(c_q5)-v(x2)
let mf_dc_vbe_q5 = v(lo_p)-v(x2)
let mf_dc_ic_q5 = i(vic_q5)
let mf_dc_vce_q6 = v(c_q6)-v(x2)
let mf_dc_vbe_q6 = v(lo_n)-v(x2)
let mf_dc_ic_q6 = i(vic_q6)
let mf_dc_sink_tail = v(tail)
print mf_dcirail
print mf_dc_vce_q1
print mf_dc_vbe_q1
print mf_dc_ic_q1
print mf_dc_vce_q2
print mf_dc_vbe_q2
print mf_dc_ic_q2
print mf_dc_vce_q3
print mf_dc_vbe_q3
print mf_dc_ic_q3
print mf_dc_vce_q4
print mf_dc_vbe_q4
print mf_dc_ic_q4
print mf_dc_vce_q5
print mf_dc_vbe_q5
print mf_dc_ic_q5
print mf_dc_vce_q6
print mf_dc_vbe_q6
print mf_dc_ic_q6
print mf_dc_sink_tail
tran 1e-12 4e-08 0 1e-12
let mfq_vce_q1 = v(c_q1)-v(e_q1)
meas tran mf_su_vcemax_q1 MAX mfq_vce_q1 from=0.0 to=2e-08
meas tran mf_su_vcemin_q1 MIN mfq_vce_q1 from=0.0 to=2e-08
meas tran mf_ss_vcemax_q1 MAX mfq_vce_q1 from=2e-08 to=4e-08
meas tran mf_ss_vcemin_q1 MIN mfq_vce_q1 from=2e-08 to=4e-08
let mfq_vbe_q1 = v(b_q1)-v(e_q1)
meas tran mf_su_vbemax_q1 MAX mfq_vbe_q1 from=0.0 to=2e-08
meas tran mf_su_vbemin_q1 MIN mfq_vbe_q1 from=0.0 to=2e-08
meas tran mf_ss_vbemax_q1 MAX mfq_vbe_q1 from=2e-08 to=4e-08
meas tran mf_ss_vbemin_q1 MIN mfq_vbe_q1 from=2e-08 to=4e-08
let mfq_ic_q1 = i(vic_q1)
meas tran mf_su_icmax_q1 MAX mfq_ic_q1 from=0.0 to=2e-08
meas tran mf_su_icmin_q1 MIN mfq_ic_q1 from=0.0 to=2e-08
meas tran mf_ss_icmax_q1 MAX mfq_ic_q1 from=2e-08 to=4e-08
meas tran mf_ss_icmin_q1 MIN mfq_ic_q1 from=2e-08 to=4e-08
let mfq_vce_q2 = v(c_q2)-v(e_q2)
meas tran mf_su_vcemax_q2 MAX mfq_vce_q2 from=0.0 to=2e-08
meas tran mf_su_vcemin_q2 MIN mfq_vce_q2 from=0.0 to=2e-08
meas tran mf_ss_vcemax_q2 MAX mfq_vce_q2 from=2e-08 to=4e-08
meas tran mf_ss_vcemin_q2 MIN mfq_vce_q2 from=2e-08 to=4e-08
let mfq_vbe_q2 = v(b_q2)-v(e_q2)
meas tran mf_su_vbemax_q2 MAX mfq_vbe_q2 from=0.0 to=2e-08
meas tran mf_su_vbemin_q2 MIN mfq_vbe_q2 from=0.0 to=2e-08
meas tran mf_ss_vbemax_q2 MAX mfq_vbe_q2 from=2e-08 to=4e-08
meas tran mf_ss_vbemin_q2 MIN mfq_vbe_q2 from=2e-08 to=4e-08
let mfq_ic_q2 = i(vic_q2)
meas tran mf_su_icmax_q2 MAX mfq_ic_q2 from=0.0 to=2e-08
meas tran mf_su_icmin_q2 MIN mfq_ic_q2 from=0.0 to=2e-08
meas tran mf_ss_icmax_q2 MAX mfq_ic_q2 from=2e-08 to=4e-08
meas tran mf_ss_icmin_q2 MIN mfq_ic_q2 from=2e-08 to=4e-08
let mfq_vce_q3 = v(c_q3)-v(x1)
meas tran mf_su_vcemax_q3 MAX mfq_vce_q3 from=0.0 to=2e-08
meas tran mf_su_vcemin_q3 MIN mfq_vce_q3 from=0.0 to=2e-08
meas tran mf_ss_vcemax_q3 MAX mfq_vce_q3 from=2e-08 to=4e-08
meas tran mf_ss_vcemin_q3 MIN mfq_vce_q3 from=2e-08 to=4e-08
let mfq_vbe_q3 = v(lo_p)-v(x1)
meas tran mf_su_vbemax_q3 MAX mfq_vbe_q3 from=0.0 to=2e-08
meas tran mf_su_vbemin_q3 MIN mfq_vbe_q3 from=0.0 to=2e-08
meas tran mf_ss_vbemax_q3 MAX mfq_vbe_q3 from=2e-08 to=4e-08
meas tran mf_ss_vbemin_q3 MIN mfq_vbe_q3 from=2e-08 to=4e-08
let mfq_ic_q3 = i(vic_q3)
meas tran mf_su_icmax_q3 MAX mfq_ic_q3 from=0.0 to=2e-08
meas tran mf_su_icmin_q3 MIN mfq_ic_q3 from=0.0 to=2e-08
meas tran mf_ss_icmax_q3 MAX mfq_ic_q3 from=2e-08 to=4e-08
meas tran mf_ss_icmin_q3 MIN mfq_ic_q3 from=2e-08 to=4e-08
let mfq_vce_q4 = v(c_q4)-v(x1)
meas tran mf_su_vcemax_q4 MAX mfq_vce_q4 from=0.0 to=2e-08
meas tran mf_su_vcemin_q4 MIN mfq_vce_q4 from=0.0 to=2e-08
meas tran mf_ss_vcemax_q4 MAX mfq_vce_q4 from=2e-08 to=4e-08
meas tran mf_ss_vcemin_q4 MIN mfq_vce_q4 from=2e-08 to=4e-08
let mfq_vbe_q4 = v(lo_n)-v(x1)
meas tran mf_su_vbemax_q4 MAX mfq_vbe_q4 from=0.0 to=2e-08
meas tran mf_su_vbemin_q4 MIN mfq_vbe_q4 from=0.0 to=2e-08
meas tran mf_ss_vbemax_q4 MAX mfq_vbe_q4 from=2e-08 to=4e-08
meas tran mf_ss_vbemin_q4 MIN mfq_vbe_q4 from=2e-08 to=4e-08
let mfq_ic_q4 = i(vic_q4)
meas tran mf_su_icmax_q4 MAX mfq_ic_q4 from=0.0 to=2e-08
meas tran mf_su_icmin_q4 MIN mfq_ic_q4 from=0.0 to=2e-08
meas tran mf_ss_icmax_q4 MAX mfq_ic_q4 from=2e-08 to=4e-08
meas tran mf_ss_icmin_q4 MIN mfq_ic_q4 from=2e-08 to=4e-08
let mfq_vce_q5 = v(c_q5)-v(x2)
meas tran mf_su_vcemax_q5 MAX mfq_vce_q5 from=0.0 to=2e-08
meas tran mf_su_vcemin_q5 MIN mfq_vce_q5 from=0.0 to=2e-08
meas tran mf_ss_vcemax_q5 MAX mfq_vce_q5 from=2e-08 to=4e-08
meas tran mf_ss_vcemin_q5 MIN mfq_vce_q5 from=2e-08 to=4e-08
let mfq_vbe_q5 = v(lo_p)-v(x2)
meas tran mf_su_vbemax_q5 MAX mfq_vbe_q5 from=0.0 to=2e-08
meas tran mf_su_vbemin_q5 MIN mfq_vbe_q5 from=0.0 to=2e-08
meas tran mf_ss_vbemax_q5 MAX mfq_vbe_q5 from=2e-08 to=4e-08
meas tran mf_ss_vbemin_q5 MIN mfq_vbe_q5 from=2e-08 to=4e-08
let mfq_ic_q5 = i(vic_q5)
meas tran mf_su_icmax_q5 MAX mfq_ic_q5 from=0.0 to=2e-08
meas tran mf_su_icmin_q5 MIN mfq_ic_q5 from=0.0 to=2e-08
meas tran mf_ss_icmax_q5 MAX mfq_ic_q5 from=2e-08 to=4e-08
meas tran mf_ss_icmin_q5 MIN mfq_ic_q5 from=2e-08 to=4e-08
let mfq_vce_q6 = v(c_q6)-v(x2)
meas tran mf_su_vcemax_q6 MAX mfq_vce_q6 from=0.0 to=2e-08
meas tran mf_su_vcemin_q6 MIN mfq_vce_q6 from=0.0 to=2e-08
meas tran mf_ss_vcemax_q6 MAX mfq_vce_q6 from=2e-08 to=4e-08
meas tran mf_ss_vcemin_q6 MIN mfq_vce_q6 from=2e-08 to=4e-08
let mfq_vbe_q6 = v(lo_n)-v(x2)
meas tran mf_su_vbemax_q6 MAX mfq_vbe_q6 from=0.0 to=2e-08
meas tran mf_su_vbemin_q6 MIN mfq_vbe_q6 from=0.0 to=2e-08
meas tran mf_ss_vbemax_q6 MAX mfq_vbe_q6 from=2e-08 to=4e-08
meas tran mf_ss_vbemin_q6 MIN mfq_vbe_q6 from=2e-08 to=4e-08
let mfq_ic_q6 = i(vic_q6)
meas tran mf_su_icmax_q6 MAX mfq_ic_q6 from=0.0 to=2e-08
meas tran mf_su_icmin_q6 MIN mfq_ic_q6 from=0.0 to=2e-08
meas tran mf_ss_icmax_q6 MAX mfq_ic_q6 from=2e-08 to=4e-08
meas tran mf_ss_icmin_q6 MIN mfq_ic_q6 from=2e-08 to=4e-08
meas tran mf_su_sinkmin_tail MIN v(tail) from=0.0 to=2e-08
meas tran mf_ss_sinkmin_tail MIN v(tail) from=2e-08 to=4e-08
print mf_su_vcemax_q1
print mf_su_vcemin_q1
print mf_ss_vcemax_q1
print mf_ss_vcemin_q1
print mf_su_vbemax_q1
print mf_su_vbemin_q1
print mf_ss_vbemax_q1
print mf_ss_vbemin_q1
print mf_su_icmax_q1
print mf_su_icmin_q1
print mf_ss_icmax_q1
print mf_ss_icmin_q1
print mf_su_vcemax_q2
print mf_su_vcemin_q2
print mf_ss_vcemax_q2
print mf_ss_vcemin_q2
print mf_su_vbemax_q2
print mf_su_vbemin_q2
print mf_ss_vbemax_q2
print mf_ss_vbemin_q2
print mf_su_icmax_q2
print mf_su_icmin_q2
print mf_ss_icmax_q2
print mf_ss_icmin_q2
print mf_su_vcemax_q3
print mf_su_vcemin_q3
print mf_ss_vcemax_q3
print mf_ss_vcemin_q3
print mf_su_vbemax_q3
print mf_su_vbemin_q3
print mf_ss_vbemax_q3
print mf_ss_vbemin_q3
print mf_su_icmax_q3
print mf_su_icmin_q3
print mf_ss_icmax_q3
print mf_ss_icmin_q3
print mf_su_vcemax_q4
print mf_su_vcemin_q4
print mf_ss_vcemax_q4
print mf_ss_vcemin_q4
print mf_su_vbemax_q4
print mf_su_vbemin_q4
print mf_ss_vbemax_q4
print mf_ss_vbemin_q4
print mf_su_icmax_q4
print mf_su_icmin_q4
print mf_ss_icmax_q4
print mf_ss_icmin_q4
print mf_su_vcemax_q5
print mf_su_vcemin_q5
print mf_ss_vcemax_q5
print mf_ss_vcemin_q5
print mf_su_vbemax_q5
print mf_su_vbemin_q5
print mf_ss_vbemax_q5
print mf_ss_vbemin_q5
print mf_su_icmax_q5
print mf_su_icmin_q5
print mf_ss_icmax_q5
print mf_ss_icmin_q5
print mf_su_vcemax_q6
print mf_su_vcemin_q6
print mf_ss_vcemax_q6
print mf_ss_vcemin_q6
print mf_su_vbemax_q6
print mf_su_vbemin_q6
print mf_ss_vbemax_q6
print mf_ss_vbemin_q6
print mf_su_icmax_q6
print mf_su_icmin_q6
print mf_ss_icmax_q6
print mf_ss_icmin_q6
print mf_su_sinkmin_tail
print mf_ss_sinkmin_tail
linearize
let mf_l = length(time)
let mfw = (time ge 1.99995e-08) * (time lt 3.99995e-08)
let mf_n = mean(mfw) * mf_l
let mfs = mf_l / mf_n
let mf_prail = mean(v(vdd) * (0 - i(vdd)) * mfw) * mfs
let mfph = 2 * pi * 20200000000.0 * (time - 2e-08)
let mf_lodiff_re = 2 * mean((v(lo_p)-v(lo_n)) * mfw * cos(mfph)) * mfs
let mf_lodiff_im = 2 * mean((v(lo_p)-v(lo_n)) * mfw * sin(mfph)) * mfs
let mfph = 2 * pi * 1000000000.0 * (time - 2e-08)
let mf_if_re = 2 * mean((v(if_out)) * mfw * cos(mfph)) * mfs
let mf_if_im = 2 * mean((v(if_out)) * mfw * sin(mfph)) * mfs
let mfph = 2 * pi * 20200000000.0 * (time - 2e-08)
let mf_loif_re = 2 * mean((v(if_out)) * mfw * cos(mfph)) * mfs
let mf_loif_im = 2 * mean((v(if_out)) * mfw * sin(mfph)) * mfs
let mfph = 2 * pi * 20200000000.0 * (time - 2e-08)
let mf_lorf_re = 2 * mean((v(rf_port)) * mfw * cos(mfph)) * mfs
let mf_lorf_im = 2 * mean((v(rf_port)) * mfw * sin(mfph)) * mfs
let mfph = 2 * pi * 950000000.0 * (time - 2e-08)
let mf_flifa_re = 2 * mean((v(if_out)) * mfw * cos(mfph)) * mfs
let mf_flifa_im = 2 * mean((v(if_out)) * mfw * sin(mfph)) * mfs
let mfph = 2 * pi * 1050000000.0 * (time - 2e-08)
let mf_flifb_re = 2 * mean((v(if_out)) * mfw * cos(mfph)) * mfs
let mf_flifb_im = 2 * mean((v(if_out)) * mfw * sin(mfph)) * mfs
let mfph = 2 * pi * 20250000000.0 * (time - 2e-08)
let mf_fllorf_re = 2 * mean((v(rf_port)) * mfw * cos(mfph)) * mfs
let mf_fllorf_im = 2 * mean((v(rf_port)) * mfw * sin(mfph)) * mfs
let mfph = 2 * pi * 20250000000.0 * (time - 2e-08)
let mf_flloif_re = 2 * mean((v(if_out)) * mfw * cos(mfph)) * mfs
let mf_flloif_im = 2 * mean((v(if_out)) * mfw * sin(mfph)) * mfs
print mf_l
print mf_n
print mf_prail
print mf_lodiff_re
print mf_lodiff_im
print mf_if_re
print mf_if_im
print mf_loif_re
print mf_loif_im
print mf_lorf_re
print mf_lorf_im
print mf_flifa_re
print mf_flifa_im
print mf_flifb_re
print mf_flifb_im
print mf_fllorf_re
print mf_fllorf_im
print mf_flloif_re
print mf_flloif_im
destroy all
echo "MFEND ls_f21p20_m30_rf66"
echo "MFRUN ls_f21p20_m27_rf60"
alterparam f1 = 21200000000.0
alterparam f2 = 21200000000.0
alterparam flo = 20200000000.0
alterparam vrf1 = 0.0006324555320336759
alterparam vrf2 = 0.0
alterparam vlo = 0.039952595059333795
reset
op
let mf_dcirail = 0 - i(vdd)
let mf_dc_vce_q1 = v(c_q1)-v(e_q1)
let mf_dc_vbe_q1 = v(b_q1)-v(e_q1)
let mf_dc_ic_q1 = i(vic_q1)
let mf_dc_vce_q2 = v(c_q2)-v(e_q2)
let mf_dc_vbe_q2 = v(b_q2)-v(e_q2)
let mf_dc_ic_q2 = i(vic_q2)
let mf_dc_vce_q3 = v(c_q3)-v(x1)
let mf_dc_vbe_q3 = v(lo_p)-v(x1)
let mf_dc_ic_q3 = i(vic_q3)
let mf_dc_vce_q4 = v(c_q4)-v(x1)
let mf_dc_vbe_q4 = v(lo_n)-v(x1)
let mf_dc_ic_q4 = i(vic_q4)
let mf_dc_vce_q5 = v(c_q5)-v(x2)
let mf_dc_vbe_q5 = v(lo_p)-v(x2)
let mf_dc_ic_q5 = i(vic_q5)
let mf_dc_vce_q6 = v(c_q6)-v(x2)
let mf_dc_vbe_q6 = v(lo_n)-v(x2)
let mf_dc_ic_q6 = i(vic_q6)
let mf_dc_sink_tail = v(tail)
print mf_dcirail
print mf_dc_vce_q1
print mf_dc_vbe_q1
print mf_dc_ic_q1
print mf_dc_vce_q2
print mf_dc_vbe_q2
print mf_dc_ic_q2
print mf_dc_vce_q3
print mf_dc_vbe_q3
print mf_dc_ic_q3
print mf_dc_vce_q4
print mf_dc_vbe_q4
print mf_dc_ic_q4
print mf_dc_vce_q5
print mf_dc_vbe_q5
print mf_dc_ic_q5
print mf_dc_vce_q6
print mf_dc_vbe_q6
print mf_dc_ic_q6
print mf_dc_sink_tail
tran 1e-12 4e-08 0 1e-12
let mfq_vce_q1 = v(c_q1)-v(e_q1)
meas tran mf_su_vcemax_q1 MAX mfq_vce_q1 from=0.0 to=2e-08
meas tran mf_su_vcemin_q1 MIN mfq_vce_q1 from=0.0 to=2e-08
meas tran mf_ss_vcemax_q1 MAX mfq_vce_q1 from=2e-08 to=4e-08
meas tran mf_ss_vcemin_q1 MIN mfq_vce_q1 from=2e-08 to=4e-08
let mfq_vbe_q1 = v(b_q1)-v(e_q1)
meas tran mf_su_vbemax_q1 MAX mfq_vbe_q1 from=0.0 to=2e-08
meas tran mf_su_vbemin_q1 MIN mfq_vbe_q1 from=0.0 to=2e-08
meas tran mf_ss_vbemax_q1 MAX mfq_vbe_q1 from=2e-08 to=4e-08
meas tran mf_ss_vbemin_q1 MIN mfq_vbe_q1 from=2e-08 to=4e-08
let mfq_ic_q1 = i(vic_q1)
meas tran mf_su_icmax_q1 MAX mfq_ic_q1 from=0.0 to=2e-08
meas tran mf_su_icmin_q1 MIN mfq_ic_q1 from=0.0 to=2e-08
meas tran mf_ss_icmax_q1 MAX mfq_ic_q1 from=2e-08 to=4e-08
meas tran mf_ss_icmin_q1 MIN mfq_ic_q1 from=2e-08 to=4e-08
let mfq_vce_q2 = v(c_q2)-v(e_q2)
meas tran mf_su_vcemax_q2 MAX mfq_vce_q2 from=0.0 to=2e-08
meas tran mf_su_vcemin_q2 MIN mfq_vce_q2 from=0.0 to=2e-08
meas tran mf_ss_vcemax_q2 MAX mfq_vce_q2 from=2e-08 to=4e-08
meas tran mf_ss_vcemin_q2 MIN mfq_vce_q2 from=2e-08 to=4e-08
let mfq_vbe_q2 = v(b_q2)-v(e_q2)
meas tran mf_su_vbemax_q2 MAX mfq_vbe_q2 from=0.0 to=2e-08
meas tran mf_su_vbemin_q2 MIN mfq_vbe_q2 from=0.0 to=2e-08
meas tran mf_ss_vbemax_q2 MAX mfq_vbe_q2 from=2e-08 to=4e-08
meas tran mf_ss_vbemin_q2 MIN mfq_vbe_q2 from=2e-08 to=4e-08
let mfq_ic_q2 = i(vic_q2)
meas tran mf_su_icmax_q2 MAX mfq_ic_q2 from=0.0 to=2e-08
meas tran mf_su_icmin_q2 MIN mfq_ic_q2 from=0.0 to=2e-08
meas tran mf_ss_icmax_q2 MAX mfq_ic_q2 from=2e-08 to=4e-08
meas tran mf_ss_icmin_q2 MIN mfq_ic_q2 from=2e-08 to=4e-08
let mfq_vce_q3 = v(c_q3)-v(x1)
meas tran mf_su_vcemax_q3 MAX mfq_vce_q3 from=0.0 to=2e-08
meas tran mf_su_vcemin_q3 MIN mfq_vce_q3 from=0.0 to=2e-08
meas tran mf_ss_vcemax_q3 MAX mfq_vce_q3 from=2e-08 to=4e-08
meas tran mf_ss_vcemin_q3 MIN mfq_vce_q3 from=2e-08 to=4e-08
let mfq_vbe_q3 = v(lo_p)-v(x1)
meas tran mf_su_vbemax_q3 MAX mfq_vbe_q3 from=0.0 to=2e-08
meas tran mf_su_vbemin_q3 MIN mfq_vbe_q3 from=0.0 to=2e-08
meas tran mf_ss_vbemax_q3 MAX mfq_vbe_q3 from=2e-08 to=4e-08
meas tran mf_ss_vbemin_q3 MIN mfq_vbe_q3 from=2e-08 to=4e-08
let mfq_ic_q3 = i(vic_q3)
meas tran mf_su_icmax_q3 MAX mfq_ic_q3 from=0.0 to=2e-08
meas tran mf_su_icmin_q3 MIN mfq_ic_q3 from=0.0 to=2e-08
meas tran mf_ss_icmax_q3 MAX mfq_ic_q3 from=2e-08 to=4e-08
meas tran mf_ss_icmin_q3 MIN mfq_ic_q3 from=2e-08 to=4e-08
let mfq_vce_q4 = v(c_q4)-v(x1)
meas tran mf_su_vcemax_q4 MAX mfq_vce_q4 from=0.0 to=2e-08
meas tran mf_su_vcemin_q4 MIN mfq_vce_q4 from=0.0 to=2e-08
meas tran mf_ss_vcemax_q4 MAX mfq_vce_q4 from=2e-08 to=4e-08
meas tran mf_ss_vcemin_q4 MIN mfq_vce_q4 from=2e-08 to=4e-08
let mfq_vbe_q4 = v(lo_n)-v(x1)
meas tran mf_su_vbemax_q4 MAX mfq_vbe_q4 from=0.0 to=2e-08
meas tran mf_su_vbemin_q4 MIN mfq_vbe_q4 from=0.0 to=2e-08
meas tran mf_ss_vbemax_q4 MAX mfq_vbe_q4 from=2e-08 to=4e-08
meas tran mf_ss_vbemin_q4 MIN mfq_vbe_q4 from=2e-08 to=4e-08
let mfq_ic_q4 = i(vic_q4)
meas tran mf_su_icmax_q4 MAX mfq_ic_q4 from=0.0 to=2e-08
meas tran mf_su_icmin_q4 MIN mfq_ic_q4 from=0.0 to=2e-08
meas tran mf_ss_icmax_q4 MAX mfq_ic_q4 from=2e-08 to=4e-08
meas tran mf_ss_icmin_q4 MIN mfq_ic_q4 from=2e-08 to=4e-08
let mfq_vce_q5 = v(c_q5)-v(x2)
meas tran mf_su_vcemax_q5 MAX mfq_vce_q5 from=0.0 to=2e-08
meas tran mf_su_vcemin_q5 MIN mfq_vce_q5 from=0.0 to=2e-08
meas tran mf_ss_vcemax_q5 MAX mfq_vce_q5 from=2e-08 to=4e-08
meas tran mf_ss_vcemin_q5 MIN mfq_vce_q5 from=2e-08 to=4e-08
let mfq_vbe_q5 = v(lo_p)-v(x2)
meas tran mf_su_vbemax_q5 MAX mfq_vbe_q5 from=0.0 to=2e-08
meas tran mf_su_vbemin_q5 MIN mfq_vbe_q5 from=0.0 to=2e-08
meas tran mf_ss_vbemax_q5 MAX mfq_vbe_q5 from=2e-08 to=4e-08
meas tran mf_ss_vbemin_q5 MIN mfq_vbe_q5 from=2e-08 to=4e-08
let mfq_ic_q5 = i(vic_q5)
meas tran mf_su_icmax_q5 MAX mfq_ic_q5 from=0.0 to=2e-08
meas tran mf_su_icmin_q5 MIN mfq_ic_q5 from=0.0 to=2e-08
meas tran mf_ss_icmax_q5 MAX mfq_ic_q5 from=2e-08 to=4e-08
meas tran mf_ss_icmin_q5 MIN mfq_ic_q5 from=2e-08 to=4e-08
let mfq_vce_q6 = v(c_q6)-v(x2)
meas tran mf_su_vcemax_q6 MAX mfq_vce_q6 from=0.0 to=2e-08
meas tran mf_su_vcemin_q6 MIN mfq_vce_q6 from=0.0 to=2e-08
meas tran mf_ss_vcemax_q6 MAX mfq_vce_q6 from=2e-08 to=4e-08
meas tran mf_ss_vcemin_q6 MIN mfq_vce_q6 from=2e-08 to=4e-08
let mfq_vbe_q6 = v(lo_n)-v(x2)
meas tran mf_su_vbemax_q6 MAX mfq_vbe_q6 from=0.0 to=2e-08
meas tran mf_su_vbemin_q6 MIN mfq_vbe_q6 from=0.0 to=2e-08
meas tran mf_ss_vbemax_q6 MAX mfq_vbe_q6 from=2e-08 to=4e-08
meas tran mf_ss_vbemin_q6 MIN mfq_vbe_q6 from=2e-08 to=4e-08
let mfq_ic_q6 = i(vic_q6)
meas tran mf_su_icmax_q6 MAX mfq_ic_q6 from=0.0 to=2e-08
meas tran mf_su_icmin_q6 MIN mfq_ic_q6 from=0.0 to=2e-08
meas tran mf_ss_icmax_q6 MAX mfq_ic_q6 from=2e-08 to=4e-08
meas tran mf_ss_icmin_q6 MIN mfq_ic_q6 from=2e-08 to=4e-08
meas tran mf_su_sinkmin_tail MIN v(tail) from=0.0 to=2e-08
meas tran mf_ss_sinkmin_tail MIN v(tail) from=2e-08 to=4e-08
print mf_su_vcemax_q1
print mf_su_vcemin_q1
print mf_ss_vcemax_q1
print mf_ss_vcemin_q1
print mf_su_vbemax_q1
print mf_su_vbemin_q1
print mf_ss_vbemax_q1
print mf_ss_vbemin_q1
print mf_su_icmax_q1
print mf_su_icmin_q1
print mf_ss_icmax_q1
print mf_ss_icmin_q1
print mf_su_vcemax_q2
print mf_su_vcemin_q2
print mf_ss_vcemax_q2
print mf_ss_vcemin_q2
print mf_su_vbemax_q2
print mf_su_vbemin_q2
print mf_ss_vbemax_q2
print mf_ss_vbemin_q2
print mf_su_icmax_q2
print mf_su_icmin_q2
print mf_ss_icmax_q2
print mf_ss_icmin_q2
print mf_su_vcemax_q3
print mf_su_vcemin_q3
print mf_ss_vcemax_q3
print mf_ss_vcemin_q3
print mf_su_vbemax_q3
print mf_su_vbemin_q3
print mf_ss_vbemax_q3
print mf_ss_vbemin_q3
print mf_su_icmax_q3
print mf_su_icmin_q3
print mf_ss_icmax_q3
print mf_ss_icmin_q3
print mf_su_vcemax_q4
print mf_su_vcemin_q4
print mf_ss_vcemax_q4
print mf_ss_vcemin_q4
print mf_su_vbemax_q4
print mf_su_vbemin_q4
print mf_ss_vbemax_q4
print mf_ss_vbemin_q4
print mf_su_icmax_q4
print mf_su_icmin_q4
print mf_ss_icmax_q4
print mf_ss_icmin_q4
print mf_su_vcemax_q5
print mf_su_vcemin_q5
print mf_ss_vcemax_q5
print mf_ss_vcemin_q5
print mf_su_vbemax_q5
print mf_su_vbemin_q5
print mf_ss_vbemax_q5
print mf_ss_vbemin_q5
print mf_su_icmax_q5
print mf_su_icmin_q5
print mf_ss_icmax_q5
print mf_ss_icmin_q5
print mf_su_vcemax_q6
print mf_su_vcemin_q6
print mf_ss_vcemax_q6
print mf_ss_vcemin_q6
print mf_su_vbemax_q6
print mf_su_vbemin_q6
print mf_ss_vbemax_q6
print mf_ss_vbemin_q6
print mf_su_icmax_q6
print mf_su_icmin_q6
print mf_ss_icmax_q6
print mf_ss_icmin_q6
print mf_su_sinkmin_tail
print mf_ss_sinkmin_tail
linearize
let mf_l = length(time)
let mfw = (time ge 1.99995e-08) * (time lt 3.99995e-08)
let mf_n = mean(mfw) * mf_l
let mfs = mf_l / mf_n
let mf_prail = mean(v(vdd) * (0 - i(vdd)) * mfw) * mfs
let mfph = 2 * pi * 20200000000.0 * (time - 2e-08)
let mf_lodiff_re = 2 * mean((v(lo_p)-v(lo_n)) * mfw * cos(mfph)) * mfs
let mf_lodiff_im = 2 * mean((v(lo_p)-v(lo_n)) * mfw * sin(mfph)) * mfs
let mfph = 2 * pi * 1000000000.0 * (time - 2e-08)
let mf_if_re = 2 * mean((v(if_out)) * mfw * cos(mfph)) * mfs
let mf_if_im = 2 * mean((v(if_out)) * mfw * sin(mfph)) * mfs
let mfph = 2 * pi * 20200000000.0 * (time - 2e-08)
let mf_loif_re = 2 * mean((v(if_out)) * mfw * cos(mfph)) * mfs
let mf_loif_im = 2 * mean((v(if_out)) * mfw * sin(mfph)) * mfs
let mfph = 2 * pi * 20200000000.0 * (time - 2e-08)
let mf_lorf_re = 2 * mean((v(rf_port)) * mfw * cos(mfph)) * mfs
let mf_lorf_im = 2 * mean((v(rf_port)) * mfw * sin(mfph)) * mfs
let mfph = 2 * pi * 950000000.0 * (time - 2e-08)
let mf_flifa_re = 2 * mean((v(if_out)) * mfw * cos(mfph)) * mfs
let mf_flifa_im = 2 * mean((v(if_out)) * mfw * sin(mfph)) * mfs
let mfph = 2 * pi * 1050000000.0 * (time - 2e-08)
let mf_flifb_re = 2 * mean((v(if_out)) * mfw * cos(mfph)) * mfs
let mf_flifb_im = 2 * mean((v(if_out)) * mfw * sin(mfph)) * mfs
let mfph = 2 * pi * 20250000000.0 * (time - 2e-08)
let mf_fllorf_re = 2 * mean((v(rf_port)) * mfw * cos(mfph)) * mfs
let mf_fllorf_im = 2 * mean((v(rf_port)) * mfw * sin(mfph)) * mfs
let mfph = 2 * pi * 20250000000.0 * (time - 2e-08)
let mf_flloif_re = 2 * mean((v(if_out)) * mfw * cos(mfph)) * mfs
let mf_flloif_im = 2 * mean((v(if_out)) * mfw * sin(mfph)) * mfs
print mf_l
print mf_n
print mf_prail
print mf_lodiff_re
print mf_lodiff_im
print mf_if_re
print mf_if_im
print mf_loif_re
print mf_loif_im
print mf_lorf_re
print mf_lorf_im
print mf_flifa_re
print mf_flifa_im
print mf_flifb_re
print mf_flifb_im
print mf_fllorf_re
print mf_fllorf_im
print mf_flloif_re
print mf_flloif_im
destroy all
echo "MFEND ls_f21p20_m27_rf60"
echo "MFRUN ls_f21p20_m27_rf66"
alterparam f1 = 21200000000.0
alterparam f2 = 21200000000.0
alterparam flo = 20200000000.0
alterparam vrf1 = 0.00031697863849222284
alterparam vrf2 = 0.0
alterparam vlo = 0.039952595059333795
reset
op
let mf_dcirail = 0 - i(vdd)
let mf_dc_vce_q1 = v(c_q1)-v(e_q1)
let mf_dc_vbe_q1 = v(b_q1)-v(e_q1)
let mf_dc_ic_q1 = i(vic_q1)
let mf_dc_vce_q2 = v(c_q2)-v(e_q2)
let mf_dc_vbe_q2 = v(b_q2)-v(e_q2)
let mf_dc_ic_q2 = i(vic_q2)
let mf_dc_vce_q3 = v(c_q3)-v(x1)
let mf_dc_vbe_q3 = v(lo_p)-v(x1)
let mf_dc_ic_q3 = i(vic_q3)
let mf_dc_vce_q4 = v(c_q4)-v(x1)
let mf_dc_vbe_q4 = v(lo_n)-v(x1)
let mf_dc_ic_q4 = i(vic_q4)
let mf_dc_vce_q5 = v(c_q5)-v(x2)
let mf_dc_vbe_q5 = v(lo_p)-v(x2)
let mf_dc_ic_q5 = i(vic_q5)
let mf_dc_vce_q6 = v(c_q6)-v(x2)
let mf_dc_vbe_q6 = v(lo_n)-v(x2)
let mf_dc_ic_q6 = i(vic_q6)
let mf_dc_sink_tail = v(tail)
print mf_dcirail
print mf_dc_vce_q1
print mf_dc_vbe_q1
print mf_dc_ic_q1
print mf_dc_vce_q2
print mf_dc_vbe_q2
print mf_dc_ic_q2
print mf_dc_vce_q3
print mf_dc_vbe_q3
print mf_dc_ic_q3
print mf_dc_vce_q4
print mf_dc_vbe_q4
print mf_dc_ic_q4
print mf_dc_vce_q5
print mf_dc_vbe_q5
print mf_dc_ic_q5
print mf_dc_vce_q6
print mf_dc_vbe_q6
print mf_dc_ic_q6
print mf_dc_sink_tail
tran 1e-12 4e-08 0 1e-12
let mfq_vce_q1 = v(c_q1)-v(e_q1)
meas tran mf_su_vcemax_q1 MAX mfq_vce_q1 from=0.0 to=2e-08
meas tran mf_su_vcemin_q1 MIN mfq_vce_q1 from=0.0 to=2e-08
meas tran mf_ss_vcemax_q1 MAX mfq_vce_q1 from=2e-08 to=4e-08
meas tran mf_ss_vcemin_q1 MIN mfq_vce_q1 from=2e-08 to=4e-08
let mfq_vbe_q1 = v(b_q1)-v(e_q1)
meas tran mf_su_vbemax_q1 MAX mfq_vbe_q1 from=0.0 to=2e-08
meas tran mf_su_vbemin_q1 MIN mfq_vbe_q1 from=0.0 to=2e-08
meas tran mf_ss_vbemax_q1 MAX mfq_vbe_q1 from=2e-08 to=4e-08
meas tran mf_ss_vbemin_q1 MIN mfq_vbe_q1 from=2e-08 to=4e-08
let mfq_ic_q1 = i(vic_q1)
meas tran mf_su_icmax_q1 MAX mfq_ic_q1 from=0.0 to=2e-08
meas tran mf_su_icmin_q1 MIN mfq_ic_q1 from=0.0 to=2e-08
meas tran mf_ss_icmax_q1 MAX mfq_ic_q1 from=2e-08 to=4e-08
meas tran mf_ss_icmin_q1 MIN mfq_ic_q1 from=2e-08 to=4e-08
let mfq_vce_q2 = v(c_q2)-v(e_q2)
meas tran mf_su_vcemax_q2 MAX mfq_vce_q2 from=0.0 to=2e-08
meas tran mf_su_vcemin_q2 MIN mfq_vce_q2 from=0.0 to=2e-08
meas tran mf_ss_vcemax_q2 MAX mfq_vce_q2 from=2e-08 to=4e-08
meas tran mf_ss_vcemin_q2 MIN mfq_vce_q2 from=2e-08 to=4e-08
let mfq_vbe_q2 = v(b_q2)-v(e_q2)
meas tran mf_su_vbemax_q2 MAX mfq_vbe_q2 from=0.0 to=2e-08
meas tran mf_su_vbemin_q2 MIN mfq_vbe_q2 from=0.0 to=2e-08
meas tran mf_ss_vbemax_q2 MAX mfq_vbe_q2 from=2e-08 to=4e-08
meas tran mf_ss_vbemin_q2 MIN mfq_vbe_q2 from=2e-08 to=4e-08
let mfq_ic_q2 = i(vic_q2)
meas tran mf_su_icmax_q2 MAX mfq_ic_q2 from=0.0 to=2e-08
meas tran mf_su_icmin_q2 MIN mfq_ic_q2 from=0.0 to=2e-08
meas tran mf_ss_icmax_q2 MAX mfq_ic_q2 from=2e-08 to=4e-08
meas tran mf_ss_icmin_q2 MIN mfq_ic_q2 from=2e-08 to=4e-08
let mfq_vce_q3 = v(c_q3)-v(x1)
meas tran mf_su_vcemax_q3 MAX mfq_vce_q3 from=0.0 to=2e-08
meas tran mf_su_vcemin_q3 MIN mfq_vce_q3 from=0.0 to=2e-08
meas tran mf_ss_vcemax_q3 MAX mfq_vce_q3 from=2e-08 to=4e-08
meas tran mf_ss_vcemin_q3 MIN mfq_vce_q3 from=2e-08 to=4e-08
let mfq_vbe_q3 = v(lo_p)-v(x1)
meas tran mf_su_vbemax_q3 MAX mfq_vbe_q3 from=0.0 to=2e-08
meas tran mf_su_vbemin_q3 MIN mfq_vbe_q3 from=0.0 to=2e-08
meas tran mf_ss_vbemax_q3 MAX mfq_vbe_q3 from=2e-08 to=4e-08
meas tran mf_ss_vbemin_q3 MIN mfq_vbe_q3 from=2e-08 to=4e-08
let mfq_ic_q3 = i(vic_q3)
meas tran mf_su_icmax_q3 MAX mfq_ic_q3 from=0.0 to=2e-08
meas tran mf_su_icmin_q3 MIN mfq_ic_q3 from=0.0 to=2e-08
meas tran mf_ss_icmax_q3 MAX mfq_ic_q3 from=2e-08 to=4e-08
meas tran mf_ss_icmin_q3 MIN mfq_ic_q3 from=2e-08 to=4e-08
let mfq_vce_q4 = v(c_q4)-v(x1)
meas tran mf_su_vcemax_q4 MAX mfq_vce_q4 from=0.0 to=2e-08
meas tran mf_su_vcemin_q4 MIN mfq_vce_q4 from=0.0 to=2e-08
meas tran mf_ss_vcemax_q4 MAX mfq_vce_q4 from=2e-08 to=4e-08
meas tran mf_ss_vcemin_q4 MIN mfq_vce_q4 from=2e-08 to=4e-08
let mfq_vbe_q4 = v(lo_n)-v(x1)
meas tran mf_su_vbemax_q4 MAX mfq_vbe_q4 from=0.0 to=2e-08
meas tran mf_su_vbemin_q4 MIN mfq_vbe_q4 from=0.0 to=2e-08
meas tran mf_ss_vbemax_q4 MAX mfq_vbe_q4 from=2e-08 to=4e-08
meas tran mf_ss_vbemin_q4 MIN mfq_vbe_q4 from=2e-08 to=4e-08
let mfq_ic_q4 = i(vic_q4)
meas tran mf_su_icmax_q4 MAX mfq_ic_q4 from=0.0 to=2e-08
meas tran mf_su_icmin_q4 MIN mfq_ic_q4 from=0.0 to=2e-08
meas tran mf_ss_icmax_q4 MAX mfq_ic_q4 from=2e-08 to=4e-08
meas tran mf_ss_icmin_q4 MIN mfq_ic_q4 from=2e-08 to=4e-08
let mfq_vce_q5 = v(c_q5)-v(x2)
meas tran mf_su_vcemax_q5 MAX mfq_vce_q5 from=0.0 to=2e-08
meas tran mf_su_vcemin_q5 MIN mfq_vce_q5 from=0.0 to=2e-08
meas tran mf_ss_vcemax_q5 MAX mfq_vce_q5 from=2e-08 to=4e-08
meas tran mf_ss_vcemin_q5 MIN mfq_vce_q5 from=2e-08 to=4e-08
let mfq_vbe_q5 = v(lo_p)-v(x2)
meas tran mf_su_vbemax_q5 MAX mfq_vbe_q5 from=0.0 to=2e-08
meas tran mf_su_vbemin_q5 MIN mfq_vbe_q5 from=0.0 to=2e-08
meas tran mf_ss_vbemax_q5 MAX mfq_vbe_q5 from=2e-08 to=4e-08
meas tran mf_ss_vbemin_q5 MIN mfq_vbe_q5 from=2e-08 to=4e-08
let mfq_ic_q5 = i(vic_q5)
meas tran mf_su_icmax_q5 MAX mfq_ic_q5 from=0.0 to=2e-08
meas tran mf_su_icmin_q5 MIN mfq_ic_q5 from=0.0 to=2e-08
meas tran mf_ss_icmax_q5 MAX mfq_ic_q5 from=2e-08 to=4e-08
meas tran mf_ss_icmin_q5 MIN mfq_ic_q5 from=2e-08 to=4e-08
let mfq_vce_q6 = v(c_q6)-v(x2)
meas tran mf_su_vcemax_q6 MAX mfq_vce_q6 from=0.0 to=2e-08
meas tran mf_su_vcemin_q6 MIN mfq_vce_q6 from=0.0 to=2e-08
meas tran mf_ss_vcemax_q6 MAX mfq_vce_q6 from=2e-08 to=4e-08
meas tran mf_ss_vcemin_q6 MIN mfq_vce_q6 from=2e-08 to=4e-08
let mfq_vbe_q6 = v(lo_n)-v(x2)
meas tran mf_su_vbemax_q6 MAX mfq_vbe_q6 from=0.0 to=2e-08
meas tran mf_su_vbemin_q6 MIN mfq_vbe_q6 from=0.0 to=2e-08
meas tran mf_ss_vbemax_q6 MAX mfq_vbe_q6 from=2e-08 to=4e-08
meas tran mf_ss_vbemin_q6 MIN mfq_vbe_q6 from=2e-08 to=4e-08
let mfq_ic_q6 = i(vic_q6)
meas tran mf_su_icmax_q6 MAX mfq_ic_q6 from=0.0 to=2e-08
meas tran mf_su_icmin_q6 MIN mfq_ic_q6 from=0.0 to=2e-08
meas tran mf_ss_icmax_q6 MAX mfq_ic_q6 from=2e-08 to=4e-08
meas tran mf_ss_icmin_q6 MIN mfq_ic_q6 from=2e-08 to=4e-08
meas tran mf_su_sinkmin_tail MIN v(tail) from=0.0 to=2e-08
meas tran mf_ss_sinkmin_tail MIN v(tail) from=2e-08 to=4e-08
print mf_su_vcemax_q1
print mf_su_vcemin_q1
print mf_ss_vcemax_q1
print mf_ss_vcemin_q1
print mf_su_vbemax_q1
print mf_su_vbemin_q1
print mf_ss_vbemax_q1
print mf_ss_vbemin_q1
print mf_su_icmax_q1
print mf_su_icmin_q1
print mf_ss_icmax_q1
print mf_ss_icmin_q1
print mf_su_vcemax_q2
print mf_su_vcemin_q2
print mf_ss_vcemax_q2
print mf_ss_vcemin_q2
print mf_su_vbemax_q2
print mf_su_vbemin_q2
print mf_ss_vbemax_q2
print mf_ss_vbemin_q2
print mf_su_icmax_q2
print mf_su_icmin_q2
print mf_ss_icmax_q2
print mf_ss_icmin_q2
print mf_su_vcemax_q3
print mf_su_vcemin_q3
print mf_ss_vcemax_q3
print mf_ss_vcemin_q3
print mf_su_vbemax_q3
print mf_su_vbemin_q3
print mf_ss_vbemax_q3
print mf_ss_vbemin_q3
print mf_su_icmax_q3
print mf_su_icmin_q3
print mf_ss_icmax_q3
print mf_ss_icmin_q3
print mf_su_vcemax_q4
print mf_su_vcemin_q4
print mf_ss_vcemax_q4
print mf_ss_vcemin_q4
print mf_su_vbemax_q4
print mf_su_vbemin_q4
print mf_ss_vbemax_q4
print mf_ss_vbemin_q4
print mf_su_icmax_q4
print mf_su_icmin_q4
print mf_ss_icmax_q4
print mf_ss_icmin_q4
print mf_su_vcemax_q5
print mf_su_vcemin_q5
print mf_ss_vcemax_q5
print mf_ss_vcemin_q5
print mf_su_vbemax_q5
print mf_su_vbemin_q5
print mf_ss_vbemax_q5
print mf_ss_vbemin_q5
print mf_su_icmax_q5
print mf_su_icmin_q5
print mf_ss_icmax_q5
print mf_ss_icmin_q5
print mf_su_vcemax_q6
print mf_su_vcemin_q6
print mf_ss_vcemax_q6
print mf_ss_vcemin_q6
print mf_su_vbemax_q6
print mf_su_vbemin_q6
print mf_ss_vbemax_q6
print mf_ss_vbemin_q6
print mf_su_icmax_q6
print mf_su_icmin_q6
print mf_ss_icmax_q6
print mf_ss_icmin_q6
print mf_su_sinkmin_tail
print mf_ss_sinkmin_tail
linearize
let mf_l = length(time)
let mfw = (time ge 1.99995e-08) * (time lt 3.99995e-08)
let mf_n = mean(mfw) * mf_l
let mfs = mf_l / mf_n
let mf_prail = mean(v(vdd) * (0 - i(vdd)) * mfw) * mfs
let mfph = 2 * pi * 20200000000.0 * (time - 2e-08)
let mf_lodiff_re = 2 * mean((v(lo_p)-v(lo_n)) * mfw * cos(mfph)) * mfs
let mf_lodiff_im = 2 * mean((v(lo_p)-v(lo_n)) * mfw * sin(mfph)) * mfs
let mfph = 2 * pi * 1000000000.0 * (time - 2e-08)
let mf_if_re = 2 * mean((v(if_out)) * mfw * cos(mfph)) * mfs
let mf_if_im = 2 * mean((v(if_out)) * mfw * sin(mfph)) * mfs
let mfph = 2 * pi * 20200000000.0 * (time - 2e-08)
let mf_loif_re = 2 * mean((v(if_out)) * mfw * cos(mfph)) * mfs
let mf_loif_im = 2 * mean((v(if_out)) * mfw * sin(mfph)) * mfs
let mfph = 2 * pi * 20200000000.0 * (time - 2e-08)
let mf_lorf_re = 2 * mean((v(rf_port)) * mfw * cos(mfph)) * mfs
let mf_lorf_im = 2 * mean((v(rf_port)) * mfw * sin(mfph)) * mfs
let mfph = 2 * pi * 950000000.0 * (time - 2e-08)
let mf_flifa_re = 2 * mean((v(if_out)) * mfw * cos(mfph)) * mfs
let mf_flifa_im = 2 * mean((v(if_out)) * mfw * sin(mfph)) * mfs
let mfph = 2 * pi * 1050000000.0 * (time - 2e-08)
let mf_flifb_re = 2 * mean((v(if_out)) * mfw * cos(mfph)) * mfs
let mf_flifb_im = 2 * mean((v(if_out)) * mfw * sin(mfph)) * mfs
let mfph = 2 * pi * 20250000000.0 * (time - 2e-08)
let mf_fllorf_re = 2 * mean((v(rf_port)) * mfw * cos(mfph)) * mfs
let mf_fllorf_im = 2 * mean((v(rf_port)) * mfw * sin(mfph)) * mfs
let mfph = 2 * pi * 20250000000.0 * (time - 2e-08)
let mf_flloif_re = 2 * mean((v(if_out)) * mfw * cos(mfph)) * mfs
let mf_flloif_im = 2 * mean((v(if_out)) * mfw * sin(mfph)) * mfs
print mf_l
print mf_n
print mf_prail
print mf_lodiff_re
print mf_lodiff_im
print mf_if_re
print mf_if_im
print mf_loif_re
print mf_loif_im
print mf_lorf_re
print mf_lorf_im
print mf_flifa_re
print mf_flifa_im
print mf_flifb_re
print mf_flifb_im
print mf_fllorf_re
print mf_fllorf_im
print mf_flloif_re
print mf_flloif_im
destroy all
echo "MFEND ls_f21p20_m27_rf66"
echo "MFRUN ls_f21p20_m24_rf60"
alterparam f1 = 21200000000.0
alterparam f2 = 21200000000.0
alterparam flo = 20200000000.0
alterparam vrf1 = 0.0006324555320336759
alterparam vrf2 = 0.0
alterparam vlo = 0.05643454052641856
reset
op
let mf_dcirail = 0 - i(vdd)
let mf_dc_vce_q1 = v(c_q1)-v(e_q1)
let mf_dc_vbe_q1 = v(b_q1)-v(e_q1)
let mf_dc_ic_q1 = i(vic_q1)
let mf_dc_vce_q2 = v(c_q2)-v(e_q2)
let mf_dc_vbe_q2 = v(b_q2)-v(e_q2)
let mf_dc_ic_q2 = i(vic_q2)
let mf_dc_vce_q3 = v(c_q3)-v(x1)
let mf_dc_vbe_q3 = v(lo_p)-v(x1)
let mf_dc_ic_q3 = i(vic_q3)
let mf_dc_vce_q4 = v(c_q4)-v(x1)
let mf_dc_vbe_q4 = v(lo_n)-v(x1)
let mf_dc_ic_q4 = i(vic_q4)
let mf_dc_vce_q5 = v(c_q5)-v(x2)
let mf_dc_vbe_q5 = v(lo_p)-v(x2)
let mf_dc_ic_q5 = i(vic_q5)
let mf_dc_vce_q6 = v(c_q6)-v(x2)
let mf_dc_vbe_q6 = v(lo_n)-v(x2)
let mf_dc_ic_q6 = i(vic_q6)
let mf_dc_sink_tail = v(tail)
print mf_dcirail
print mf_dc_vce_q1
print mf_dc_vbe_q1
print mf_dc_ic_q1
print mf_dc_vce_q2
print mf_dc_vbe_q2
print mf_dc_ic_q2
print mf_dc_vce_q3
print mf_dc_vbe_q3
print mf_dc_ic_q3
print mf_dc_vce_q4
print mf_dc_vbe_q4
print mf_dc_ic_q4
print mf_dc_vce_q5
print mf_dc_vbe_q5
print mf_dc_ic_q5
print mf_dc_vce_q6
print mf_dc_vbe_q6
print mf_dc_ic_q6
print mf_dc_sink_tail
tran 1e-12 4e-08 0 1e-12
let mfq_vce_q1 = v(c_q1)-v(e_q1)
meas tran mf_su_vcemax_q1 MAX mfq_vce_q1 from=0.0 to=2e-08
meas tran mf_su_vcemin_q1 MIN mfq_vce_q1 from=0.0 to=2e-08
meas tran mf_ss_vcemax_q1 MAX mfq_vce_q1 from=2e-08 to=4e-08
meas tran mf_ss_vcemin_q1 MIN mfq_vce_q1 from=2e-08 to=4e-08
let mfq_vbe_q1 = v(b_q1)-v(e_q1)
meas tran mf_su_vbemax_q1 MAX mfq_vbe_q1 from=0.0 to=2e-08
meas tran mf_su_vbemin_q1 MIN mfq_vbe_q1 from=0.0 to=2e-08
meas tran mf_ss_vbemax_q1 MAX mfq_vbe_q1 from=2e-08 to=4e-08
meas tran mf_ss_vbemin_q1 MIN mfq_vbe_q1 from=2e-08 to=4e-08
let mfq_ic_q1 = i(vic_q1)
meas tran mf_su_icmax_q1 MAX mfq_ic_q1 from=0.0 to=2e-08
meas tran mf_su_icmin_q1 MIN mfq_ic_q1 from=0.0 to=2e-08
meas tran mf_ss_icmax_q1 MAX mfq_ic_q1 from=2e-08 to=4e-08
meas tran mf_ss_icmin_q1 MIN mfq_ic_q1 from=2e-08 to=4e-08
let mfq_vce_q2 = v(c_q2)-v(e_q2)
meas tran mf_su_vcemax_q2 MAX mfq_vce_q2 from=0.0 to=2e-08
meas tran mf_su_vcemin_q2 MIN mfq_vce_q2 from=0.0 to=2e-08
meas tran mf_ss_vcemax_q2 MAX mfq_vce_q2 from=2e-08 to=4e-08
meas tran mf_ss_vcemin_q2 MIN mfq_vce_q2 from=2e-08 to=4e-08
let mfq_vbe_q2 = v(b_q2)-v(e_q2)
meas tran mf_su_vbemax_q2 MAX mfq_vbe_q2 from=0.0 to=2e-08
meas tran mf_su_vbemin_q2 MIN mfq_vbe_q2 from=0.0 to=2e-08
meas tran mf_ss_vbemax_q2 MAX mfq_vbe_q2 from=2e-08 to=4e-08
meas tran mf_ss_vbemin_q2 MIN mfq_vbe_q2 from=2e-08 to=4e-08
let mfq_ic_q2 = i(vic_q2)
meas tran mf_su_icmax_q2 MAX mfq_ic_q2 from=0.0 to=2e-08
meas tran mf_su_icmin_q2 MIN mfq_ic_q2 from=0.0 to=2e-08
meas tran mf_ss_icmax_q2 MAX mfq_ic_q2 from=2e-08 to=4e-08
meas tran mf_ss_icmin_q2 MIN mfq_ic_q2 from=2e-08 to=4e-08
let mfq_vce_q3 = v(c_q3)-v(x1)
meas tran mf_su_vcemax_q3 MAX mfq_vce_q3 from=0.0 to=2e-08
meas tran mf_su_vcemin_q3 MIN mfq_vce_q3 from=0.0 to=2e-08
meas tran mf_ss_vcemax_q3 MAX mfq_vce_q3 from=2e-08 to=4e-08
meas tran mf_ss_vcemin_q3 MIN mfq_vce_q3 from=2e-08 to=4e-08
let mfq_vbe_q3 = v(lo_p)-v(x1)
meas tran mf_su_vbemax_q3 MAX mfq_vbe_q3 from=0.0 to=2e-08
meas tran mf_su_vbemin_q3 MIN mfq_vbe_q3 from=0.0 to=2e-08
meas tran mf_ss_vbemax_q3 MAX mfq_vbe_q3 from=2e-08 to=4e-08
meas tran mf_ss_vbemin_q3 MIN mfq_vbe_q3 from=2e-08 to=4e-08
let mfq_ic_q3 = i(vic_q3)
meas tran mf_su_icmax_q3 MAX mfq_ic_q3 from=0.0 to=2e-08
meas tran mf_su_icmin_q3 MIN mfq_ic_q3 from=0.0 to=2e-08
meas tran mf_ss_icmax_q3 MAX mfq_ic_q3 from=2e-08 to=4e-08
meas tran mf_ss_icmin_q3 MIN mfq_ic_q3 from=2e-08 to=4e-08
let mfq_vce_q4 = v(c_q4)-v(x1)
meas tran mf_su_vcemax_q4 MAX mfq_vce_q4 from=0.0 to=2e-08
meas tran mf_su_vcemin_q4 MIN mfq_vce_q4 from=0.0 to=2e-08
meas tran mf_ss_vcemax_q4 MAX mfq_vce_q4 from=2e-08 to=4e-08
meas tran mf_ss_vcemin_q4 MIN mfq_vce_q4 from=2e-08 to=4e-08
let mfq_vbe_q4 = v(lo_n)-v(x1)
meas tran mf_su_vbemax_q4 MAX mfq_vbe_q4 from=0.0 to=2e-08
meas tran mf_su_vbemin_q4 MIN mfq_vbe_q4 from=0.0 to=2e-08
meas tran mf_ss_vbemax_q4 MAX mfq_vbe_q4 from=2e-08 to=4e-08
meas tran mf_ss_vbemin_q4 MIN mfq_vbe_q4 from=2e-08 to=4e-08
let mfq_ic_q4 = i(vic_q4)
meas tran mf_su_icmax_q4 MAX mfq_ic_q4 from=0.0 to=2e-08
meas tran mf_su_icmin_q4 MIN mfq_ic_q4 from=0.0 to=2e-08
meas tran mf_ss_icmax_q4 MAX mfq_ic_q4 from=2e-08 to=4e-08
meas tran mf_ss_icmin_q4 MIN mfq_ic_q4 from=2e-08 to=4e-08
let mfq_vce_q5 = v(c_q5)-v(x2)
meas tran mf_su_vcemax_q5 MAX mfq_vce_q5 from=0.0 to=2e-08
meas tran mf_su_vcemin_q5 MIN mfq_vce_q5 from=0.0 to=2e-08
meas tran mf_ss_vcemax_q5 MAX mfq_vce_q5 from=2e-08 to=4e-08
meas tran mf_ss_vcemin_q5 MIN mfq_vce_q5 from=2e-08 to=4e-08
let mfq_vbe_q5 = v(lo_p)-v(x2)
meas tran mf_su_vbemax_q5 MAX mfq_vbe_q5 from=0.0 to=2e-08
meas tran mf_su_vbemin_q5 MIN mfq_vbe_q5 from=0.0 to=2e-08
meas tran mf_ss_vbemax_q5 MAX mfq_vbe_q5 from=2e-08 to=4e-08
meas tran mf_ss_vbemin_q5 MIN mfq_vbe_q5 from=2e-08 to=4e-08
let mfq_ic_q5 = i(vic_q5)
meas tran mf_su_icmax_q5 MAX mfq_ic_q5 from=0.0 to=2e-08
meas tran mf_su_icmin_q5 MIN mfq_ic_q5 from=0.0 to=2e-08
meas tran mf_ss_icmax_q5 MAX mfq_ic_q5 from=2e-08 to=4e-08
meas tran mf_ss_icmin_q5 MIN mfq_ic_q5 from=2e-08 to=4e-08
let mfq_vce_q6 = v(c_q6)-v(x2)
meas tran mf_su_vcemax_q6 MAX mfq_vce_q6 from=0.0 to=2e-08
meas tran mf_su_vcemin_q6 MIN mfq_vce_q6 from=0.0 to=2e-08
meas tran mf_ss_vcemax_q6 MAX mfq_vce_q6 from=2e-08 to=4e-08
meas tran mf_ss_vcemin_q6 MIN mfq_vce_q6 from=2e-08 to=4e-08
let mfq_vbe_q6 = v(lo_n)-v(x2)
meas tran mf_su_vbemax_q6 MAX mfq_vbe_q6 from=0.0 to=2e-08
meas tran mf_su_vbemin_q6 MIN mfq_vbe_q6 from=0.0 to=2e-08
meas tran mf_ss_vbemax_q6 MAX mfq_vbe_q6 from=2e-08 to=4e-08
meas tran mf_ss_vbemin_q6 MIN mfq_vbe_q6 from=2e-08 to=4e-08
let mfq_ic_q6 = i(vic_q6)
meas tran mf_su_icmax_q6 MAX mfq_ic_q6 from=0.0 to=2e-08
meas tran mf_su_icmin_q6 MIN mfq_ic_q6 from=0.0 to=2e-08
meas tran mf_ss_icmax_q6 MAX mfq_ic_q6 from=2e-08 to=4e-08
meas tran mf_ss_icmin_q6 MIN mfq_ic_q6 from=2e-08 to=4e-08
meas tran mf_su_sinkmin_tail MIN v(tail) from=0.0 to=2e-08
meas tran mf_ss_sinkmin_tail MIN v(tail) from=2e-08 to=4e-08
print mf_su_vcemax_q1
print mf_su_vcemin_q1
print mf_ss_vcemax_q1
print mf_ss_vcemin_q1
print mf_su_vbemax_q1
print mf_su_vbemin_q1
print mf_ss_vbemax_q1
print mf_ss_vbemin_q1
print mf_su_icmax_q1
print mf_su_icmin_q1
print mf_ss_icmax_q1
print mf_ss_icmin_q1
print mf_su_vcemax_q2
print mf_su_vcemin_q2
print mf_ss_vcemax_q2
print mf_ss_vcemin_q2
print mf_su_vbemax_q2
print mf_su_vbemin_q2
print mf_ss_vbemax_q2
print mf_ss_vbemin_q2
print mf_su_icmax_q2
print mf_su_icmin_q2
print mf_ss_icmax_q2
print mf_ss_icmin_q2
print mf_su_vcemax_q3
print mf_su_vcemin_q3
print mf_ss_vcemax_q3
print mf_ss_vcemin_q3
print mf_su_vbemax_q3
print mf_su_vbemin_q3
print mf_ss_vbemax_q3
print mf_ss_vbemin_q3
print mf_su_icmax_q3
print mf_su_icmin_q3
print mf_ss_icmax_q3
print mf_ss_icmin_q3
print mf_su_vcemax_q4
print mf_su_vcemin_q4
print mf_ss_vcemax_q4
print mf_ss_vcemin_q4
print mf_su_vbemax_q4
print mf_su_vbemin_q4
print mf_ss_vbemax_q4
print mf_ss_vbemin_q4
print mf_su_icmax_q4
print mf_su_icmin_q4
print mf_ss_icmax_q4
print mf_ss_icmin_q4
print mf_su_vcemax_q5
print mf_su_vcemin_q5
print mf_ss_vcemax_q5
print mf_ss_vcemin_q5
print mf_su_vbemax_q5
print mf_su_vbemin_q5
print mf_ss_vbemax_q5
print mf_ss_vbemin_q5
print mf_su_icmax_q5
print mf_su_icmin_q5
print mf_ss_icmax_q5
print mf_ss_icmin_q5
print mf_su_vcemax_q6
print mf_su_vcemin_q6
print mf_ss_vcemax_q6
print mf_ss_vcemin_q6
print mf_su_vbemax_q6
print mf_su_vbemin_q6
print mf_ss_vbemax_q6
print mf_ss_vbemin_q6
print mf_su_icmax_q6
print mf_su_icmin_q6
print mf_ss_icmax_q6
print mf_ss_icmin_q6
print mf_su_sinkmin_tail
print mf_ss_sinkmin_tail
linearize
let mf_l = length(time)
let mfw = (time ge 1.99995e-08) * (time lt 3.99995e-08)
let mf_n = mean(mfw) * mf_l
let mfs = mf_l / mf_n
let mf_prail = mean(v(vdd) * (0 - i(vdd)) * mfw) * mfs
let mfph = 2 * pi * 20200000000.0 * (time - 2e-08)
let mf_lodiff_re = 2 * mean((v(lo_p)-v(lo_n)) * mfw * cos(mfph)) * mfs
let mf_lodiff_im = 2 * mean((v(lo_p)-v(lo_n)) * mfw * sin(mfph)) * mfs
let mfph = 2 * pi * 1000000000.0 * (time - 2e-08)
let mf_if_re = 2 * mean((v(if_out)) * mfw * cos(mfph)) * mfs
let mf_if_im = 2 * mean((v(if_out)) * mfw * sin(mfph)) * mfs
let mfph = 2 * pi * 20200000000.0 * (time - 2e-08)
let mf_loif_re = 2 * mean((v(if_out)) * mfw * cos(mfph)) * mfs
let mf_loif_im = 2 * mean((v(if_out)) * mfw * sin(mfph)) * mfs
let mfph = 2 * pi * 20200000000.0 * (time - 2e-08)
let mf_lorf_re = 2 * mean((v(rf_port)) * mfw * cos(mfph)) * mfs
let mf_lorf_im = 2 * mean((v(rf_port)) * mfw * sin(mfph)) * mfs
let mfph = 2 * pi * 950000000.0 * (time - 2e-08)
let mf_flifa_re = 2 * mean((v(if_out)) * mfw * cos(mfph)) * mfs
let mf_flifa_im = 2 * mean((v(if_out)) * mfw * sin(mfph)) * mfs
let mfph = 2 * pi * 1050000000.0 * (time - 2e-08)
let mf_flifb_re = 2 * mean((v(if_out)) * mfw * cos(mfph)) * mfs
let mf_flifb_im = 2 * mean((v(if_out)) * mfw * sin(mfph)) * mfs
let mfph = 2 * pi * 20250000000.0 * (time - 2e-08)
let mf_fllorf_re = 2 * mean((v(rf_port)) * mfw * cos(mfph)) * mfs
let mf_fllorf_im = 2 * mean((v(rf_port)) * mfw * sin(mfph)) * mfs
let mfph = 2 * pi * 20250000000.0 * (time - 2e-08)
let mf_flloif_re = 2 * mean((v(if_out)) * mfw * cos(mfph)) * mfs
let mf_flloif_im = 2 * mean((v(if_out)) * mfw * sin(mfph)) * mfs
print mf_l
print mf_n
print mf_prail
print mf_lodiff_re
print mf_lodiff_im
print mf_if_re
print mf_if_im
print mf_loif_re
print mf_loif_im
print mf_lorf_re
print mf_lorf_im
print mf_flifa_re
print mf_flifa_im
print mf_flifb_re
print mf_flifb_im
print mf_fllorf_re
print mf_fllorf_im
print mf_flloif_re
print mf_flloif_im
destroy all
echo "MFEND ls_f21p20_m24_rf60"
echo "MFRUN ls_f21p20_m24_rf66"
alterparam f1 = 21200000000.0
alterparam f2 = 21200000000.0
alterparam flo = 20200000000.0
alterparam vrf1 = 0.00031697863849222284
alterparam vrf2 = 0.0
alterparam vlo = 0.05643454052641856
reset
op
let mf_dcirail = 0 - i(vdd)
let mf_dc_vce_q1 = v(c_q1)-v(e_q1)
let mf_dc_vbe_q1 = v(b_q1)-v(e_q1)
let mf_dc_ic_q1 = i(vic_q1)
let mf_dc_vce_q2 = v(c_q2)-v(e_q2)
let mf_dc_vbe_q2 = v(b_q2)-v(e_q2)
let mf_dc_ic_q2 = i(vic_q2)
let mf_dc_vce_q3 = v(c_q3)-v(x1)
let mf_dc_vbe_q3 = v(lo_p)-v(x1)
let mf_dc_ic_q3 = i(vic_q3)
let mf_dc_vce_q4 = v(c_q4)-v(x1)
let mf_dc_vbe_q4 = v(lo_n)-v(x1)
let mf_dc_ic_q4 = i(vic_q4)
let mf_dc_vce_q5 = v(c_q5)-v(x2)
let mf_dc_vbe_q5 = v(lo_p)-v(x2)
let mf_dc_ic_q5 = i(vic_q5)
let mf_dc_vce_q6 = v(c_q6)-v(x2)
let mf_dc_vbe_q6 = v(lo_n)-v(x2)
let mf_dc_ic_q6 = i(vic_q6)
let mf_dc_sink_tail = v(tail)
print mf_dcirail
print mf_dc_vce_q1
print mf_dc_vbe_q1
print mf_dc_ic_q1
print mf_dc_vce_q2
print mf_dc_vbe_q2
print mf_dc_ic_q2
print mf_dc_vce_q3
print mf_dc_vbe_q3
print mf_dc_ic_q3
print mf_dc_vce_q4
print mf_dc_vbe_q4
print mf_dc_ic_q4
print mf_dc_vce_q5
print mf_dc_vbe_q5
print mf_dc_ic_q5
print mf_dc_vce_q6
print mf_dc_vbe_q6
print mf_dc_ic_q6
print mf_dc_sink_tail
tran 1e-12 4e-08 0 1e-12
let mfq_vce_q1 = v(c_q1)-v(e_q1)
meas tran mf_su_vcemax_q1 MAX mfq_vce_q1 from=0.0 to=2e-08
meas tran mf_su_vcemin_q1 MIN mfq_vce_q1 from=0.0 to=2e-08
meas tran mf_ss_vcemax_q1 MAX mfq_vce_q1 from=2e-08 to=4e-08
meas tran mf_ss_vcemin_q1 MIN mfq_vce_q1 from=2e-08 to=4e-08
let mfq_vbe_q1 = v(b_q1)-v(e_q1)
meas tran mf_su_vbemax_q1 MAX mfq_vbe_q1 from=0.0 to=2e-08
meas tran mf_su_vbemin_q1 MIN mfq_vbe_q1 from=0.0 to=2e-08
meas tran mf_ss_vbemax_q1 MAX mfq_vbe_q1 from=2e-08 to=4e-08
meas tran mf_ss_vbemin_q1 MIN mfq_vbe_q1 from=2e-08 to=4e-08
let mfq_ic_q1 = i(vic_q1)
meas tran mf_su_icmax_q1 MAX mfq_ic_q1 from=0.0 to=2e-08
meas tran mf_su_icmin_q1 MIN mfq_ic_q1 from=0.0 to=2e-08
meas tran mf_ss_icmax_q1 MAX mfq_ic_q1 from=2e-08 to=4e-08
meas tran mf_ss_icmin_q1 MIN mfq_ic_q1 from=2e-08 to=4e-08
let mfq_vce_q2 = v(c_q2)-v(e_q2)
meas tran mf_su_vcemax_q2 MAX mfq_vce_q2 from=0.0 to=2e-08
meas tran mf_su_vcemin_q2 MIN mfq_vce_q2 from=0.0 to=2e-08
meas tran mf_ss_vcemax_q2 MAX mfq_vce_q2 from=2e-08 to=4e-08
meas tran mf_ss_vcemin_q2 MIN mfq_vce_q2 from=2e-08 to=4e-08
let mfq_vbe_q2 = v(b_q2)-v(e_q2)
meas tran mf_su_vbemax_q2 MAX mfq_vbe_q2 from=0.0 to=2e-08
meas tran mf_su_vbemin_q2 MIN mfq_vbe_q2 from=0.0 to=2e-08
meas tran mf_ss_vbemax_q2 MAX mfq_vbe_q2 from=2e-08 to=4e-08
meas tran mf_ss_vbemin_q2 MIN mfq_vbe_q2 from=2e-08 to=4e-08
let mfq_ic_q2 = i(vic_q2)
meas tran mf_su_icmax_q2 MAX mfq_ic_q2 from=0.0 to=2e-08
meas tran mf_su_icmin_q2 MIN mfq_ic_q2 from=0.0 to=2e-08
meas tran mf_ss_icmax_q2 MAX mfq_ic_q2 from=2e-08 to=4e-08
meas tran mf_ss_icmin_q2 MIN mfq_ic_q2 from=2e-08 to=4e-08
let mfq_vce_q3 = v(c_q3)-v(x1)
meas tran mf_su_vcemax_q3 MAX mfq_vce_q3 from=0.0 to=2e-08
meas tran mf_su_vcemin_q3 MIN mfq_vce_q3 from=0.0 to=2e-08
meas tran mf_ss_vcemax_q3 MAX mfq_vce_q3 from=2e-08 to=4e-08
meas tran mf_ss_vcemin_q3 MIN mfq_vce_q3 from=2e-08 to=4e-08
let mfq_vbe_q3 = v(lo_p)-v(x1)
meas tran mf_su_vbemax_q3 MAX mfq_vbe_q3 from=0.0 to=2e-08
meas tran mf_su_vbemin_q3 MIN mfq_vbe_q3 from=0.0 to=2e-08
meas tran mf_ss_vbemax_q3 MAX mfq_vbe_q3 from=2e-08 to=4e-08
meas tran mf_ss_vbemin_q3 MIN mfq_vbe_q3 from=2e-08 to=4e-08
let mfq_ic_q3 = i(vic_q3)
meas tran mf_su_icmax_q3 MAX mfq_ic_q3 from=0.0 to=2e-08
meas tran mf_su_icmin_q3 MIN mfq_ic_q3 from=0.0 to=2e-08
meas tran mf_ss_icmax_q3 MAX mfq_ic_q3 from=2e-08 to=4e-08
meas tran mf_ss_icmin_q3 MIN mfq_ic_q3 from=2e-08 to=4e-08
let mfq_vce_q4 = v(c_q4)-v(x1)
meas tran mf_su_vcemax_q4 MAX mfq_vce_q4 from=0.0 to=2e-08
meas tran mf_su_vcemin_q4 MIN mfq_vce_q4 from=0.0 to=2e-08
meas tran mf_ss_vcemax_q4 MAX mfq_vce_q4 from=2e-08 to=4e-08
meas tran mf_ss_vcemin_q4 MIN mfq_vce_q4 from=2e-08 to=4e-08
let mfq_vbe_q4 = v(lo_n)-v(x1)
meas tran mf_su_vbemax_q4 MAX mfq_vbe_q4 from=0.0 to=2e-08
meas tran mf_su_vbemin_q4 MIN mfq_vbe_q4 from=0.0 to=2e-08
meas tran mf_ss_vbemax_q4 MAX mfq_vbe_q4 from=2e-08 to=4e-08
meas tran mf_ss_vbemin_q4 MIN mfq_vbe_q4 from=2e-08 to=4e-08
let mfq_ic_q4 = i(vic_q4)
meas tran mf_su_icmax_q4 MAX mfq_ic_q4 from=0.0 to=2e-08
meas tran mf_su_icmin_q4 MIN mfq_ic_q4 from=0.0 to=2e-08
meas tran mf_ss_icmax_q4 MAX mfq_ic_q4 from=2e-08 to=4e-08
meas tran mf_ss_icmin_q4 MIN mfq_ic_q4 from=2e-08 to=4e-08
let mfq_vce_q5 = v(c_q5)-v(x2)
meas tran mf_su_vcemax_q5 MAX mfq_vce_q5 from=0.0 to=2e-08
meas tran mf_su_vcemin_q5 MIN mfq_vce_q5 from=0.0 to=2e-08
meas tran mf_ss_vcemax_q5 MAX mfq_vce_q5 from=2e-08 to=4e-08
meas tran mf_ss_vcemin_q5 MIN mfq_vce_q5 from=2e-08 to=4e-08
let mfq_vbe_q5 = v(lo_p)-v(x2)
meas tran mf_su_vbemax_q5 MAX mfq_vbe_q5 from=0.0 to=2e-08
meas tran mf_su_vbemin_q5 MIN mfq_vbe_q5 from=0.0 to=2e-08
meas tran mf_ss_vbemax_q5 MAX mfq_vbe_q5 from=2e-08 to=4e-08
meas tran mf_ss_vbemin_q5 MIN mfq_vbe_q5 from=2e-08 to=4e-08
let mfq_ic_q5 = i(vic_q5)
meas tran mf_su_icmax_q5 MAX mfq_ic_q5 from=0.0 to=2e-08
meas tran mf_su_icmin_q5 MIN mfq_ic_q5 from=0.0 to=2e-08
meas tran mf_ss_icmax_q5 MAX mfq_ic_q5 from=2e-08 to=4e-08
meas tran mf_ss_icmin_q5 MIN mfq_ic_q5 from=2e-08 to=4e-08
let mfq_vce_q6 = v(c_q6)-v(x2)
meas tran mf_su_vcemax_q6 MAX mfq_vce_q6 from=0.0 to=2e-08
meas tran mf_su_vcemin_q6 MIN mfq_vce_q6 from=0.0 to=2e-08
meas tran mf_ss_vcemax_q6 MAX mfq_vce_q6 from=2e-08 to=4e-08
meas tran mf_ss_vcemin_q6 MIN mfq_vce_q6 from=2e-08 to=4e-08
let mfq_vbe_q6 = v(lo_n)-v(x2)
meas tran mf_su_vbemax_q6 MAX mfq_vbe_q6 from=0.0 to=2e-08
meas tran mf_su_vbemin_q6 MIN mfq_vbe_q6 from=0.0 to=2e-08
meas tran mf_ss_vbemax_q6 MAX mfq_vbe_q6 from=2e-08 to=4e-08
meas tran mf_ss_vbemin_q6 MIN mfq_vbe_q6 from=2e-08 to=4e-08
let mfq_ic_q6 = i(vic_q6)
meas tran mf_su_icmax_q6 MAX mfq_ic_q6 from=0.0 to=2e-08
meas tran mf_su_icmin_q6 MIN mfq_ic_q6 from=0.0 to=2e-08
meas tran mf_ss_icmax_q6 MAX mfq_ic_q6 from=2e-08 to=4e-08
meas tran mf_ss_icmin_q6 MIN mfq_ic_q6 from=2e-08 to=4e-08
meas tran mf_su_sinkmin_tail MIN v(tail) from=0.0 to=2e-08
meas tran mf_ss_sinkmin_tail MIN v(tail) from=2e-08 to=4e-08
print mf_su_vcemax_q1
print mf_su_vcemin_q1
print mf_ss_vcemax_q1
print mf_ss_vcemin_q1
print mf_su_vbemax_q1
print mf_su_vbemin_q1
print mf_ss_vbemax_q1
print mf_ss_vbemin_q1
print mf_su_icmax_q1
print mf_su_icmin_q1
print mf_ss_icmax_q1
print mf_ss_icmin_q1
print mf_su_vcemax_q2
print mf_su_vcemin_q2
print mf_ss_vcemax_q2
print mf_ss_vcemin_q2
print mf_su_vbemax_q2
print mf_su_vbemin_q2
print mf_ss_vbemax_q2
print mf_ss_vbemin_q2
print mf_su_icmax_q2
print mf_su_icmin_q2
print mf_ss_icmax_q2
print mf_ss_icmin_q2
print mf_su_vcemax_q3
print mf_su_vcemin_q3
print mf_ss_vcemax_q3
print mf_ss_vcemin_q3
print mf_su_vbemax_q3
print mf_su_vbemin_q3
print mf_ss_vbemax_q3
print mf_ss_vbemin_q3
print mf_su_icmax_q3
print mf_su_icmin_q3
print mf_ss_icmax_q3
print mf_ss_icmin_q3
print mf_su_vcemax_q4
print mf_su_vcemin_q4
print mf_ss_vcemax_q4
print mf_ss_vcemin_q4
print mf_su_vbemax_q4
print mf_su_vbemin_q4
print mf_ss_vbemax_q4
print mf_ss_vbemin_q4
print mf_su_icmax_q4
print mf_su_icmin_q4
print mf_ss_icmax_q4
print mf_ss_icmin_q4
print mf_su_vcemax_q5
print mf_su_vcemin_q5
print mf_ss_vcemax_q5
print mf_ss_vcemin_q5
print mf_su_vbemax_q5
print mf_su_vbemin_q5
print mf_ss_vbemax_q5
print mf_ss_vbemin_q5
print mf_su_icmax_q5
print mf_su_icmin_q5
print mf_ss_icmax_q5
print mf_ss_icmin_q5
print mf_su_vcemax_q6
print mf_su_vcemin_q6
print mf_ss_vcemax_q6
print mf_ss_vcemin_q6
print mf_su_vbemax_q6
print mf_su_vbemin_q6
print mf_ss_vbemax_q6
print mf_ss_vbemin_q6
print mf_su_icmax_q6
print mf_su_icmin_q6
print mf_ss_icmax_q6
print mf_ss_icmin_q6
print mf_su_sinkmin_tail
print mf_ss_sinkmin_tail
linearize
let mf_l = length(time)
let mfw = (time ge 1.99995e-08) * (time lt 3.99995e-08)
let mf_n = mean(mfw) * mf_l
let mfs = mf_l / mf_n
let mf_prail = mean(v(vdd) * (0 - i(vdd)) * mfw) * mfs
let mfph = 2 * pi * 20200000000.0 * (time - 2e-08)
let mf_lodiff_re = 2 * mean((v(lo_p)-v(lo_n)) * mfw * cos(mfph)) * mfs
let mf_lodiff_im = 2 * mean((v(lo_p)-v(lo_n)) * mfw * sin(mfph)) * mfs
let mfph = 2 * pi * 1000000000.0 * (time - 2e-08)
let mf_if_re = 2 * mean((v(if_out)) * mfw * cos(mfph)) * mfs
let mf_if_im = 2 * mean((v(if_out)) * mfw * sin(mfph)) * mfs
let mfph = 2 * pi * 20200000000.0 * (time - 2e-08)
let mf_loif_re = 2 * mean((v(if_out)) * mfw * cos(mfph)) * mfs
let mf_loif_im = 2 * mean((v(if_out)) * mfw * sin(mfph)) * mfs
let mfph = 2 * pi * 20200000000.0 * (time - 2e-08)
let mf_lorf_re = 2 * mean((v(rf_port)) * mfw * cos(mfph)) * mfs
let mf_lorf_im = 2 * mean((v(rf_port)) * mfw * sin(mfph)) * mfs
let mfph = 2 * pi * 950000000.0 * (time - 2e-08)
let mf_flifa_re = 2 * mean((v(if_out)) * mfw * cos(mfph)) * mfs
let mf_flifa_im = 2 * mean((v(if_out)) * mfw * sin(mfph)) * mfs
let mfph = 2 * pi * 1050000000.0 * (time - 2e-08)
let mf_flifb_re = 2 * mean((v(if_out)) * mfw * cos(mfph)) * mfs
let mf_flifb_im = 2 * mean((v(if_out)) * mfw * sin(mfph)) * mfs
let mfph = 2 * pi * 20250000000.0 * (time - 2e-08)
let mf_fllorf_re = 2 * mean((v(rf_port)) * mfw * cos(mfph)) * mfs
let mf_fllorf_im = 2 * mean((v(rf_port)) * mfw * sin(mfph)) * mfs
let mfph = 2 * pi * 20250000000.0 * (time - 2e-08)
let mf_flloif_re = 2 * mean((v(if_out)) * mfw * cos(mfph)) * mfs
let mf_flloif_im = 2 * mean((v(if_out)) * mfw * sin(mfph)) * mfs
print mf_l
print mf_n
print mf_prail
print mf_lodiff_re
print mf_lodiff_im
print mf_if_re
print mf_if_im
print mf_loif_re
print mf_loif_im
print mf_lorf_re
print mf_lorf_im
print mf_flifa_re
print mf_flifa_im
print mf_flifb_re
print mf_flifb_im
print mf_fllorf_re
print mf_fllorf_im
print mf_flloif_re
print mf_flloif_im
destroy all
echo "MFEND ls_f21p20_m24_rf66"
echo "MFRUN ls_f21p20_m21_rf60"
alterparam f1 = 21200000000.0
alterparam f2 = 21200000000.0
alterparam flo = 20200000000.0
alterparam vrf1 = 0.0006324555320336759
alterparam vrf2 = 0.0
alterparam vlo = 0.07971590730710057
reset
op
let mf_dcirail = 0 - i(vdd)
let mf_dc_vce_q1 = v(c_q1)-v(e_q1)
let mf_dc_vbe_q1 = v(b_q1)-v(e_q1)
let mf_dc_ic_q1 = i(vic_q1)
let mf_dc_vce_q2 = v(c_q2)-v(e_q2)
let mf_dc_vbe_q2 = v(b_q2)-v(e_q2)
let mf_dc_ic_q2 = i(vic_q2)
let mf_dc_vce_q3 = v(c_q3)-v(x1)
let mf_dc_vbe_q3 = v(lo_p)-v(x1)
let mf_dc_ic_q3 = i(vic_q3)
let mf_dc_vce_q4 = v(c_q4)-v(x1)
let mf_dc_vbe_q4 = v(lo_n)-v(x1)
let mf_dc_ic_q4 = i(vic_q4)
let mf_dc_vce_q5 = v(c_q5)-v(x2)
let mf_dc_vbe_q5 = v(lo_p)-v(x2)
let mf_dc_ic_q5 = i(vic_q5)
let mf_dc_vce_q6 = v(c_q6)-v(x2)
let mf_dc_vbe_q6 = v(lo_n)-v(x2)
let mf_dc_ic_q6 = i(vic_q6)
let mf_dc_sink_tail = v(tail)
print mf_dcirail
print mf_dc_vce_q1
print mf_dc_vbe_q1
print mf_dc_ic_q1
print mf_dc_vce_q2
print mf_dc_vbe_q2
print mf_dc_ic_q2
print mf_dc_vce_q3
print mf_dc_vbe_q3
print mf_dc_ic_q3
print mf_dc_vce_q4
print mf_dc_vbe_q4
print mf_dc_ic_q4
print mf_dc_vce_q5
print mf_dc_vbe_q5
print mf_dc_ic_q5
print mf_dc_vce_q6
print mf_dc_vbe_q6
print mf_dc_ic_q6
print mf_dc_sink_tail
tran 1e-12 4e-08 0 1e-12
let mfq_vce_q1 = v(c_q1)-v(e_q1)
meas tran mf_su_vcemax_q1 MAX mfq_vce_q1 from=0.0 to=2e-08
meas tran mf_su_vcemin_q1 MIN mfq_vce_q1 from=0.0 to=2e-08
meas tran mf_ss_vcemax_q1 MAX mfq_vce_q1 from=2e-08 to=4e-08
meas tran mf_ss_vcemin_q1 MIN mfq_vce_q1 from=2e-08 to=4e-08
let mfq_vbe_q1 = v(b_q1)-v(e_q1)
meas tran mf_su_vbemax_q1 MAX mfq_vbe_q1 from=0.0 to=2e-08
meas tran mf_su_vbemin_q1 MIN mfq_vbe_q1 from=0.0 to=2e-08
meas tran mf_ss_vbemax_q1 MAX mfq_vbe_q1 from=2e-08 to=4e-08
meas tran mf_ss_vbemin_q1 MIN mfq_vbe_q1 from=2e-08 to=4e-08
let mfq_ic_q1 = i(vic_q1)
meas tran mf_su_icmax_q1 MAX mfq_ic_q1 from=0.0 to=2e-08
meas tran mf_su_icmin_q1 MIN mfq_ic_q1 from=0.0 to=2e-08
meas tran mf_ss_icmax_q1 MAX mfq_ic_q1 from=2e-08 to=4e-08
meas tran mf_ss_icmin_q1 MIN mfq_ic_q1 from=2e-08 to=4e-08
let mfq_vce_q2 = v(c_q2)-v(e_q2)
meas tran mf_su_vcemax_q2 MAX mfq_vce_q2 from=0.0 to=2e-08
meas tran mf_su_vcemin_q2 MIN mfq_vce_q2 from=0.0 to=2e-08
meas tran mf_ss_vcemax_q2 MAX mfq_vce_q2 from=2e-08 to=4e-08
meas tran mf_ss_vcemin_q2 MIN mfq_vce_q2 from=2e-08 to=4e-08
let mfq_vbe_q2 = v(b_q2)-v(e_q2)
meas tran mf_su_vbemax_q2 MAX mfq_vbe_q2 from=0.0 to=2e-08
meas tran mf_su_vbemin_q2 MIN mfq_vbe_q2 from=0.0 to=2e-08
meas tran mf_ss_vbemax_q2 MAX mfq_vbe_q2 from=2e-08 to=4e-08
meas tran mf_ss_vbemin_q2 MIN mfq_vbe_q2 from=2e-08 to=4e-08
let mfq_ic_q2 = i(vic_q2)
meas tran mf_su_icmax_q2 MAX mfq_ic_q2 from=0.0 to=2e-08
meas tran mf_su_icmin_q2 MIN mfq_ic_q2 from=0.0 to=2e-08
meas tran mf_ss_icmax_q2 MAX mfq_ic_q2 from=2e-08 to=4e-08
meas tran mf_ss_icmin_q2 MIN mfq_ic_q2 from=2e-08 to=4e-08
let mfq_vce_q3 = v(c_q3)-v(x1)
meas tran mf_su_vcemax_q3 MAX mfq_vce_q3 from=0.0 to=2e-08
meas tran mf_su_vcemin_q3 MIN mfq_vce_q3 from=0.0 to=2e-08
meas tran mf_ss_vcemax_q3 MAX mfq_vce_q3 from=2e-08 to=4e-08
meas tran mf_ss_vcemin_q3 MIN mfq_vce_q3 from=2e-08 to=4e-08
let mfq_vbe_q3 = v(lo_p)-v(x1)
meas tran mf_su_vbemax_q3 MAX mfq_vbe_q3 from=0.0 to=2e-08
meas tran mf_su_vbemin_q3 MIN mfq_vbe_q3 from=0.0 to=2e-08
meas tran mf_ss_vbemax_q3 MAX mfq_vbe_q3 from=2e-08 to=4e-08
meas tran mf_ss_vbemin_q3 MIN mfq_vbe_q3 from=2e-08 to=4e-08
let mfq_ic_q3 = i(vic_q3)
meas tran mf_su_icmax_q3 MAX mfq_ic_q3 from=0.0 to=2e-08
meas tran mf_su_icmin_q3 MIN mfq_ic_q3 from=0.0 to=2e-08
meas tran mf_ss_icmax_q3 MAX mfq_ic_q3 from=2e-08 to=4e-08
meas tran mf_ss_icmin_q3 MIN mfq_ic_q3 from=2e-08 to=4e-08
let mfq_vce_q4 = v(c_q4)-v(x1)
meas tran mf_su_vcemax_q4 MAX mfq_vce_q4 from=0.0 to=2e-08
meas tran mf_su_vcemin_q4 MIN mfq_vce_q4 from=0.0 to=2e-08
meas tran mf_ss_vcemax_q4 MAX mfq_vce_q4 from=2e-08 to=4e-08
meas tran mf_ss_vcemin_q4 MIN mfq_vce_q4 from=2e-08 to=4e-08
let mfq_vbe_q4 = v(lo_n)-v(x1)
meas tran mf_su_vbemax_q4 MAX mfq_vbe_q4 from=0.0 to=2e-08
meas tran mf_su_vbemin_q4 MIN mfq_vbe_q4 from=0.0 to=2e-08
meas tran mf_ss_vbemax_q4 MAX mfq_vbe_q4 from=2e-08 to=4e-08
meas tran mf_ss_vbemin_q4 MIN mfq_vbe_q4 from=2e-08 to=4e-08
let mfq_ic_q4 = i(vic_q4)
meas tran mf_su_icmax_q4 MAX mfq_ic_q4 from=0.0 to=2e-08
meas tran mf_su_icmin_q4 MIN mfq_ic_q4 from=0.0 to=2e-08
meas tran mf_ss_icmax_q4 MAX mfq_ic_q4 from=2e-08 to=4e-08
meas tran mf_ss_icmin_q4 MIN mfq_ic_q4 from=2e-08 to=4e-08
let mfq_vce_q5 = v(c_q5)-v(x2)
meas tran mf_su_vcemax_q5 MAX mfq_vce_q5 from=0.0 to=2e-08
meas tran mf_su_vcemin_q5 MIN mfq_vce_q5 from=0.0 to=2e-08
meas tran mf_ss_vcemax_q5 MAX mfq_vce_q5 from=2e-08 to=4e-08
meas tran mf_ss_vcemin_q5 MIN mfq_vce_q5 from=2e-08 to=4e-08
let mfq_vbe_q5 = v(lo_p)-v(x2)
meas tran mf_su_vbemax_q5 MAX mfq_vbe_q5 from=0.0 to=2e-08
meas tran mf_su_vbemin_q5 MIN mfq_vbe_q5 from=0.0 to=2e-08
meas tran mf_ss_vbemax_q5 MAX mfq_vbe_q5 from=2e-08 to=4e-08
meas tran mf_ss_vbemin_q5 MIN mfq_vbe_q5 from=2e-08 to=4e-08
let mfq_ic_q5 = i(vic_q5)
meas tran mf_su_icmax_q5 MAX mfq_ic_q5 from=0.0 to=2e-08
meas tran mf_su_icmin_q5 MIN mfq_ic_q5 from=0.0 to=2e-08
meas tran mf_ss_icmax_q5 MAX mfq_ic_q5 from=2e-08 to=4e-08
meas tran mf_ss_icmin_q5 MIN mfq_ic_q5 from=2e-08 to=4e-08
let mfq_vce_q6 = v(c_q6)-v(x2)
meas tran mf_su_vcemax_q6 MAX mfq_vce_q6 from=0.0 to=2e-08
meas tran mf_su_vcemin_q6 MIN mfq_vce_q6 from=0.0 to=2e-08
meas tran mf_ss_vcemax_q6 MAX mfq_vce_q6 from=2e-08 to=4e-08
meas tran mf_ss_vcemin_q6 MIN mfq_vce_q6 from=2e-08 to=4e-08
let mfq_vbe_q6 = v(lo_n)-v(x2)
meas tran mf_su_vbemax_q6 MAX mfq_vbe_q6 from=0.0 to=2e-08
meas tran mf_su_vbemin_q6 MIN mfq_vbe_q6 from=0.0 to=2e-08
meas tran mf_ss_vbemax_q6 MAX mfq_vbe_q6 from=2e-08 to=4e-08
meas tran mf_ss_vbemin_q6 MIN mfq_vbe_q6 from=2e-08 to=4e-08
let mfq_ic_q6 = i(vic_q6)
meas tran mf_su_icmax_q6 MAX mfq_ic_q6 from=0.0 to=2e-08
meas tran mf_su_icmin_q6 MIN mfq_ic_q6 from=0.0 to=2e-08
meas tran mf_ss_icmax_q6 MAX mfq_ic_q6 from=2e-08 to=4e-08
meas tran mf_ss_icmin_q6 MIN mfq_ic_q6 from=2e-08 to=4e-08
meas tran mf_su_sinkmin_tail MIN v(tail) from=0.0 to=2e-08
meas tran mf_ss_sinkmin_tail MIN v(tail) from=2e-08 to=4e-08
print mf_su_vcemax_q1
print mf_su_vcemin_q1
print mf_ss_vcemax_q1
print mf_ss_vcemin_q1
print mf_su_vbemax_q1
print mf_su_vbemin_q1
print mf_ss_vbemax_q1
print mf_ss_vbemin_q1
print mf_su_icmax_q1
print mf_su_icmin_q1
print mf_ss_icmax_q1
print mf_ss_icmin_q1
print mf_su_vcemax_q2
print mf_su_vcemin_q2
print mf_ss_vcemax_q2
print mf_ss_vcemin_q2
print mf_su_vbemax_q2
print mf_su_vbemin_q2
print mf_ss_vbemax_q2
print mf_ss_vbemin_q2
print mf_su_icmax_q2
print mf_su_icmin_q2
print mf_ss_icmax_q2
print mf_ss_icmin_q2
print mf_su_vcemax_q3
print mf_su_vcemin_q3
print mf_ss_vcemax_q3
print mf_ss_vcemin_q3
print mf_su_vbemax_q3
print mf_su_vbemin_q3
print mf_ss_vbemax_q3
print mf_ss_vbemin_q3
print mf_su_icmax_q3
print mf_su_icmin_q3
print mf_ss_icmax_q3
print mf_ss_icmin_q3
print mf_su_vcemax_q4
print mf_su_vcemin_q4
print mf_ss_vcemax_q4
print mf_ss_vcemin_q4
print mf_su_vbemax_q4
print mf_su_vbemin_q4
print mf_ss_vbemax_q4
print mf_ss_vbemin_q4
print mf_su_icmax_q4
print mf_su_icmin_q4
print mf_ss_icmax_q4
print mf_ss_icmin_q4
print mf_su_vcemax_q5
print mf_su_vcemin_q5
print mf_ss_vcemax_q5
print mf_ss_vcemin_q5
print mf_su_vbemax_q5
print mf_su_vbemin_q5
print mf_ss_vbemax_q5
print mf_ss_vbemin_q5
print mf_su_icmax_q5
print mf_su_icmin_q5
print mf_ss_icmax_q5
print mf_ss_icmin_q5
print mf_su_vcemax_q6
print mf_su_vcemin_q6
print mf_ss_vcemax_q6
print mf_ss_vcemin_q6
print mf_su_vbemax_q6
print mf_su_vbemin_q6
print mf_ss_vbemax_q6
print mf_ss_vbemin_q6
print mf_su_icmax_q6
print mf_su_icmin_q6
print mf_ss_icmax_q6
print mf_ss_icmin_q6
print mf_su_sinkmin_tail
print mf_ss_sinkmin_tail
linearize
let mf_l = length(time)
let mfw = (time ge 1.99995e-08) * (time lt 3.99995e-08)
let mf_n = mean(mfw) * mf_l
let mfs = mf_l / mf_n
let mf_prail = mean(v(vdd) * (0 - i(vdd)) * mfw) * mfs
let mfph = 2 * pi * 20200000000.0 * (time - 2e-08)
let mf_lodiff_re = 2 * mean((v(lo_p)-v(lo_n)) * mfw * cos(mfph)) * mfs
let mf_lodiff_im = 2 * mean((v(lo_p)-v(lo_n)) * mfw * sin(mfph)) * mfs
let mfph = 2 * pi * 1000000000.0 * (time - 2e-08)
let mf_if_re = 2 * mean((v(if_out)) * mfw * cos(mfph)) * mfs
let mf_if_im = 2 * mean((v(if_out)) * mfw * sin(mfph)) * mfs
let mfph = 2 * pi * 20200000000.0 * (time - 2e-08)
let mf_loif_re = 2 * mean((v(if_out)) * mfw * cos(mfph)) * mfs
let mf_loif_im = 2 * mean((v(if_out)) * mfw * sin(mfph)) * mfs
let mfph = 2 * pi * 20200000000.0 * (time - 2e-08)
let mf_lorf_re = 2 * mean((v(rf_port)) * mfw * cos(mfph)) * mfs
let mf_lorf_im = 2 * mean((v(rf_port)) * mfw * sin(mfph)) * mfs
let mfph = 2 * pi * 950000000.0 * (time - 2e-08)
let mf_flifa_re = 2 * mean((v(if_out)) * mfw * cos(mfph)) * mfs
let mf_flifa_im = 2 * mean((v(if_out)) * mfw * sin(mfph)) * mfs
let mfph = 2 * pi * 1050000000.0 * (time - 2e-08)
let mf_flifb_re = 2 * mean((v(if_out)) * mfw * cos(mfph)) * mfs
let mf_flifb_im = 2 * mean((v(if_out)) * mfw * sin(mfph)) * mfs
let mfph = 2 * pi * 20250000000.0 * (time - 2e-08)
let mf_fllorf_re = 2 * mean((v(rf_port)) * mfw * cos(mfph)) * mfs
let mf_fllorf_im = 2 * mean((v(rf_port)) * mfw * sin(mfph)) * mfs
let mfph = 2 * pi * 20250000000.0 * (time - 2e-08)
let mf_flloif_re = 2 * mean((v(if_out)) * mfw * cos(mfph)) * mfs
let mf_flloif_im = 2 * mean((v(if_out)) * mfw * sin(mfph)) * mfs
print mf_l
print mf_n
print mf_prail
print mf_lodiff_re
print mf_lodiff_im
print mf_if_re
print mf_if_im
print mf_loif_re
print mf_loif_im
print mf_lorf_re
print mf_lorf_im
print mf_flifa_re
print mf_flifa_im
print mf_flifb_re
print mf_flifb_im
print mf_fllorf_re
print mf_fllorf_im
print mf_flloif_re
print mf_flloif_im
destroy all
echo "MFEND ls_f21p20_m21_rf60"
echo "MFRUN ls_f21p20_m21_rf66"
alterparam f1 = 21200000000.0
alterparam f2 = 21200000000.0
alterparam flo = 20200000000.0
alterparam vrf1 = 0.00031697863849222284
alterparam vrf2 = 0.0
alterparam vlo = 0.07971590730710057
reset
op
let mf_dcirail = 0 - i(vdd)
let mf_dc_vce_q1 = v(c_q1)-v(e_q1)
let mf_dc_vbe_q1 = v(b_q1)-v(e_q1)
let mf_dc_ic_q1 = i(vic_q1)
let mf_dc_vce_q2 = v(c_q2)-v(e_q2)
let mf_dc_vbe_q2 = v(b_q2)-v(e_q2)
let mf_dc_ic_q2 = i(vic_q2)
let mf_dc_vce_q3 = v(c_q3)-v(x1)
let mf_dc_vbe_q3 = v(lo_p)-v(x1)
let mf_dc_ic_q3 = i(vic_q3)
let mf_dc_vce_q4 = v(c_q4)-v(x1)
let mf_dc_vbe_q4 = v(lo_n)-v(x1)
let mf_dc_ic_q4 = i(vic_q4)
let mf_dc_vce_q5 = v(c_q5)-v(x2)
let mf_dc_vbe_q5 = v(lo_p)-v(x2)
let mf_dc_ic_q5 = i(vic_q5)
let mf_dc_vce_q6 = v(c_q6)-v(x2)
let mf_dc_vbe_q6 = v(lo_n)-v(x2)
let mf_dc_ic_q6 = i(vic_q6)
let mf_dc_sink_tail = v(tail)
print mf_dcirail
print mf_dc_vce_q1
print mf_dc_vbe_q1
print mf_dc_ic_q1
print mf_dc_vce_q2
print mf_dc_vbe_q2
print mf_dc_ic_q2
print mf_dc_vce_q3
print mf_dc_vbe_q3
print mf_dc_ic_q3
print mf_dc_vce_q4
print mf_dc_vbe_q4
print mf_dc_ic_q4
print mf_dc_vce_q5
print mf_dc_vbe_q5
print mf_dc_ic_q5
print mf_dc_vce_q6
print mf_dc_vbe_q6
print mf_dc_ic_q6
print mf_dc_sink_tail
tran 1e-12 4e-08 0 1e-12
let mfq_vce_q1 = v(c_q1)-v(e_q1)
meas tran mf_su_vcemax_q1 MAX mfq_vce_q1 from=0.0 to=2e-08
meas tran mf_su_vcemin_q1 MIN mfq_vce_q1 from=0.0 to=2e-08
meas tran mf_ss_vcemax_q1 MAX mfq_vce_q1 from=2e-08 to=4e-08
meas tran mf_ss_vcemin_q1 MIN mfq_vce_q1 from=2e-08 to=4e-08
let mfq_vbe_q1 = v(b_q1)-v(e_q1)
meas tran mf_su_vbemax_q1 MAX mfq_vbe_q1 from=0.0 to=2e-08
meas tran mf_su_vbemin_q1 MIN mfq_vbe_q1 from=0.0 to=2e-08
meas tran mf_ss_vbemax_q1 MAX mfq_vbe_q1 from=2e-08 to=4e-08
meas tran mf_ss_vbemin_q1 MIN mfq_vbe_q1 from=2e-08 to=4e-08
let mfq_ic_q1 = i(vic_q1)
meas tran mf_su_icmax_q1 MAX mfq_ic_q1 from=0.0 to=2e-08
meas tran mf_su_icmin_q1 MIN mfq_ic_q1 from=0.0 to=2e-08
meas tran mf_ss_icmax_q1 MAX mfq_ic_q1 from=2e-08 to=4e-08
meas tran mf_ss_icmin_q1 MIN mfq_ic_q1 from=2e-08 to=4e-08
let mfq_vce_q2 = v(c_q2)-v(e_q2)
meas tran mf_su_vcemax_q2 MAX mfq_vce_q2 from=0.0 to=2e-08
meas tran mf_su_vcemin_q2 MIN mfq_vce_q2 from=0.0 to=2e-08
meas tran mf_ss_vcemax_q2 MAX mfq_vce_q2 from=2e-08 to=4e-08
meas tran mf_ss_vcemin_q2 MIN mfq_vce_q2 from=2e-08 to=4e-08
let mfq_vbe_q2 = v(b_q2)-v(e_q2)
meas tran mf_su_vbemax_q2 MAX mfq_vbe_q2 from=0.0 to=2e-08
meas tran mf_su_vbemin_q2 MIN mfq_vbe_q2 from=0.0 to=2e-08
meas tran mf_ss_vbemax_q2 MAX mfq_vbe_q2 from=2e-08 to=4e-08
meas tran mf_ss_vbemin_q2 MIN mfq_vbe_q2 from=2e-08 to=4e-08
let mfq_ic_q2 = i(vic_q2)
meas tran mf_su_icmax_q2 MAX mfq_ic_q2 from=0.0 to=2e-08
meas tran mf_su_icmin_q2 MIN mfq_ic_q2 from=0.0 to=2e-08
meas tran mf_ss_icmax_q2 MAX mfq_ic_q2 from=2e-08 to=4e-08
meas tran mf_ss_icmin_q2 MIN mfq_ic_q2 from=2e-08 to=4e-08
let mfq_vce_q3 = v(c_q3)-v(x1)
meas tran mf_su_vcemax_q3 MAX mfq_vce_q3 from=0.0 to=2e-08
meas tran mf_su_vcemin_q3 MIN mfq_vce_q3 from=0.0 to=2e-08
meas tran mf_ss_vcemax_q3 MAX mfq_vce_q3 from=2e-08 to=4e-08
meas tran mf_ss_vcemin_q3 MIN mfq_vce_q3 from=2e-08 to=4e-08
let mfq_vbe_q3 = v(lo_p)-v(x1)
meas tran mf_su_vbemax_q3 MAX mfq_vbe_q3 from=0.0 to=2e-08
meas tran mf_su_vbemin_q3 MIN mfq_vbe_q3 from=0.0 to=2e-08
meas tran mf_ss_vbemax_q3 MAX mfq_vbe_q3 from=2e-08 to=4e-08
meas tran mf_ss_vbemin_q3 MIN mfq_vbe_q3 from=2e-08 to=4e-08
let mfq_ic_q3 = i(vic_q3)
meas tran mf_su_icmax_q3 MAX mfq_ic_q3 from=0.0 to=2e-08
meas tran mf_su_icmin_q3 MIN mfq_ic_q3 from=0.0 to=2e-08
meas tran mf_ss_icmax_q3 MAX mfq_ic_q3 from=2e-08 to=4e-08
meas tran mf_ss_icmin_q3 MIN mfq_ic_q3 from=2e-08 to=4e-08
let mfq_vce_q4 = v(c_q4)-v(x1)
meas tran mf_su_vcemax_q4 MAX mfq_vce_q4 from=0.0 to=2e-08
meas tran mf_su_vcemin_q4 MIN mfq_vce_q4 from=0.0 to=2e-08
meas tran mf_ss_vcemax_q4 MAX mfq_vce_q4 from=2e-08 to=4e-08
meas tran mf_ss_vcemin_q4 MIN mfq_vce_q4 from=2e-08 to=4e-08
let mfq_vbe_q4 = v(lo_n)-v(x1)
meas tran mf_su_vbemax_q4 MAX mfq_vbe_q4 from=0.0 to=2e-08
meas tran mf_su_vbemin_q4 MIN mfq_vbe_q4 from=0.0 to=2e-08
meas tran mf_ss_vbemax_q4 MAX mfq_vbe_q4 from=2e-08 to=4e-08
meas tran mf_ss_vbemin_q4 MIN mfq_vbe_q4 from=2e-08 to=4e-08
let mfq_ic_q4 = i(vic_q4)
meas tran mf_su_icmax_q4 MAX mfq_ic_q4 from=0.0 to=2e-08
meas tran mf_su_icmin_q4 MIN mfq_ic_q4 from=0.0 to=2e-08
meas tran mf_ss_icmax_q4 MAX mfq_ic_q4 from=2e-08 to=4e-08
meas tran mf_ss_icmin_q4 MIN mfq_ic_q4 from=2e-08 to=4e-08
let mfq_vce_q5 = v(c_q5)-v(x2)
meas tran mf_su_vcemax_q5 MAX mfq_vce_q5 from=0.0 to=2e-08
meas tran mf_su_vcemin_q5 MIN mfq_vce_q5 from=0.0 to=2e-08
meas tran mf_ss_vcemax_q5 MAX mfq_vce_q5 from=2e-08 to=4e-08
meas tran mf_ss_vcemin_q5 MIN mfq_vce_q5 from=2e-08 to=4e-08
let mfq_vbe_q5 = v(lo_p)-v(x2)
meas tran mf_su_vbemax_q5 MAX mfq_vbe_q5 from=0.0 to=2e-08
meas tran mf_su_vbemin_q5 MIN mfq_vbe_q5 from=0.0 to=2e-08
meas tran mf_ss_vbemax_q5 MAX mfq_vbe_q5 from=2e-08 to=4e-08
meas tran mf_ss_vbemin_q5 MIN mfq_vbe_q5 from=2e-08 to=4e-08
let mfq_ic_q5 = i(vic_q5)
meas tran mf_su_icmax_q5 MAX mfq_ic_q5 from=0.0 to=2e-08
meas tran mf_su_icmin_q5 MIN mfq_ic_q5 from=0.0 to=2e-08
meas tran mf_ss_icmax_q5 MAX mfq_ic_q5 from=2e-08 to=4e-08
meas tran mf_ss_icmin_q5 MIN mfq_ic_q5 from=2e-08 to=4e-08
let mfq_vce_q6 = v(c_q6)-v(x2)
meas tran mf_su_vcemax_q6 MAX mfq_vce_q6 from=0.0 to=2e-08
meas tran mf_su_vcemin_q6 MIN mfq_vce_q6 from=0.0 to=2e-08
meas tran mf_ss_vcemax_q6 MAX mfq_vce_q6 from=2e-08 to=4e-08
meas tran mf_ss_vcemin_q6 MIN mfq_vce_q6 from=2e-08 to=4e-08
let mfq_vbe_q6 = v(lo_n)-v(x2)
meas tran mf_su_vbemax_q6 MAX mfq_vbe_q6 from=0.0 to=2e-08
meas tran mf_su_vbemin_q6 MIN mfq_vbe_q6 from=0.0 to=2e-08
meas tran mf_ss_vbemax_q6 MAX mfq_vbe_q6 from=2e-08 to=4e-08
meas tran mf_ss_vbemin_q6 MIN mfq_vbe_q6 from=2e-08 to=4e-08
let mfq_ic_q6 = i(vic_q6)
meas tran mf_su_icmax_q6 MAX mfq_ic_q6 from=0.0 to=2e-08
meas tran mf_su_icmin_q6 MIN mfq_ic_q6 from=0.0 to=2e-08
meas tran mf_ss_icmax_q6 MAX mfq_ic_q6 from=2e-08 to=4e-08
meas tran mf_ss_icmin_q6 MIN mfq_ic_q6 from=2e-08 to=4e-08
meas tran mf_su_sinkmin_tail MIN v(tail) from=0.0 to=2e-08
meas tran mf_ss_sinkmin_tail MIN v(tail) from=2e-08 to=4e-08
print mf_su_vcemax_q1
print mf_su_vcemin_q1
print mf_ss_vcemax_q1
print mf_ss_vcemin_q1
print mf_su_vbemax_q1
print mf_su_vbemin_q1
print mf_ss_vbemax_q1
print mf_ss_vbemin_q1
print mf_su_icmax_q1
print mf_su_icmin_q1
print mf_ss_icmax_q1
print mf_ss_icmin_q1
print mf_su_vcemax_q2
print mf_su_vcemin_q2
print mf_ss_vcemax_q2
print mf_ss_vcemin_q2
print mf_su_vbemax_q2
print mf_su_vbemin_q2
print mf_ss_vbemax_q2
print mf_ss_vbemin_q2
print mf_su_icmax_q2
print mf_su_icmin_q2
print mf_ss_icmax_q2
print mf_ss_icmin_q2
print mf_su_vcemax_q3
print mf_su_vcemin_q3
print mf_ss_vcemax_q3
print mf_ss_vcemin_q3
print mf_su_vbemax_q3
print mf_su_vbemin_q3
print mf_ss_vbemax_q3
print mf_ss_vbemin_q3
print mf_su_icmax_q3
print mf_su_icmin_q3
print mf_ss_icmax_q3
print mf_ss_icmin_q3
print mf_su_vcemax_q4
print mf_su_vcemin_q4
print mf_ss_vcemax_q4
print mf_ss_vcemin_q4
print mf_su_vbemax_q4
print mf_su_vbemin_q4
print mf_ss_vbemax_q4
print mf_ss_vbemin_q4
print mf_su_icmax_q4
print mf_su_icmin_q4
print mf_ss_icmax_q4
print mf_ss_icmin_q4
print mf_su_vcemax_q5
print mf_su_vcemin_q5
print mf_ss_vcemax_q5
print mf_ss_vcemin_q5
print mf_su_vbemax_q5
print mf_su_vbemin_q5
print mf_ss_vbemax_q5
print mf_ss_vbemin_q5
print mf_su_icmax_q5
print mf_su_icmin_q5
print mf_ss_icmax_q5
print mf_ss_icmin_q5
print mf_su_vcemax_q6
print mf_su_vcemin_q6
print mf_ss_vcemax_q6
print mf_ss_vcemin_q6
print mf_su_vbemax_q6
print mf_su_vbemin_q6
print mf_ss_vbemax_q6
print mf_ss_vbemin_q6
print mf_su_icmax_q6
print mf_su_icmin_q6
print mf_ss_icmax_q6
print mf_ss_icmin_q6
print mf_su_sinkmin_tail
print mf_ss_sinkmin_tail
linearize
let mf_l = length(time)
let mfw = (time ge 1.99995e-08) * (time lt 3.99995e-08)
let mf_n = mean(mfw) * mf_l
let mfs = mf_l / mf_n
let mf_prail = mean(v(vdd) * (0 - i(vdd)) * mfw) * mfs
let mfph = 2 * pi * 20200000000.0 * (time - 2e-08)
let mf_lodiff_re = 2 * mean((v(lo_p)-v(lo_n)) * mfw * cos(mfph)) * mfs
let mf_lodiff_im = 2 * mean((v(lo_p)-v(lo_n)) * mfw * sin(mfph)) * mfs
let mfph = 2 * pi * 1000000000.0 * (time - 2e-08)
let mf_if_re = 2 * mean((v(if_out)) * mfw * cos(mfph)) * mfs
let mf_if_im = 2 * mean((v(if_out)) * mfw * sin(mfph)) * mfs
let mfph = 2 * pi * 20200000000.0 * (time - 2e-08)
let mf_loif_re = 2 * mean((v(if_out)) * mfw * cos(mfph)) * mfs
let mf_loif_im = 2 * mean((v(if_out)) * mfw * sin(mfph)) * mfs
let mfph = 2 * pi * 20200000000.0 * (time - 2e-08)
let mf_lorf_re = 2 * mean((v(rf_port)) * mfw * cos(mfph)) * mfs
let mf_lorf_im = 2 * mean((v(rf_port)) * mfw * sin(mfph)) * mfs
let mfph = 2 * pi * 950000000.0 * (time - 2e-08)
let mf_flifa_re = 2 * mean((v(if_out)) * mfw * cos(mfph)) * mfs
let mf_flifa_im = 2 * mean((v(if_out)) * mfw * sin(mfph)) * mfs
let mfph = 2 * pi * 1050000000.0 * (time - 2e-08)
let mf_flifb_re = 2 * mean((v(if_out)) * mfw * cos(mfph)) * mfs
let mf_flifb_im = 2 * mean((v(if_out)) * mfw * sin(mfph)) * mfs
let mfph = 2 * pi * 20250000000.0 * (time - 2e-08)
let mf_fllorf_re = 2 * mean((v(rf_port)) * mfw * cos(mfph)) * mfs
let mf_fllorf_im = 2 * mean((v(rf_port)) * mfw * sin(mfph)) * mfs
let mfph = 2 * pi * 20250000000.0 * (time - 2e-08)
let mf_flloif_re = 2 * mean((v(if_out)) * mfw * cos(mfph)) * mfs
let mf_flloif_im = 2 * mean((v(if_out)) * mfw * sin(mfph)) * mfs
print mf_l
print mf_n
print mf_prail
print mf_lodiff_re
print mf_lodiff_im
print mf_if_re
print mf_if_im
print mf_loif_re
print mf_loif_im
print mf_lorf_re
print mf_lorf_im
print mf_flifa_re
print mf_flifa_im
print mf_flifb_re
print mf_flifb_im
print mf_fllorf_re
print mf_fllorf_im
print mf_flloif_re
print mf_flloif_im
destroy all
echo "MFEND ls_f21p20_m21_rf66"
echo "MFRUN ls_f21p20_m18_rf60"
alterparam f1 = 21200000000.0
alterparam f2 = 21200000000.0
alterparam flo = 20200000000.0
alterparam vrf1 = 0.0006324555320336759
alterparam vrf2 = 0.0
alterparam vlo = 0.11260171197494694
reset
op
let mf_dcirail = 0 - i(vdd)
let mf_dc_vce_q1 = v(c_q1)-v(e_q1)
let mf_dc_vbe_q1 = v(b_q1)-v(e_q1)
let mf_dc_ic_q1 = i(vic_q1)
let mf_dc_vce_q2 = v(c_q2)-v(e_q2)
let mf_dc_vbe_q2 = v(b_q2)-v(e_q2)
let mf_dc_ic_q2 = i(vic_q2)
let mf_dc_vce_q3 = v(c_q3)-v(x1)
let mf_dc_vbe_q3 = v(lo_p)-v(x1)
let mf_dc_ic_q3 = i(vic_q3)
let mf_dc_vce_q4 = v(c_q4)-v(x1)
let mf_dc_vbe_q4 = v(lo_n)-v(x1)
let mf_dc_ic_q4 = i(vic_q4)
let mf_dc_vce_q5 = v(c_q5)-v(x2)
let mf_dc_vbe_q5 = v(lo_p)-v(x2)
let mf_dc_ic_q5 = i(vic_q5)
let mf_dc_vce_q6 = v(c_q6)-v(x2)
let mf_dc_vbe_q6 = v(lo_n)-v(x2)
let mf_dc_ic_q6 = i(vic_q6)
let mf_dc_sink_tail = v(tail)
print mf_dcirail
print mf_dc_vce_q1
print mf_dc_vbe_q1
print mf_dc_ic_q1
print mf_dc_vce_q2
print mf_dc_vbe_q2
print mf_dc_ic_q2
print mf_dc_vce_q3
print mf_dc_vbe_q3
print mf_dc_ic_q3
print mf_dc_vce_q4
print mf_dc_vbe_q4
print mf_dc_ic_q4
print mf_dc_vce_q5
print mf_dc_vbe_q5
print mf_dc_ic_q5
print mf_dc_vce_q6
print mf_dc_vbe_q6
print mf_dc_ic_q6
print mf_dc_sink_tail
tran 1e-12 4e-08 0 1e-12
let mfq_vce_q1 = v(c_q1)-v(e_q1)
meas tran mf_su_vcemax_q1 MAX mfq_vce_q1 from=0.0 to=2e-08
meas tran mf_su_vcemin_q1 MIN mfq_vce_q1 from=0.0 to=2e-08
meas tran mf_ss_vcemax_q1 MAX mfq_vce_q1 from=2e-08 to=4e-08
meas tran mf_ss_vcemin_q1 MIN mfq_vce_q1 from=2e-08 to=4e-08
let mfq_vbe_q1 = v(b_q1)-v(e_q1)
meas tran mf_su_vbemax_q1 MAX mfq_vbe_q1 from=0.0 to=2e-08
meas tran mf_su_vbemin_q1 MIN mfq_vbe_q1 from=0.0 to=2e-08
meas tran mf_ss_vbemax_q1 MAX mfq_vbe_q1 from=2e-08 to=4e-08
meas tran mf_ss_vbemin_q1 MIN mfq_vbe_q1 from=2e-08 to=4e-08
let mfq_ic_q1 = i(vic_q1)
meas tran mf_su_icmax_q1 MAX mfq_ic_q1 from=0.0 to=2e-08
meas tran mf_su_icmin_q1 MIN mfq_ic_q1 from=0.0 to=2e-08
meas tran mf_ss_icmax_q1 MAX mfq_ic_q1 from=2e-08 to=4e-08
meas tran mf_ss_icmin_q1 MIN mfq_ic_q1 from=2e-08 to=4e-08
let mfq_vce_q2 = v(c_q2)-v(e_q2)
meas tran mf_su_vcemax_q2 MAX mfq_vce_q2 from=0.0 to=2e-08
meas tran mf_su_vcemin_q2 MIN mfq_vce_q2 from=0.0 to=2e-08
meas tran mf_ss_vcemax_q2 MAX mfq_vce_q2 from=2e-08 to=4e-08
meas tran mf_ss_vcemin_q2 MIN mfq_vce_q2 from=2e-08 to=4e-08
let mfq_vbe_q2 = v(b_q2)-v(e_q2)
meas tran mf_su_vbemax_q2 MAX mfq_vbe_q2 from=0.0 to=2e-08
meas tran mf_su_vbemin_q2 MIN mfq_vbe_q2 from=0.0 to=2e-08
meas tran mf_ss_vbemax_q2 MAX mfq_vbe_q2 from=2e-08 to=4e-08
meas tran mf_ss_vbemin_q2 MIN mfq_vbe_q2 from=2e-08 to=4e-08
let mfq_ic_q2 = i(vic_q2)
meas tran mf_su_icmax_q2 MAX mfq_ic_q2 from=0.0 to=2e-08
meas tran mf_su_icmin_q2 MIN mfq_ic_q2 from=0.0 to=2e-08
meas tran mf_ss_icmax_q2 MAX mfq_ic_q2 from=2e-08 to=4e-08
meas tran mf_ss_icmin_q2 MIN mfq_ic_q2 from=2e-08 to=4e-08
let mfq_vce_q3 = v(c_q3)-v(x1)
meas tran mf_su_vcemax_q3 MAX mfq_vce_q3 from=0.0 to=2e-08
meas tran mf_su_vcemin_q3 MIN mfq_vce_q3 from=0.0 to=2e-08
meas tran mf_ss_vcemax_q3 MAX mfq_vce_q3 from=2e-08 to=4e-08
meas tran mf_ss_vcemin_q3 MIN mfq_vce_q3 from=2e-08 to=4e-08
let mfq_vbe_q3 = v(lo_p)-v(x1)
meas tran mf_su_vbemax_q3 MAX mfq_vbe_q3 from=0.0 to=2e-08
meas tran mf_su_vbemin_q3 MIN mfq_vbe_q3 from=0.0 to=2e-08
meas tran mf_ss_vbemax_q3 MAX mfq_vbe_q3 from=2e-08 to=4e-08
meas tran mf_ss_vbemin_q3 MIN mfq_vbe_q3 from=2e-08 to=4e-08
let mfq_ic_q3 = i(vic_q3)
meas tran mf_su_icmax_q3 MAX mfq_ic_q3 from=0.0 to=2e-08
meas tran mf_su_icmin_q3 MIN mfq_ic_q3 from=0.0 to=2e-08
meas tran mf_ss_icmax_q3 MAX mfq_ic_q3 from=2e-08 to=4e-08
meas tran mf_ss_icmin_q3 MIN mfq_ic_q3 from=2e-08 to=4e-08
let mfq_vce_q4 = v(c_q4)-v(x1)
meas tran mf_su_vcemax_q4 MAX mfq_vce_q4 from=0.0 to=2e-08
meas tran mf_su_vcemin_q4 MIN mfq_vce_q4 from=0.0 to=2e-08
meas tran mf_ss_vcemax_q4 MAX mfq_vce_q4 from=2e-08 to=4e-08
meas tran mf_ss_vcemin_q4 MIN mfq_vce_q4 from=2e-08 to=4e-08
let mfq_vbe_q4 = v(lo_n)-v(x1)
meas tran mf_su_vbemax_q4 MAX mfq_vbe_q4 from=0.0 to=2e-08
meas tran mf_su_vbemin_q4 MIN mfq_vbe_q4 from=0.0 to=2e-08
meas tran mf_ss_vbemax_q4 MAX mfq_vbe_q4 from=2e-08 to=4e-08
meas tran mf_ss_vbemin_q4 MIN mfq_vbe_q4 from=2e-08 to=4e-08
let mfq_ic_q4 = i(vic_q4)
meas tran mf_su_icmax_q4 MAX mfq_ic_q4 from=0.0 to=2e-08
meas tran mf_su_icmin_q4 MIN mfq_ic_q4 from=0.0 to=2e-08
meas tran mf_ss_icmax_q4 MAX mfq_ic_q4 from=2e-08 to=4e-08
meas tran mf_ss_icmin_q4 MIN mfq_ic_q4 from=2e-08 to=4e-08
let mfq_vce_q5 = v(c_q5)-v(x2)
meas tran mf_su_vcemax_q5 MAX mfq_vce_q5 from=0.0 to=2e-08
meas tran mf_su_vcemin_q5 MIN mfq_vce_q5 from=0.0 to=2e-08
meas tran mf_ss_vcemax_q5 MAX mfq_vce_q5 from=2e-08 to=4e-08
meas tran mf_ss_vcemin_q5 MIN mfq_vce_q5 from=2e-08 to=4e-08
let mfq_vbe_q5 = v(lo_p)-v(x2)
meas tran mf_su_vbemax_q5 MAX mfq_vbe_q5 from=0.0 to=2e-08
meas tran mf_su_vbemin_q5 MIN mfq_vbe_q5 from=0.0 to=2e-08
meas tran mf_ss_vbemax_q5 MAX mfq_vbe_q5 from=2e-08 to=4e-08
meas tran mf_ss_vbemin_q5 MIN mfq_vbe_q5 from=2e-08 to=4e-08
let mfq_ic_q5 = i(vic_q5)
meas tran mf_su_icmax_q5 MAX mfq_ic_q5 from=0.0 to=2e-08
meas tran mf_su_icmin_q5 MIN mfq_ic_q5 from=0.0 to=2e-08
meas tran mf_ss_icmax_q5 MAX mfq_ic_q5 from=2e-08 to=4e-08
meas tran mf_ss_icmin_q5 MIN mfq_ic_q5 from=2e-08 to=4e-08
let mfq_vce_q6 = v(c_q6)-v(x2)
meas tran mf_su_vcemax_q6 MAX mfq_vce_q6 from=0.0 to=2e-08
meas tran mf_su_vcemin_q6 MIN mfq_vce_q6 from=0.0 to=2e-08
meas tran mf_ss_vcemax_q6 MAX mfq_vce_q6 from=2e-08 to=4e-08
meas tran mf_ss_vcemin_q6 MIN mfq_vce_q6 from=2e-08 to=4e-08
let mfq_vbe_q6 = v(lo_n)-v(x2)
meas tran mf_su_vbemax_q6 MAX mfq_vbe_q6 from=0.0 to=2e-08
meas tran mf_su_vbemin_q6 MIN mfq_vbe_q6 from=0.0 to=2e-08
meas tran mf_ss_vbemax_q6 MAX mfq_vbe_q6 from=2e-08 to=4e-08
meas tran mf_ss_vbemin_q6 MIN mfq_vbe_q6 from=2e-08 to=4e-08
let mfq_ic_q6 = i(vic_q6)
meas tran mf_su_icmax_q6 MAX mfq_ic_q6 from=0.0 to=2e-08
meas tran mf_su_icmin_q6 MIN mfq_ic_q6 from=0.0 to=2e-08
meas tran mf_ss_icmax_q6 MAX mfq_ic_q6 from=2e-08 to=4e-08
meas tran mf_ss_icmin_q6 MIN mfq_ic_q6 from=2e-08 to=4e-08
meas tran mf_su_sinkmin_tail MIN v(tail) from=0.0 to=2e-08
meas tran mf_ss_sinkmin_tail MIN v(tail) from=2e-08 to=4e-08
print mf_su_vcemax_q1
print mf_su_vcemin_q1
print mf_ss_vcemax_q1
print mf_ss_vcemin_q1
print mf_su_vbemax_q1
print mf_su_vbemin_q1
print mf_ss_vbemax_q1
print mf_ss_vbemin_q1
print mf_su_icmax_q1
print mf_su_icmin_q1
print mf_ss_icmax_q1
print mf_ss_icmin_q1
print mf_su_vcemax_q2
print mf_su_vcemin_q2
print mf_ss_vcemax_q2
print mf_ss_vcemin_q2
print mf_su_vbemax_q2
print mf_su_vbemin_q2
print mf_ss_vbemax_q2
print mf_ss_vbemin_q2
print mf_su_icmax_q2
print mf_su_icmin_q2
print mf_ss_icmax_q2
print mf_ss_icmin_q2
print mf_su_vcemax_q3
print mf_su_vcemin_q3
print mf_ss_vcemax_q3
print mf_ss_vcemin_q3
print mf_su_vbemax_q3
print mf_su_vbemin_q3
print mf_ss_vbemax_q3
print mf_ss_vbemin_q3
print mf_su_icmax_q3
print mf_su_icmin_q3
print mf_ss_icmax_q3
print mf_ss_icmin_q3
print mf_su_vcemax_q4
print mf_su_vcemin_q4
print mf_ss_vcemax_q4
print mf_ss_vcemin_q4
print mf_su_vbemax_q4
print mf_su_vbemin_q4
print mf_ss_vbemax_q4
print mf_ss_vbemin_q4
print mf_su_icmax_q4
print mf_su_icmin_q4
print mf_ss_icmax_q4
print mf_ss_icmin_q4
print mf_su_vcemax_q5
print mf_su_vcemin_q5
print mf_ss_vcemax_q5
print mf_ss_vcemin_q5
print mf_su_vbemax_q5
print mf_su_vbemin_q5
print mf_ss_vbemax_q5
print mf_ss_vbemin_q5
print mf_su_icmax_q5
print mf_su_icmin_q5
print mf_ss_icmax_q5
print mf_ss_icmin_q5
print mf_su_vcemax_q6
print mf_su_vcemin_q6
print mf_ss_vcemax_q6
print mf_ss_vcemin_q6
print mf_su_vbemax_q6
print mf_su_vbemin_q6
print mf_ss_vbemax_q6
print mf_ss_vbemin_q6
print mf_su_icmax_q6
print mf_su_icmin_q6
print mf_ss_icmax_q6
print mf_ss_icmin_q6
print mf_su_sinkmin_tail
print mf_ss_sinkmin_tail
linearize
let mf_l = length(time)
let mfw = (time ge 1.99995e-08) * (time lt 3.99995e-08)
let mf_n = mean(mfw) * mf_l
let mfs = mf_l / mf_n
let mf_prail = mean(v(vdd) * (0 - i(vdd)) * mfw) * mfs
let mfph = 2 * pi * 20200000000.0 * (time - 2e-08)
let mf_lodiff_re = 2 * mean((v(lo_p)-v(lo_n)) * mfw * cos(mfph)) * mfs
let mf_lodiff_im = 2 * mean((v(lo_p)-v(lo_n)) * mfw * sin(mfph)) * mfs
let mfph = 2 * pi * 1000000000.0 * (time - 2e-08)
let mf_if_re = 2 * mean((v(if_out)) * mfw * cos(mfph)) * mfs
let mf_if_im = 2 * mean((v(if_out)) * mfw * sin(mfph)) * mfs
let mfph = 2 * pi * 20200000000.0 * (time - 2e-08)
let mf_loif_re = 2 * mean((v(if_out)) * mfw * cos(mfph)) * mfs
let mf_loif_im = 2 * mean((v(if_out)) * mfw * sin(mfph)) * mfs
let mfph = 2 * pi * 20200000000.0 * (time - 2e-08)
let mf_lorf_re = 2 * mean((v(rf_port)) * mfw * cos(mfph)) * mfs
let mf_lorf_im = 2 * mean((v(rf_port)) * mfw * sin(mfph)) * mfs
let mfph = 2 * pi * 950000000.0 * (time - 2e-08)
let mf_flifa_re = 2 * mean((v(if_out)) * mfw * cos(mfph)) * mfs
let mf_flifa_im = 2 * mean((v(if_out)) * mfw * sin(mfph)) * mfs
let mfph = 2 * pi * 1050000000.0 * (time - 2e-08)
let mf_flifb_re = 2 * mean((v(if_out)) * mfw * cos(mfph)) * mfs
let mf_flifb_im = 2 * mean((v(if_out)) * mfw * sin(mfph)) * mfs
let mfph = 2 * pi * 20250000000.0 * (time - 2e-08)
let mf_fllorf_re = 2 * mean((v(rf_port)) * mfw * cos(mfph)) * mfs
let mf_fllorf_im = 2 * mean((v(rf_port)) * mfw * sin(mfph)) * mfs
let mfph = 2 * pi * 20250000000.0 * (time - 2e-08)
let mf_flloif_re = 2 * mean((v(if_out)) * mfw * cos(mfph)) * mfs
let mf_flloif_im = 2 * mean((v(if_out)) * mfw * sin(mfph)) * mfs
print mf_l
print mf_n
print mf_prail
print mf_lodiff_re
print mf_lodiff_im
print mf_if_re
print mf_if_im
print mf_loif_re
print mf_loif_im
print mf_lorf_re
print mf_lorf_im
print mf_flifa_re
print mf_flifa_im
print mf_flifb_re
print mf_flifb_im
print mf_fllorf_re
print mf_fllorf_im
print mf_flloif_re
print mf_flloif_im
destroy all
echo "MFEND ls_f21p20_m18_rf60"
echo "MFRUN ls_f21p20_m18_rf66"
alterparam f1 = 21200000000.0
alterparam f2 = 21200000000.0
alterparam flo = 20200000000.0
alterparam vrf1 = 0.00031697863849222284
alterparam vrf2 = 0.0
alterparam vlo = 0.11260171197494694
reset
op
let mf_dcirail = 0 - i(vdd)
let mf_dc_vce_q1 = v(c_q1)-v(e_q1)
let mf_dc_vbe_q1 = v(b_q1)-v(e_q1)
let mf_dc_ic_q1 = i(vic_q1)
let mf_dc_vce_q2 = v(c_q2)-v(e_q2)
let mf_dc_vbe_q2 = v(b_q2)-v(e_q2)
let mf_dc_ic_q2 = i(vic_q2)
let mf_dc_vce_q3 = v(c_q3)-v(x1)
let mf_dc_vbe_q3 = v(lo_p)-v(x1)
let mf_dc_ic_q3 = i(vic_q3)
let mf_dc_vce_q4 = v(c_q4)-v(x1)
let mf_dc_vbe_q4 = v(lo_n)-v(x1)
let mf_dc_ic_q4 = i(vic_q4)
let mf_dc_vce_q5 = v(c_q5)-v(x2)
let mf_dc_vbe_q5 = v(lo_p)-v(x2)
let mf_dc_ic_q5 = i(vic_q5)
let mf_dc_vce_q6 = v(c_q6)-v(x2)
let mf_dc_vbe_q6 = v(lo_n)-v(x2)
let mf_dc_ic_q6 = i(vic_q6)
let mf_dc_sink_tail = v(tail)
print mf_dcirail
print mf_dc_vce_q1
print mf_dc_vbe_q1
print mf_dc_ic_q1
print mf_dc_vce_q2
print mf_dc_vbe_q2
print mf_dc_ic_q2
print mf_dc_vce_q3
print mf_dc_vbe_q3
print mf_dc_ic_q3
print mf_dc_vce_q4
print mf_dc_vbe_q4
print mf_dc_ic_q4
print mf_dc_vce_q5
print mf_dc_vbe_q5
print mf_dc_ic_q5
print mf_dc_vce_q6
print mf_dc_vbe_q6
print mf_dc_ic_q6
print mf_dc_sink_tail
tran 1e-12 4e-08 0 1e-12
let mfq_vce_q1 = v(c_q1)-v(e_q1)
meas tran mf_su_vcemax_q1 MAX mfq_vce_q1 from=0.0 to=2e-08
meas tran mf_su_vcemin_q1 MIN mfq_vce_q1 from=0.0 to=2e-08
meas tran mf_ss_vcemax_q1 MAX mfq_vce_q1 from=2e-08 to=4e-08
meas tran mf_ss_vcemin_q1 MIN mfq_vce_q1 from=2e-08 to=4e-08
let mfq_vbe_q1 = v(b_q1)-v(e_q1)
meas tran mf_su_vbemax_q1 MAX mfq_vbe_q1 from=0.0 to=2e-08
meas tran mf_su_vbemin_q1 MIN mfq_vbe_q1 from=0.0 to=2e-08
meas tran mf_ss_vbemax_q1 MAX mfq_vbe_q1 from=2e-08 to=4e-08
meas tran mf_ss_vbemin_q1 MIN mfq_vbe_q1 from=2e-08 to=4e-08
let mfq_ic_q1 = i(vic_q1)
meas tran mf_su_icmax_q1 MAX mfq_ic_q1 from=0.0 to=2e-08
meas tran mf_su_icmin_q1 MIN mfq_ic_q1 from=0.0 to=2e-08
meas tran mf_ss_icmax_q1 MAX mfq_ic_q1 from=2e-08 to=4e-08
meas tran mf_ss_icmin_q1 MIN mfq_ic_q1 from=2e-08 to=4e-08
let mfq_vce_q2 = v(c_q2)-v(e_q2)
meas tran mf_su_vcemax_q2 MAX mfq_vce_q2 from=0.0 to=2e-08
meas tran mf_su_vcemin_q2 MIN mfq_vce_q2 from=0.0 to=2e-08
meas tran mf_ss_vcemax_q2 MAX mfq_vce_q2 from=2e-08 to=4e-08
meas tran mf_ss_vcemin_q2 MIN mfq_vce_q2 from=2e-08 to=4e-08
let mfq_vbe_q2 = v(b_q2)-v(e_q2)
meas tran mf_su_vbemax_q2 MAX mfq_vbe_q2 from=0.0 to=2e-08
meas tran mf_su_vbemin_q2 MIN mfq_vbe_q2 from=0.0 to=2e-08
meas tran mf_ss_vbemax_q2 MAX mfq_vbe_q2 from=2e-08 to=4e-08
meas tran mf_ss_vbemin_q2 MIN mfq_vbe_q2 from=2e-08 to=4e-08
let mfq_ic_q2 = i(vic_q2)
meas tran mf_su_icmax_q2 MAX mfq_ic_q2 from=0.0 to=2e-08
meas tran mf_su_icmin_q2 MIN mfq_ic_q2 from=0.0 to=2e-08
meas tran mf_ss_icmax_q2 MAX mfq_ic_q2 from=2e-08 to=4e-08
meas tran mf_ss_icmin_q2 MIN mfq_ic_q2 from=2e-08 to=4e-08
let mfq_vce_q3 = v(c_q3)-v(x1)
meas tran mf_su_vcemax_q3 MAX mfq_vce_q3 from=0.0 to=2e-08
meas tran mf_su_vcemin_q3 MIN mfq_vce_q3 from=0.0 to=2e-08
meas tran mf_ss_vcemax_q3 MAX mfq_vce_q3 from=2e-08 to=4e-08
meas tran mf_ss_vcemin_q3 MIN mfq_vce_q3 from=2e-08 to=4e-08
let mfq_vbe_q3 = v(lo_p)-v(x1)
meas tran mf_su_vbemax_q3 MAX mfq_vbe_q3 from=0.0 to=2e-08
meas tran mf_su_vbemin_q3 MIN mfq_vbe_q3 from=0.0 to=2e-08
meas tran mf_ss_vbemax_q3 MAX mfq_vbe_q3 from=2e-08 to=4e-08
meas tran mf_ss_vbemin_q3 MIN mfq_vbe_q3 from=2e-08 to=4e-08
let mfq_ic_q3 = i(vic_q3)
meas tran mf_su_icmax_q3 MAX mfq_ic_q3 from=0.0 to=2e-08
meas tran mf_su_icmin_q3 MIN mfq_ic_q3 from=0.0 to=2e-08
meas tran mf_ss_icmax_q3 MAX mfq_ic_q3 from=2e-08 to=4e-08
meas tran mf_ss_icmin_q3 MIN mfq_ic_q3 from=2e-08 to=4e-08
let mfq_vce_q4 = v(c_q4)-v(x1)
meas tran mf_su_vcemax_q4 MAX mfq_vce_q4 from=0.0 to=2e-08
meas tran mf_su_vcemin_q4 MIN mfq_vce_q4 from=0.0 to=2e-08
meas tran mf_ss_vcemax_q4 MAX mfq_vce_q4 from=2e-08 to=4e-08
meas tran mf_ss_vcemin_q4 MIN mfq_vce_q4 from=2e-08 to=4e-08
let mfq_vbe_q4 = v(lo_n)-v(x1)
meas tran mf_su_vbemax_q4 MAX mfq_vbe_q4 from=0.0 to=2e-08
meas tran mf_su_vbemin_q4 MIN mfq_vbe_q4 from=0.0 to=2e-08
meas tran mf_ss_vbemax_q4 MAX mfq_vbe_q4 from=2e-08 to=4e-08
meas tran mf_ss_vbemin_q4 MIN mfq_vbe_q4 from=2e-08 to=4e-08
let mfq_ic_q4 = i(vic_q4)
meas tran mf_su_icmax_q4 MAX mfq_ic_q4 from=0.0 to=2e-08
meas tran mf_su_icmin_q4 MIN mfq_ic_q4 from=0.0 to=2e-08
meas tran mf_ss_icmax_q4 MAX mfq_ic_q4 from=2e-08 to=4e-08
meas tran mf_ss_icmin_q4 MIN mfq_ic_q4 from=2e-08 to=4e-08
let mfq_vce_q5 = v(c_q5)-v(x2)
meas tran mf_su_vcemax_q5 MAX mfq_vce_q5 from=0.0 to=2e-08
meas tran mf_su_vcemin_q5 MIN mfq_vce_q5 from=0.0 to=2e-08
meas tran mf_ss_vcemax_q5 MAX mfq_vce_q5 from=2e-08 to=4e-08
meas tran mf_ss_vcemin_q5 MIN mfq_vce_q5 from=2e-08 to=4e-08
let mfq_vbe_q5 = v(lo_p)-v(x2)
meas tran mf_su_vbemax_q5 MAX mfq_vbe_q5 from=0.0 to=2e-08
meas tran mf_su_vbemin_q5 MIN mfq_vbe_q5 from=0.0 to=2e-08
meas tran mf_ss_vbemax_q5 MAX mfq_vbe_q5 from=2e-08 to=4e-08
meas tran mf_ss_vbemin_q5 MIN mfq_vbe_q5 from=2e-08 to=4e-08
let mfq_ic_q5 = i(vic_q5)
meas tran mf_su_icmax_q5 MAX mfq_ic_q5 from=0.0 to=2e-08
meas tran mf_su_icmin_q5 MIN mfq_ic_q5 from=0.0 to=2e-08
meas tran mf_ss_icmax_q5 MAX mfq_ic_q5 from=2e-08 to=4e-08
meas tran mf_ss_icmin_q5 MIN mfq_ic_q5 from=2e-08 to=4e-08
let mfq_vce_q6 = v(c_q6)-v(x2)
meas tran mf_su_vcemax_q6 MAX mfq_vce_q6 from=0.0 to=2e-08
meas tran mf_su_vcemin_q6 MIN mfq_vce_q6 from=0.0 to=2e-08
meas tran mf_ss_vcemax_q6 MAX mfq_vce_q6 from=2e-08 to=4e-08
meas tran mf_ss_vcemin_q6 MIN mfq_vce_q6 from=2e-08 to=4e-08
let mfq_vbe_q6 = v(lo_n)-v(x2)
meas tran mf_su_vbemax_q6 MAX mfq_vbe_q6 from=0.0 to=2e-08
meas tran mf_su_vbemin_q6 MIN mfq_vbe_q6 from=0.0 to=2e-08
meas tran mf_ss_vbemax_q6 MAX mfq_vbe_q6 from=2e-08 to=4e-08
meas tran mf_ss_vbemin_q6 MIN mfq_vbe_q6 from=2e-08 to=4e-08
let mfq_ic_q6 = i(vic_q6)
meas tran mf_su_icmax_q6 MAX mfq_ic_q6 from=0.0 to=2e-08
meas tran mf_su_icmin_q6 MIN mfq_ic_q6 from=0.0 to=2e-08
meas tran mf_ss_icmax_q6 MAX mfq_ic_q6 from=2e-08 to=4e-08
meas tran mf_ss_icmin_q6 MIN mfq_ic_q6 from=2e-08 to=4e-08
meas tran mf_su_sinkmin_tail MIN v(tail) from=0.0 to=2e-08
meas tran mf_ss_sinkmin_tail MIN v(tail) from=2e-08 to=4e-08
print mf_su_vcemax_q1
print mf_su_vcemin_q1
print mf_ss_vcemax_q1
print mf_ss_vcemin_q1
print mf_su_vbemax_q1
print mf_su_vbemin_q1
print mf_ss_vbemax_q1
print mf_ss_vbemin_q1
print mf_su_icmax_q1
print mf_su_icmin_q1
print mf_ss_icmax_q1
print mf_ss_icmin_q1
print mf_su_vcemax_q2
print mf_su_vcemin_q2
print mf_ss_vcemax_q2
print mf_ss_vcemin_q2
print mf_su_vbemax_q2
print mf_su_vbemin_q2
print mf_ss_vbemax_q2
print mf_ss_vbemin_q2
print mf_su_icmax_q2
print mf_su_icmin_q2
print mf_ss_icmax_q2
print mf_ss_icmin_q2
print mf_su_vcemax_q3
print mf_su_vcemin_q3
print mf_ss_vcemax_q3
print mf_ss_vcemin_q3
print mf_su_vbemax_q3
print mf_su_vbemin_q3
print mf_ss_vbemax_q3
print mf_ss_vbemin_q3
print mf_su_icmax_q3
print mf_su_icmin_q3
print mf_ss_icmax_q3
print mf_ss_icmin_q3
print mf_su_vcemax_q4
print mf_su_vcemin_q4
print mf_ss_vcemax_q4
print mf_ss_vcemin_q4
print mf_su_vbemax_q4
print mf_su_vbemin_q4
print mf_ss_vbemax_q4
print mf_ss_vbemin_q4
print mf_su_icmax_q4
print mf_su_icmin_q4
print mf_ss_icmax_q4
print mf_ss_icmin_q4
print mf_su_vcemax_q5
print mf_su_vcemin_q5
print mf_ss_vcemax_q5
print mf_ss_vcemin_q5
print mf_su_vbemax_q5
print mf_su_vbemin_q5
print mf_ss_vbemax_q5
print mf_ss_vbemin_q5
print mf_su_icmax_q5
print mf_su_icmin_q5
print mf_ss_icmax_q5
print mf_ss_icmin_q5
print mf_su_vcemax_q6
print mf_su_vcemin_q6
print mf_ss_vcemax_q6
print mf_ss_vcemin_q6
print mf_su_vbemax_q6
print mf_su_vbemin_q6
print mf_ss_vbemax_q6
print mf_ss_vbemin_q6
print mf_su_icmax_q6
print mf_su_icmin_q6
print mf_ss_icmax_q6
print mf_ss_icmin_q6
print mf_su_sinkmin_tail
print mf_ss_sinkmin_tail
linearize
let mf_l = length(time)
let mfw = (time ge 1.99995e-08) * (time lt 3.99995e-08)
let mf_n = mean(mfw) * mf_l
let mfs = mf_l / mf_n
let mf_prail = mean(v(vdd) * (0 - i(vdd)) * mfw) * mfs
let mfph = 2 * pi * 20200000000.0 * (time - 2e-08)
let mf_lodiff_re = 2 * mean((v(lo_p)-v(lo_n)) * mfw * cos(mfph)) * mfs
let mf_lodiff_im = 2 * mean((v(lo_p)-v(lo_n)) * mfw * sin(mfph)) * mfs
let mfph = 2 * pi * 1000000000.0 * (time - 2e-08)
let mf_if_re = 2 * mean((v(if_out)) * mfw * cos(mfph)) * mfs
let mf_if_im = 2 * mean((v(if_out)) * mfw * sin(mfph)) * mfs
let mfph = 2 * pi * 20200000000.0 * (time - 2e-08)
let mf_loif_re = 2 * mean((v(if_out)) * mfw * cos(mfph)) * mfs
let mf_loif_im = 2 * mean((v(if_out)) * mfw * sin(mfph)) * mfs
let mfph = 2 * pi * 20200000000.0 * (time - 2e-08)
let mf_lorf_re = 2 * mean((v(rf_port)) * mfw * cos(mfph)) * mfs
let mf_lorf_im = 2 * mean((v(rf_port)) * mfw * sin(mfph)) * mfs
let mfph = 2 * pi * 950000000.0 * (time - 2e-08)
let mf_flifa_re = 2 * mean((v(if_out)) * mfw * cos(mfph)) * mfs
let mf_flifa_im = 2 * mean((v(if_out)) * mfw * sin(mfph)) * mfs
let mfph = 2 * pi * 1050000000.0 * (time - 2e-08)
let mf_flifb_re = 2 * mean((v(if_out)) * mfw * cos(mfph)) * mfs
let mf_flifb_im = 2 * mean((v(if_out)) * mfw * sin(mfph)) * mfs
let mfph = 2 * pi * 20250000000.0 * (time - 2e-08)
let mf_fllorf_re = 2 * mean((v(rf_port)) * mfw * cos(mfph)) * mfs
let mf_fllorf_im = 2 * mean((v(rf_port)) * mfw * sin(mfph)) * mfs
let mfph = 2 * pi * 20250000000.0 * (time - 2e-08)
let mf_flloif_re = 2 * mean((v(if_out)) * mfw * cos(mfph)) * mfs
let mf_flloif_im = 2 * mean((v(if_out)) * mfw * sin(mfph)) * mfs
print mf_l
print mf_n
print mf_prail
print mf_lodiff_re
print mf_lodiff_im
print mf_if_re
print mf_if_im
print mf_loif_re
print mf_loif_im
print mf_lorf_re
print mf_lorf_im
print mf_flifa_re
print mf_flifa_im
print mf_flifb_re
print mf_flifb_im
print mf_fllorf_re
print mf_fllorf_im
print mf_flloif_re
print mf_flloif_im
destroy all
echo "MFEND ls_f21p20_m18_rf66"
echo "MFRUN ls_f21p20_m15_rf60"
alterparam f1 = 21200000000.0
alterparam f2 = 21200000000.0
alterparam flo = 20200000000.0
alterparam vrf1 = 0.0006324555320336759
alterparam vrf2 = 0.0
alterparam vlo = 0.15905414575341015
reset
op
let mf_dcirail = 0 - i(vdd)
let mf_dc_vce_q1 = v(c_q1)-v(e_q1)
let mf_dc_vbe_q1 = v(b_q1)-v(e_q1)
let mf_dc_ic_q1 = i(vic_q1)
let mf_dc_vce_q2 = v(c_q2)-v(e_q2)
let mf_dc_vbe_q2 = v(b_q2)-v(e_q2)
let mf_dc_ic_q2 = i(vic_q2)
let mf_dc_vce_q3 = v(c_q3)-v(x1)
let mf_dc_vbe_q3 = v(lo_p)-v(x1)
let mf_dc_ic_q3 = i(vic_q3)
let mf_dc_vce_q4 = v(c_q4)-v(x1)
let mf_dc_vbe_q4 = v(lo_n)-v(x1)
let mf_dc_ic_q4 = i(vic_q4)
let mf_dc_vce_q5 = v(c_q5)-v(x2)
let mf_dc_vbe_q5 = v(lo_p)-v(x2)
let mf_dc_ic_q5 = i(vic_q5)
let mf_dc_vce_q6 = v(c_q6)-v(x2)
let mf_dc_vbe_q6 = v(lo_n)-v(x2)
let mf_dc_ic_q6 = i(vic_q6)
let mf_dc_sink_tail = v(tail)
print mf_dcirail
print mf_dc_vce_q1
print mf_dc_vbe_q1
print mf_dc_ic_q1
print mf_dc_vce_q2
print mf_dc_vbe_q2
print mf_dc_ic_q2
print mf_dc_vce_q3
print mf_dc_vbe_q3
print mf_dc_ic_q3
print mf_dc_vce_q4
print mf_dc_vbe_q4
print mf_dc_ic_q4
print mf_dc_vce_q5
print mf_dc_vbe_q5
print mf_dc_ic_q5
print mf_dc_vce_q6
print mf_dc_vbe_q6
print mf_dc_ic_q6
print mf_dc_sink_tail
tran 1e-12 4e-08 0 1e-12
let mfq_vce_q1 = v(c_q1)-v(e_q1)
meas tran mf_su_vcemax_q1 MAX mfq_vce_q1 from=0.0 to=2e-08
meas tran mf_su_vcemin_q1 MIN mfq_vce_q1 from=0.0 to=2e-08
meas tran mf_ss_vcemax_q1 MAX mfq_vce_q1 from=2e-08 to=4e-08
meas tran mf_ss_vcemin_q1 MIN mfq_vce_q1 from=2e-08 to=4e-08
let mfq_vbe_q1 = v(b_q1)-v(e_q1)
meas tran mf_su_vbemax_q1 MAX mfq_vbe_q1 from=0.0 to=2e-08
meas tran mf_su_vbemin_q1 MIN mfq_vbe_q1 from=0.0 to=2e-08
meas tran mf_ss_vbemax_q1 MAX mfq_vbe_q1 from=2e-08 to=4e-08
meas tran mf_ss_vbemin_q1 MIN mfq_vbe_q1 from=2e-08 to=4e-08
let mfq_ic_q1 = i(vic_q1)
meas tran mf_su_icmax_q1 MAX mfq_ic_q1 from=0.0 to=2e-08
meas tran mf_su_icmin_q1 MIN mfq_ic_q1 from=0.0 to=2e-08
meas tran mf_ss_icmax_q1 MAX mfq_ic_q1 from=2e-08 to=4e-08
meas tran mf_ss_icmin_q1 MIN mfq_ic_q1 from=2e-08 to=4e-08
let mfq_vce_q2 = v(c_q2)-v(e_q2)
meas tran mf_su_vcemax_q2 MAX mfq_vce_q2 from=0.0 to=2e-08
meas tran mf_su_vcemin_q2 MIN mfq_vce_q2 from=0.0 to=2e-08
meas tran mf_ss_vcemax_q2 MAX mfq_vce_q2 from=2e-08 to=4e-08
meas tran mf_ss_vcemin_q2 MIN mfq_vce_q2 from=2e-08 to=4e-08
let mfq_vbe_q2 = v(b_q2)-v(e_q2)
meas tran mf_su_vbemax_q2 MAX mfq_vbe_q2 from=0.0 to=2e-08
meas tran mf_su_vbemin_q2 MIN mfq_vbe_q2 from=0.0 to=2e-08
meas tran mf_ss_vbemax_q2 MAX mfq_vbe_q2 from=2e-08 to=4e-08
meas tran mf_ss_vbemin_q2 MIN mfq_vbe_q2 from=2e-08 to=4e-08
let mfq_ic_q2 = i(vic_q2)
meas tran mf_su_icmax_q2 MAX mfq_ic_q2 from=0.0 to=2e-08
meas tran mf_su_icmin_q2 MIN mfq_ic_q2 from=0.0 to=2e-08
meas tran mf_ss_icmax_q2 MAX mfq_ic_q2 from=2e-08 to=4e-08
meas tran mf_ss_icmin_q2 MIN mfq_ic_q2 from=2e-08 to=4e-08
let mfq_vce_q3 = v(c_q3)-v(x1)
meas tran mf_su_vcemax_q3 MAX mfq_vce_q3 from=0.0 to=2e-08
meas tran mf_su_vcemin_q3 MIN mfq_vce_q3 from=0.0 to=2e-08
meas tran mf_ss_vcemax_q3 MAX mfq_vce_q3 from=2e-08 to=4e-08
meas tran mf_ss_vcemin_q3 MIN mfq_vce_q3 from=2e-08 to=4e-08
let mfq_vbe_q3 = v(lo_p)-v(x1)
meas tran mf_su_vbemax_q3 MAX mfq_vbe_q3 from=0.0 to=2e-08
meas tran mf_su_vbemin_q3 MIN mfq_vbe_q3 from=0.0 to=2e-08
meas tran mf_ss_vbemax_q3 MAX mfq_vbe_q3 from=2e-08 to=4e-08
meas tran mf_ss_vbemin_q3 MIN mfq_vbe_q3 from=2e-08 to=4e-08
let mfq_ic_q3 = i(vic_q3)
meas tran mf_su_icmax_q3 MAX mfq_ic_q3 from=0.0 to=2e-08
meas tran mf_su_icmin_q3 MIN mfq_ic_q3 from=0.0 to=2e-08
meas tran mf_ss_icmax_q3 MAX mfq_ic_q3 from=2e-08 to=4e-08
meas tran mf_ss_icmin_q3 MIN mfq_ic_q3 from=2e-08 to=4e-08
let mfq_vce_q4 = v(c_q4)-v(x1)
meas tran mf_su_vcemax_q4 MAX mfq_vce_q4 from=0.0 to=2e-08
meas tran mf_su_vcemin_q4 MIN mfq_vce_q4 from=0.0 to=2e-08
meas tran mf_ss_vcemax_q4 MAX mfq_vce_q4 from=2e-08 to=4e-08
meas tran mf_ss_vcemin_q4 MIN mfq_vce_q4 from=2e-08 to=4e-08
let mfq_vbe_q4 = v(lo_n)-v(x1)
meas tran mf_su_vbemax_q4 MAX mfq_vbe_q4 from=0.0 to=2e-08
meas tran mf_su_vbemin_q4 MIN mfq_vbe_q4 from=0.0 to=2e-08
meas tran mf_ss_vbemax_q4 MAX mfq_vbe_q4 from=2e-08 to=4e-08
meas tran mf_ss_vbemin_q4 MIN mfq_vbe_q4 from=2e-08 to=4e-08
let mfq_ic_q4 = i(vic_q4)
meas tran mf_su_icmax_q4 MAX mfq_ic_q4 from=0.0 to=2e-08
meas tran mf_su_icmin_q4 MIN mfq_ic_q4 from=0.0 to=2e-08
meas tran mf_ss_icmax_q4 MAX mfq_ic_q4 from=2e-08 to=4e-08
meas tran mf_ss_icmin_q4 MIN mfq_ic_q4 from=2e-08 to=4e-08
let mfq_vce_q5 = v(c_q5)-v(x2)
meas tran mf_su_vcemax_q5 MAX mfq_vce_q5 from=0.0 to=2e-08
meas tran mf_su_vcemin_q5 MIN mfq_vce_q5 from=0.0 to=2e-08
meas tran mf_ss_vcemax_q5 MAX mfq_vce_q5 from=2e-08 to=4e-08
meas tran mf_ss_vcemin_q5 MIN mfq_vce_q5 from=2e-08 to=4e-08
let mfq_vbe_q5 = v(lo_p)-v(x2)
meas tran mf_su_vbemax_q5 MAX mfq_vbe_q5 from=0.0 to=2e-08
meas tran mf_su_vbemin_q5 MIN mfq_vbe_q5 from=0.0 to=2e-08
meas tran mf_ss_vbemax_q5 MAX mfq_vbe_q5 from=2e-08 to=4e-08
meas tran mf_ss_vbemin_q5 MIN mfq_vbe_q5 from=2e-08 to=4e-08
let mfq_ic_q5 = i(vic_q5)
meas tran mf_su_icmax_q5 MAX mfq_ic_q5 from=0.0 to=2e-08
meas tran mf_su_icmin_q5 MIN mfq_ic_q5 from=0.0 to=2e-08
meas tran mf_ss_icmax_q5 MAX mfq_ic_q5 from=2e-08 to=4e-08
meas tran mf_ss_icmin_q5 MIN mfq_ic_q5 from=2e-08 to=4e-08
let mfq_vce_q6 = v(c_q6)-v(x2)
meas tran mf_su_vcemax_q6 MAX mfq_vce_q6 from=0.0 to=2e-08
meas tran mf_su_vcemin_q6 MIN mfq_vce_q6 from=0.0 to=2e-08
meas tran mf_ss_vcemax_q6 MAX mfq_vce_q6 from=2e-08 to=4e-08
meas tran mf_ss_vcemin_q6 MIN mfq_vce_q6 from=2e-08 to=4e-08
let mfq_vbe_q6 = v(lo_n)-v(x2)
meas tran mf_su_vbemax_q6 MAX mfq_vbe_q6 from=0.0 to=2e-08
meas tran mf_su_vbemin_q6 MIN mfq_vbe_q6 from=0.0 to=2e-08
meas tran mf_ss_vbemax_q6 MAX mfq_vbe_q6 from=2e-08 to=4e-08
meas tran mf_ss_vbemin_q6 MIN mfq_vbe_q6 from=2e-08 to=4e-08
let mfq_ic_q6 = i(vic_q6)
meas tran mf_su_icmax_q6 MAX mfq_ic_q6 from=0.0 to=2e-08
meas tran mf_su_icmin_q6 MIN mfq_ic_q6 from=0.0 to=2e-08
meas tran mf_ss_icmax_q6 MAX mfq_ic_q6 from=2e-08 to=4e-08
meas tran mf_ss_icmin_q6 MIN mfq_ic_q6 from=2e-08 to=4e-08
meas tran mf_su_sinkmin_tail MIN v(tail) from=0.0 to=2e-08
meas tran mf_ss_sinkmin_tail MIN v(tail) from=2e-08 to=4e-08
print mf_su_vcemax_q1
print mf_su_vcemin_q1
print mf_ss_vcemax_q1
print mf_ss_vcemin_q1
print mf_su_vbemax_q1
print mf_su_vbemin_q1
print mf_ss_vbemax_q1
print mf_ss_vbemin_q1
print mf_su_icmax_q1
print mf_su_icmin_q1
print mf_ss_icmax_q1
print mf_ss_icmin_q1
print mf_su_vcemax_q2
print mf_su_vcemin_q2
print mf_ss_vcemax_q2
print mf_ss_vcemin_q2
print mf_su_vbemax_q2
print mf_su_vbemin_q2
print mf_ss_vbemax_q2
print mf_ss_vbemin_q2
print mf_su_icmax_q2
print mf_su_icmin_q2
print mf_ss_icmax_q2
print mf_ss_icmin_q2
print mf_su_vcemax_q3
print mf_su_vcemin_q3
print mf_ss_vcemax_q3
print mf_ss_vcemin_q3
print mf_su_vbemax_q3
print mf_su_vbemin_q3
print mf_ss_vbemax_q3
print mf_ss_vbemin_q3
print mf_su_icmax_q3
print mf_su_icmin_q3
print mf_ss_icmax_q3
print mf_ss_icmin_q3
print mf_su_vcemax_q4
print mf_su_vcemin_q4
print mf_ss_vcemax_q4
print mf_ss_vcemin_q4
print mf_su_vbemax_q4
print mf_su_vbemin_q4
print mf_ss_vbemax_q4
print mf_ss_vbemin_q4
print mf_su_icmax_q4
print mf_su_icmin_q4
print mf_ss_icmax_q4
print mf_ss_icmin_q4
print mf_su_vcemax_q5
print mf_su_vcemin_q5
print mf_ss_vcemax_q5
print mf_ss_vcemin_q5
print mf_su_vbemax_q5
print mf_su_vbemin_q5
print mf_ss_vbemax_q5
print mf_ss_vbemin_q5
print mf_su_icmax_q5
print mf_su_icmin_q5
print mf_ss_icmax_q5
print mf_ss_icmin_q5
print mf_su_vcemax_q6
print mf_su_vcemin_q6
print mf_ss_vcemax_q6
print mf_ss_vcemin_q6
print mf_su_vbemax_q6
print mf_su_vbemin_q6
print mf_ss_vbemax_q6
print mf_ss_vbemin_q6
print mf_su_icmax_q6
print mf_su_icmin_q6
print mf_ss_icmax_q6
print mf_ss_icmin_q6
print mf_su_sinkmin_tail
print mf_ss_sinkmin_tail
linearize
let mf_l = length(time)
let mfw = (time ge 1.99995e-08) * (time lt 3.99995e-08)
let mf_n = mean(mfw) * mf_l
let mfs = mf_l / mf_n
let mf_prail = mean(v(vdd) * (0 - i(vdd)) * mfw) * mfs
let mfph = 2 * pi * 20200000000.0 * (time - 2e-08)
let mf_lodiff_re = 2 * mean((v(lo_p)-v(lo_n)) * mfw * cos(mfph)) * mfs
let mf_lodiff_im = 2 * mean((v(lo_p)-v(lo_n)) * mfw * sin(mfph)) * mfs
let mfph = 2 * pi * 1000000000.0 * (time - 2e-08)
let mf_if_re = 2 * mean((v(if_out)) * mfw * cos(mfph)) * mfs
let mf_if_im = 2 * mean((v(if_out)) * mfw * sin(mfph)) * mfs
let mfph = 2 * pi * 20200000000.0 * (time - 2e-08)
let mf_loif_re = 2 * mean((v(if_out)) * mfw * cos(mfph)) * mfs
let mf_loif_im = 2 * mean((v(if_out)) * mfw * sin(mfph)) * mfs
let mfph = 2 * pi * 20200000000.0 * (time - 2e-08)
let mf_lorf_re = 2 * mean((v(rf_port)) * mfw * cos(mfph)) * mfs
let mf_lorf_im = 2 * mean((v(rf_port)) * mfw * sin(mfph)) * mfs
let mfph = 2 * pi * 950000000.0 * (time - 2e-08)
let mf_flifa_re = 2 * mean((v(if_out)) * mfw * cos(mfph)) * mfs
let mf_flifa_im = 2 * mean((v(if_out)) * mfw * sin(mfph)) * mfs
let mfph = 2 * pi * 1050000000.0 * (time - 2e-08)
let mf_flifb_re = 2 * mean((v(if_out)) * mfw * cos(mfph)) * mfs
let mf_flifb_im = 2 * mean((v(if_out)) * mfw * sin(mfph)) * mfs
let mfph = 2 * pi * 20250000000.0 * (time - 2e-08)
let mf_fllorf_re = 2 * mean((v(rf_port)) * mfw * cos(mfph)) * mfs
let mf_fllorf_im = 2 * mean((v(rf_port)) * mfw * sin(mfph)) * mfs
let mfph = 2 * pi * 20250000000.0 * (time - 2e-08)
let mf_flloif_re = 2 * mean((v(if_out)) * mfw * cos(mfph)) * mfs
let mf_flloif_im = 2 * mean((v(if_out)) * mfw * sin(mfph)) * mfs
print mf_l
print mf_n
print mf_prail
print mf_lodiff_re
print mf_lodiff_im
print mf_if_re
print mf_if_im
print mf_loif_re
print mf_loif_im
print mf_lorf_re
print mf_lorf_im
print mf_flifa_re
print mf_flifa_im
print mf_flifb_re
print mf_flifb_im
print mf_fllorf_re
print mf_fllorf_im
print mf_flloif_re
print mf_flloif_im
destroy all
echo "MFEND ls_f21p20_m15_rf60"
echo "MFRUN ls_f21p20_m15_rf66"
alterparam f1 = 21200000000.0
alterparam f2 = 21200000000.0
alterparam flo = 20200000000.0
alterparam vrf1 = 0.00031697863849222284
alterparam vrf2 = 0.0
alterparam vlo = 0.15905414575341015
reset
op
let mf_dcirail = 0 - i(vdd)
let mf_dc_vce_q1 = v(c_q1)-v(e_q1)
let mf_dc_vbe_q1 = v(b_q1)-v(e_q1)
let mf_dc_ic_q1 = i(vic_q1)
let mf_dc_vce_q2 = v(c_q2)-v(e_q2)
let mf_dc_vbe_q2 = v(b_q2)-v(e_q2)
let mf_dc_ic_q2 = i(vic_q2)
let mf_dc_vce_q3 = v(c_q3)-v(x1)
let mf_dc_vbe_q3 = v(lo_p)-v(x1)
let mf_dc_ic_q3 = i(vic_q3)
let mf_dc_vce_q4 = v(c_q4)-v(x1)
let mf_dc_vbe_q4 = v(lo_n)-v(x1)
let mf_dc_ic_q4 = i(vic_q4)
let mf_dc_vce_q5 = v(c_q5)-v(x2)
let mf_dc_vbe_q5 = v(lo_p)-v(x2)
let mf_dc_ic_q5 = i(vic_q5)
let mf_dc_vce_q6 = v(c_q6)-v(x2)
let mf_dc_vbe_q6 = v(lo_n)-v(x2)
let mf_dc_ic_q6 = i(vic_q6)
let mf_dc_sink_tail = v(tail)
print mf_dcirail
print mf_dc_vce_q1
print mf_dc_vbe_q1
print mf_dc_ic_q1
print mf_dc_vce_q2
print mf_dc_vbe_q2
print mf_dc_ic_q2
print mf_dc_vce_q3
print mf_dc_vbe_q3
print mf_dc_ic_q3
print mf_dc_vce_q4
print mf_dc_vbe_q4
print mf_dc_ic_q4
print mf_dc_vce_q5
print mf_dc_vbe_q5
print mf_dc_ic_q5
print mf_dc_vce_q6
print mf_dc_vbe_q6
print mf_dc_ic_q6
print mf_dc_sink_tail
tran 1e-12 4e-08 0 1e-12
let mfq_vce_q1 = v(c_q1)-v(e_q1)
meas tran mf_su_vcemax_q1 MAX mfq_vce_q1 from=0.0 to=2e-08
meas tran mf_su_vcemin_q1 MIN mfq_vce_q1 from=0.0 to=2e-08
meas tran mf_ss_vcemax_q1 MAX mfq_vce_q1 from=2e-08 to=4e-08
meas tran mf_ss_vcemin_q1 MIN mfq_vce_q1 from=2e-08 to=4e-08
let mfq_vbe_q1 = v(b_q1)-v(e_q1)
meas tran mf_su_vbemax_q1 MAX mfq_vbe_q1 from=0.0 to=2e-08
meas tran mf_su_vbemin_q1 MIN mfq_vbe_q1 from=0.0 to=2e-08
meas tran mf_ss_vbemax_q1 MAX mfq_vbe_q1 from=2e-08 to=4e-08
meas tran mf_ss_vbemin_q1 MIN mfq_vbe_q1 from=2e-08 to=4e-08
let mfq_ic_q1 = i(vic_q1)
meas tran mf_su_icmax_q1 MAX mfq_ic_q1 from=0.0 to=2e-08
meas tran mf_su_icmin_q1 MIN mfq_ic_q1 from=0.0 to=2e-08
meas tran mf_ss_icmax_q1 MAX mfq_ic_q1 from=2e-08 to=4e-08
meas tran mf_ss_icmin_q1 MIN mfq_ic_q1 from=2e-08 to=4e-08
let mfq_vce_q2 = v(c_q2)-v(e_q2)
meas tran mf_su_vcemax_q2 MAX mfq_vce_q2 from=0.0 to=2e-08
meas tran mf_su_vcemin_q2 MIN mfq_vce_q2 from=0.0 to=2e-08
meas tran mf_ss_vcemax_q2 MAX mfq_vce_q2 from=2e-08 to=4e-08
meas tran mf_ss_vcemin_q2 MIN mfq_vce_q2 from=2e-08 to=4e-08
let mfq_vbe_q2 = v(b_q2)-v(e_q2)
meas tran mf_su_vbemax_q2 MAX mfq_vbe_q2 from=0.0 to=2e-08
meas tran mf_su_vbemin_q2 MIN mfq_vbe_q2 from=0.0 to=2e-08
meas tran mf_ss_vbemax_q2 MAX mfq_vbe_q2 from=2e-08 to=4e-08
meas tran mf_ss_vbemin_q2 MIN mfq_vbe_q2 from=2e-08 to=4e-08
let mfq_ic_q2 = i(vic_q2)
meas tran mf_su_icmax_q2 MAX mfq_ic_q2 from=0.0 to=2e-08
meas tran mf_su_icmin_q2 MIN mfq_ic_q2 from=0.0 to=2e-08
meas tran mf_ss_icmax_q2 MAX mfq_ic_q2 from=2e-08 to=4e-08
meas tran mf_ss_icmin_q2 MIN mfq_ic_q2 from=2e-08 to=4e-08
let mfq_vce_q3 = v(c_q3)-v(x1)
meas tran mf_su_vcemax_q3 MAX mfq_vce_q3 from=0.0 to=2e-08
meas tran mf_su_vcemin_q3 MIN mfq_vce_q3 from=0.0 to=2e-08
meas tran mf_ss_vcemax_q3 MAX mfq_vce_q3 from=2e-08 to=4e-08
meas tran mf_ss_vcemin_q3 MIN mfq_vce_q3 from=2e-08 to=4e-08
let mfq_vbe_q3 = v(lo_p)-v(x1)
meas tran mf_su_vbemax_q3 MAX mfq_vbe_q3 from=0.0 to=2e-08
meas tran mf_su_vbemin_q3 MIN mfq_vbe_q3 from=0.0 to=2e-08
meas tran mf_ss_vbemax_q3 MAX mfq_vbe_q3 from=2e-08 to=4e-08
meas tran mf_ss_vbemin_q3 MIN mfq_vbe_q3 from=2e-08 to=4e-08
let mfq_ic_q3 = i(vic_q3)
meas tran mf_su_icmax_q3 MAX mfq_ic_q3 from=0.0 to=2e-08
meas tran mf_su_icmin_q3 MIN mfq_ic_q3 from=0.0 to=2e-08
meas tran mf_ss_icmax_q3 MAX mfq_ic_q3 from=2e-08 to=4e-08
meas tran mf_ss_icmin_q3 MIN mfq_ic_q3 from=2e-08 to=4e-08
let mfq_vce_q4 = v(c_q4)-v(x1)
meas tran mf_su_vcemax_q4 MAX mfq_vce_q4 from=0.0 to=2e-08
meas tran mf_su_vcemin_q4 MIN mfq_vce_q4 from=0.0 to=2e-08
meas tran mf_ss_vcemax_q4 MAX mfq_vce_q4 from=2e-08 to=4e-08
meas tran mf_ss_vcemin_q4 MIN mfq_vce_q4 from=2e-08 to=4e-08
let mfq_vbe_q4 = v(lo_n)-v(x1)
meas tran mf_su_vbemax_q4 MAX mfq_vbe_q4 from=0.0 to=2e-08
meas tran mf_su_vbemin_q4 MIN mfq_vbe_q4 from=0.0 to=2e-08
meas tran mf_ss_vbemax_q4 MAX mfq_vbe_q4 from=2e-08 to=4e-08
meas tran mf_ss_vbemin_q4 MIN mfq_vbe_q4 from=2e-08 to=4e-08
let mfq_ic_q4 = i(vic_q4)
meas tran mf_su_icmax_q4 MAX mfq_ic_q4 from=0.0 to=2e-08
meas tran mf_su_icmin_q4 MIN mfq_ic_q4 from=0.0 to=2e-08
meas tran mf_ss_icmax_q4 MAX mfq_ic_q4 from=2e-08 to=4e-08
meas tran mf_ss_icmin_q4 MIN mfq_ic_q4 from=2e-08 to=4e-08
let mfq_vce_q5 = v(c_q5)-v(x2)
meas tran mf_su_vcemax_q5 MAX mfq_vce_q5 from=0.0 to=2e-08
meas tran mf_su_vcemin_q5 MIN mfq_vce_q5 from=0.0 to=2e-08
meas tran mf_ss_vcemax_q5 MAX mfq_vce_q5 from=2e-08 to=4e-08
meas tran mf_ss_vcemin_q5 MIN mfq_vce_q5 from=2e-08 to=4e-08
let mfq_vbe_q5 = v(lo_p)-v(x2)
meas tran mf_su_vbemax_q5 MAX mfq_vbe_q5 from=0.0 to=2e-08
meas tran mf_su_vbemin_q5 MIN mfq_vbe_q5 from=0.0 to=2e-08
meas tran mf_ss_vbemax_q5 MAX mfq_vbe_q5 from=2e-08 to=4e-08
meas tran mf_ss_vbemin_q5 MIN mfq_vbe_q5 from=2e-08 to=4e-08
let mfq_ic_q5 = i(vic_q5)
meas tran mf_su_icmax_q5 MAX mfq_ic_q5 from=0.0 to=2e-08
meas tran mf_su_icmin_q5 MIN mfq_ic_q5 from=0.0 to=2e-08
meas tran mf_ss_icmax_q5 MAX mfq_ic_q5 from=2e-08 to=4e-08
meas tran mf_ss_icmin_q5 MIN mfq_ic_q5 from=2e-08 to=4e-08
let mfq_vce_q6 = v(c_q6)-v(x2)
meas tran mf_su_vcemax_q6 MAX mfq_vce_q6 from=0.0 to=2e-08
meas tran mf_su_vcemin_q6 MIN mfq_vce_q6 from=0.0 to=2e-08
meas tran mf_ss_vcemax_q6 MAX mfq_vce_q6 from=2e-08 to=4e-08
meas tran mf_ss_vcemin_q6 MIN mfq_vce_q6 from=2e-08 to=4e-08
let mfq_vbe_q6 = v(lo_n)-v(x2)
meas tran mf_su_vbemax_q6 MAX mfq_vbe_q6 from=0.0 to=2e-08
meas tran mf_su_vbemin_q6 MIN mfq_vbe_q6 from=0.0 to=2e-08
meas tran mf_ss_vbemax_q6 MAX mfq_vbe_q6 from=2e-08 to=4e-08
meas tran mf_ss_vbemin_q6 MIN mfq_vbe_q6 from=2e-08 to=4e-08
let mfq_ic_q6 = i(vic_q6)
meas tran mf_su_icmax_q6 MAX mfq_ic_q6 from=0.0 to=2e-08
meas tran mf_su_icmin_q6 MIN mfq_ic_q6 from=0.0 to=2e-08
meas tran mf_ss_icmax_q6 MAX mfq_ic_q6 from=2e-08 to=4e-08
meas tran mf_ss_icmin_q6 MIN mfq_ic_q6 from=2e-08 to=4e-08
meas tran mf_su_sinkmin_tail MIN v(tail) from=0.0 to=2e-08
meas tran mf_ss_sinkmin_tail MIN v(tail) from=2e-08 to=4e-08
print mf_su_vcemax_q1
print mf_su_vcemin_q1
print mf_ss_vcemax_q1
print mf_ss_vcemin_q1
print mf_su_vbemax_q1
print mf_su_vbemin_q1
print mf_ss_vbemax_q1
print mf_ss_vbemin_q1
print mf_su_icmax_q1
print mf_su_icmin_q1
print mf_ss_icmax_q1
print mf_ss_icmin_q1
print mf_su_vcemax_q2
print mf_su_vcemin_q2
print mf_ss_vcemax_q2
print mf_ss_vcemin_q2
print mf_su_vbemax_q2
print mf_su_vbemin_q2
print mf_ss_vbemax_q2
print mf_ss_vbemin_q2
print mf_su_icmax_q2
print mf_su_icmin_q2
print mf_ss_icmax_q2
print mf_ss_icmin_q2
print mf_su_vcemax_q3
print mf_su_vcemin_q3
print mf_ss_vcemax_q3
print mf_ss_vcemin_q3
print mf_su_vbemax_q3
print mf_su_vbemin_q3
print mf_ss_vbemax_q3
print mf_ss_vbemin_q3
print mf_su_icmax_q3
print mf_su_icmin_q3
print mf_ss_icmax_q3
print mf_ss_icmin_q3
print mf_su_vcemax_q4
print mf_su_vcemin_q4
print mf_ss_vcemax_q4
print mf_ss_vcemin_q4
print mf_su_vbemax_q4
print mf_su_vbemin_q4
print mf_ss_vbemax_q4
print mf_ss_vbemin_q4
print mf_su_icmax_q4
print mf_su_icmin_q4
print mf_ss_icmax_q4
print mf_ss_icmin_q4
print mf_su_vcemax_q5
print mf_su_vcemin_q5
print mf_ss_vcemax_q5
print mf_ss_vcemin_q5
print mf_su_vbemax_q5
print mf_su_vbemin_q5
print mf_ss_vbemax_q5
print mf_ss_vbemin_q5
print mf_su_icmax_q5
print mf_su_icmin_q5
print mf_ss_icmax_q5
print mf_ss_icmin_q5
print mf_su_vcemax_q6
print mf_su_vcemin_q6
print mf_ss_vcemax_q6
print mf_ss_vcemin_q6
print mf_su_vbemax_q6
print mf_su_vbemin_q6
print mf_ss_vbemax_q6
print mf_ss_vbemin_q6
print mf_su_icmax_q6
print mf_su_icmin_q6
print mf_ss_icmax_q6
print mf_ss_icmin_q6
print mf_su_sinkmin_tail
print mf_ss_sinkmin_tail
linearize
let mf_l = length(time)
let mfw = (time ge 1.99995e-08) * (time lt 3.99995e-08)
let mf_n = mean(mfw) * mf_l
let mfs = mf_l / mf_n
let mf_prail = mean(v(vdd) * (0 - i(vdd)) * mfw) * mfs
let mfph = 2 * pi * 20200000000.0 * (time - 2e-08)
let mf_lodiff_re = 2 * mean((v(lo_p)-v(lo_n)) * mfw * cos(mfph)) * mfs
let mf_lodiff_im = 2 * mean((v(lo_p)-v(lo_n)) * mfw * sin(mfph)) * mfs
let mfph = 2 * pi * 1000000000.0 * (time - 2e-08)
let mf_if_re = 2 * mean((v(if_out)) * mfw * cos(mfph)) * mfs
let mf_if_im = 2 * mean((v(if_out)) * mfw * sin(mfph)) * mfs
let mfph = 2 * pi * 20200000000.0 * (time - 2e-08)
let mf_loif_re = 2 * mean((v(if_out)) * mfw * cos(mfph)) * mfs
let mf_loif_im = 2 * mean((v(if_out)) * mfw * sin(mfph)) * mfs
let mfph = 2 * pi * 20200000000.0 * (time - 2e-08)
let mf_lorf_re = 2 * mean((v(rf_port)) * mfw * cos(mfph)) * mfs
let mf_lorf_im = 2 * mean((v(rf_port)) * mfw * sin(mfph)) * mfs
let mfph = 2 * pi * 950000000.0 * (time - 2e-08)
let mf_flifa_re = 2 * mean((v(if_out)) * mfw * cos(mfph)) * mfs
let mf_flifa_im = 2 * mean((v(if_out)) * mfw * sin(mfph)) * mfs
let mfph = 2 * pi * 1050000000.0 * (time - 2e-08)
let mf_flifb_re = 2 * mean((v(if_out)) * mfw * cos(mfph)) * mfs
let mf_flifb_im = 2 * mean((v(if_out)) * mfw * sin(mfph)) * mfs
let mfph = 2 * pi * 20250000000.0 * (time - 2e-08)
let mf_fllorf_re = 2 * mean((v(rf_port)) * mfw * cos(mfph)) * mfs
let mf_fllorf_im = 2 * mean((v(rf_port)) * mfw * sin(mfph)) * mfs
let mfph = 2 * pi * 20250000000.0 * (time - 2e-08)
let mf_flloif_re = 2 * mean((v(if_out)) * mfw * cos(mfph)) * mfs
let mf_flloif_im = 2 * mean((v(if_out)) * mfw * sin(mfph)) * mfs
print mf_l
print mf_n
print mf_prail
print mf_lodiff_re
print mf_lodiff_im
print mf_if_re
print mf_if_im
print mf_loif_re
print mf_loif_im
print mf_lorf_re
print mf_lorf_im
print mf_flifa_re
print mf_flifa_im
print mf_flifb_re
print mf_flifb_im
print mf_fllorf_re
print mf_fllorf_im
print mf_flloif_re
print mf_flloif_im
destroy all
echo "MFEND ls_f21p20_m15_rf66"
echo "MFRUN ls_f21p20_m12_rf60"
alterparam f1 = 21200000000.0
alterparam f2 = 21200000000.0
alterparam flo = 20200000000.0
alterparam vrf1 = 0.0006324555320336759
alterparam vrf2 = 0.0
alterparam vlo = 0.22466995250459165
reset
op
let mf_dcirail = 0 - i(vdd)
let mf_dc_vce_q1 = v(c_q1)-v(e_q1)
let mf_dc_vbe_q1 = v(b_q1)-v(e_q1)
let mf_dc_ic_q1 = i(vic_q1)
let mf_dc_vce_q2 = v(c_q2)-v(e_q2)
let mf_dc_vbe_q2 = v(b_q2)-v(e_q2)
let mf_dc_ic_q2 = i(vic_q2)
let mf_dc_vce_q3 = v(c_q3)-v(x1)
let mf_dc_vbe_q3 = v(lo_p)-v(x1)
let mf_dc_ic_q3 = i(vic_q3)
let mf_dc_vce_q4 = v(c_q4)-v(x1)
let mf_dc_vbe_q4 = v(lo_n)-v(x1)
let mf_dc_ic_q4 = i(vic_q4)
let mf_dc_vce_q5 = v(c_q5)-v(x2)
let mf_dc_vbe_q5 = v(lo_p)-v(x2)
let mf_dc_ic_q5 = i(vic_q5)
let mf_dc_vce_q6 = v(c_q6)-v(x2)
let mf_dc_vbe_q6 = v(lo_n)-v(x2)
let mf_dc_ic_q6 = i(vic_q6)
let mf_dc_sink_tail = v(tail)
print mf_dcirail
print mf_dc_vce_q1
print mf_dc_vbe_q1
print mf_dc_ic_q1
print mf_dc_vce_q2
print mf_dc_vbe_q2
print mf_dc_ic_q2
print mf_dc_vce_q3
print mf_dc_vbe_q3
print mf_dc_ic_q3
print mf_dc_vce_q4
print mf_dc_vbe_q4
print mf_dc_ic_q4
print mf_dc_vce_q5
print mf_dc_vbe_q5
print mf_dc_ic_q5
print mf_dc_vce_q6
print mf_dc_vbe_q6
print mf_dc_ic_q6
print mf_dc_sink_tail
tran 1e-12 4e-08 0 1e-12
let mfq_vce_q1 = v(c_q1)-v(e_q1)
meas tran mf_su_vcemax_q1 MAX mfq_vce_q1 from=0.0 to=2e-08
meas tran mf_su_vcemin_q1 MIN mfq_vce_q1 from=0.0 to=2e-08
meas tran mf_ss_vcemax_q1 MAX mfq_vce_q1 from=2e-08 to=4e-08
meas tran mf_ss_vcemin_q1 MIN mfq_vce_q1 from=2e-08 to=4e-08
let mfq_vbe_q1 = v(b_q1)-v(e_q1)
meas tran mf_su_vbemax_q1 MAX mfq_vbe_q1 from=0.0 to=2e-08
meas tran mf_su_vbemin_q1 MIN mfq_vbe_q1 from=0.0 to=2e-08
meas tran mf_ss_vbemax_q1 MAX mfq_vbe_q1 from=2e-08 to=4e-08
meas tran mf_ss_vbemin_q1 MIN mfq_vbe_q1 from=2e-08 to=4e-08
let mfq_ic_q1 = i(vic_q1)
meas tran mf_su_icmax_q1 MAX mfq_ic_q1 from=0.0 to=2e-08
meas tran mf_su_icmin_q1 MIN mfq_ic_q1 from=0.0 to=2e-08
meas tran mf_ss_icmax_q1 MAX mfq_ic_q1 from=2e-08 to=4e-08
meas tran mf_ss_icmin_q1 MIN mfq_ic_q1 from=2e-08 to=4e-08
let mfq_vce_q2 = v(c_q2)-v(e_q2)
meas tran mf_su_vcemax_q2 MAX mfq_vce_q2 from=0.0 to=2e-08
meas tran mf_su_vcemin_q2 MIN mfq_vce_q2 from=0.0 to=2e-08
meas tran mf_ss_vcemax_q2 MAX mfq_vce_q2 from=2e-08 to=4e-08
meas tran mf_ss_vcemin_q2 MIN mfq_vce_q2 from=2e-08 to=4e-08
let mfq_vbe_q2 = v(b_q2)-v(e_q2)
meas tran mf_su_vbemax_q2 MAX mfq_vbe_q2 from=0.0 to=2e-08
meas tran mf_su_vbemin_q2 MIN mfq_vbe_q2 from=0.0 to=2e-08
meas tran mf_ss_vbemax_q2 MAX mfq_vbe_q2 from=2e-08 to=4e-08
meas tran mf_ss_vbemin_q2 MIN mfq_vbe_q2 from=2e-08 to=4e-08
let mfq_ic_q2 = i(vic_q2)
meas tran mf_su_icmax_q2 MAX mfq_ic_q2 from=0.0 to=2e-08
meas tran mf_su_icmin_q2 MIN mfq_ic_q2 from=0.0 to=2e-08
meas tran mf_ss_icmax_q2 MAX mfq_ic_q2 from=2e-08 to=4e-08
meas tran mf_ss_icmin_q2 MIN mfq_ic_q2 from=2e-08 to=4e-08
let mfq_vce_q3 = v(c_q3)-v(x1)
meas tran mf_su_vcemax_q3 MAX mfq_vce_q3 from=0.0 to=2e-08
meas tran mf_su_vcemin_q3 MIN mfq_vce_q3 from=0.0 to=2e-08
meas tran mf_ss_vcemax_q3 MAX mfq_vce_q3 from=2e-08 to=4e-08
meas tran mf_ss_vcemin_q3 MIN mfq_vce_q3 from=2e-08 to=4e-08
let mfq_vbe_q3 = v(lo_p)-v(x1)
meas tran mf_su_vbemax_q3 MAX mfq_vbe_q3 from=0.0 to=2e-08
meas tran mf_su_vbemin_q3 MIN mfq_vbe_q3 from=0.0 to=2e-08
meas tran mf_ss_vbemax_q3 MAX mfq_vbe_q3 from=2e-08 to=4e-08
meas tran mf_ss_vbemin_q3 MIN mfq_vbe_q3 from=2e-08 to=4e-08
let mfq_ic_q3 = i(vic_q3)
meas tran mf_su_icmax_q3 MAX mfq_ic_q3 from=0.0 to=2e-08
meas tran mf_su_icmin_q3 MIN mfq_ic_q3 from=0.0 to=2e-08
meas tran mf_ss_icmax_q3 MAX mfq_ic_q3 from=2e-08 to=4e-08
meas tran mf_ss_icmin_q3 MIN mfq_ic_q3 from=2e-08 to=4e-08
let mfq_vce_q4 = v(c_q4)-v(x1)
meas tran mf_su_vcemax_q4 MAX mfq_vce_q4 from=0.0 to=2e-08
meas tran mf_su_vcemin_q4 MIN mfq_vce_q4 from=0.0 to=2e-08
meas tran mf_ss_vcemax_q4 MAX mfq_vce_q4 from=2e-08 to=4e-08
meas tran mf_ss_vcemin_q4 MIN mfq_vce_q4 from=2e-08 to=4e-08
let mfq_vbe_q4 = v(lo_n)-v(x1)
meas tran mf_su_vbemax_q4 MAX mfq_vbe_q4 from=0.0 to=2e-08
meas tran mf_su_vbemin_q4 MIN mfq_vbe_q4 from=0.0 to=2e-08
meas tran mf_ss_vbemax_q4 MAX mfq_vbe_q4 from=2e-08 to=4e-08
meas tran mf_ss_vbemin_q4 MIN mfq_vbe_q4 from=2e-08 to=4e-08
let mfq_ic_q4 = i(vic_q4)
meas tran mf_su_icmax_q4 MAX mfq_ic_q4 from=0.0 to=2e-08
meas tran mf_su_icmin_q4 MIN mfq_ic_q4 from=0.0 to=2e-08
meas tran mf_ss_icmax_q4 MAX mfq_ic_q4 from=2e-08 to=4e-08
meas tran mf_ss_icmin_q4 MIN mfq_ic_q4 from=2e-08 to=4e-08
let mfq_vce_q5 = v(c_q5)-v(x2)
meas tran mf_su_vcemax_q5 MAX mfq_vce_q5 from=0.0 to=2e-08
meas tran mf_su_vcemin_q5 MIN mfq_vce_q5 from=0.0 to=2e-08
meas tran mf_ss_vcemax_q5 MAX mfq_vce_q5 from=2e-08 to=4e-08
meas tran mf_ss_vcemin_q5 MIN mfq_vce_q5 from=2e-08 to=4e-08
let mfq_vbe_q5 = v(lo_p)-v(x2)
meas tran mf_su_vbemax_q5 MAX mfq_vbe_q5 from=0.0 to=2e-08
meas tran mf_su_vbemin_q5 MIN mfq_vbe_q5 from=0.0 to=2e-08
meas tran mf_ss_vbemax_q5 MAX mfq_vbe_q5 from=2e-08 to=4e-08
meas tran mf_ss_vbemin_q5 MIN mfq_vbe_q5 from=2e-08 to=4e-08
let mfq_ic_q5 = i(vic_q5)
meas tran mf_su_icmax_q5 MAX mfq_ic_q5 from=0.0 to=2e-08
meas tran mf_su_icmin_q5 MIN mfq_ic_q5 from=0.0 to=2e-08
meas tran mf_ss_icmax_q5 MAX mfq_ic_q5 from=2e-08 to=4e-08
meas tran mf_ss_icmin_q5 MIN mfq_ic_q5 from=2e-08 to=4e-08
let mfq_vce_q6 = v(c_q6)-v(x2)
meas tran mf_su_vcemax_q6 MAX mfq_vce_q6 from=0.0 to=2e-08
meas tran mf_su_vcemin_q6 MIN mfq_vce_q6 from=0.0 to=2e-08
meas tran mf_ss_vcemax_q6 MAX mfq_vce_q6 from=2e-08 to=4e-08
meas tran mf_ss_vcemin_q6 MIN mfq_vce_q6 from=2e-08 to=4e-08
let mfq_vbe_q6 = v(lo_n)-v(x2)
meas tran mf_su_vbemax_q6 MAX mfq_vbe_q6 from=0.0 to=2e-08
meas tran mf_su_vbemin_q6 MIN mfq_vbe_q6 from=0.0 to=2e-08
meas tran mf_ss_vbemax_q6 MAX mfq_vbe_q6 from=2e-08 to=4e-08
meas tran mf_ss_vbemin_q6 MIN mfq_vbe_q6 from=2e-08 to=4e-08
let mfq_ic_q6 = i(vic_q6)
meas tran mf_su_icmax_q6 MAX mfq_ic_q6 from=0.0 to=2e-08
meas tran mf_su_icmin_q6 MIN mfq_ic_q6 from=0.0 to=2e-08
meas tran mf_ss_icmax_q6 MAX mfq_ic_q6 from=2e-08 to=4e-08
meas tran mf_ss_icmin_q6 MIN mfq_ic_q6 from=2e-08 to=4e-08
meas tran mf_su_sinkmin_tail MIN v(tail) from=0.0 to=2e-08
meas tran mf_ss_sinkmin_tail MIN v(tail) from=2e-08 to=4e-08
print mf_su_vcemax_q1
print mf_su_vcemin_q1
print mf_ss_vcemax_q1
print mf_ss_vcemin_q1
print mf_su_vbemax_q1
print mf_su_vbemin_q1
print mf_ss_vbemax_q1
print mf_ss_vbemin_q1
print mf_su_icmax_q1
print mf_su_icmin_q1
print mf_ss_icmax_q1
print mf_ss_icmin_q1
print mf_su_vcemax_q2
print mf_su_vcemin_q2
print mf_ss_vcemax_q2
print mf_ss_vcemin_q2
print mf_su_vbemax_q2
print mf_su_vbemin_q2
print mf_ss_vbemax_q2
print mf_ss_vbemin_q2
print mf_su_icmax_q2
print mf_su_icmin_q2
print mf_ss_icmax_q2
print mf_ss_icmin_q2
print mf_su_vcemax_q3
print mf_su_vcemin_q3
print mf_ss_vcemax_q3
print mf_ss_vcemin_q3
print mf_su_vbemax_q3
print mf_su_vbemin_q3
print mf_ss_vbemax_q3
print mf_ss_vbemin_q3
print mf_su_icmax_q3
print mf_su_icmin_q3
print mf_ss_icmax_q3
print mf_ss_icmin_q3
print mf_su_vcemax_q4
print mf_su_vcemin_q4
print mf_ss_vcemax_q4
print mf_ss_vcemin_q4
print mf_su_vbemax_q4
print mf_su_vbemin_q4
print mf_ss_vbemax_q4
print mf_ss_vbemin_q4
print mf_su_icmax_q4
print mf_su_icmin_q4
print mf_ss_icmax_q4
print mf_ss_icmin_q4
print mf_su_vcemax_q5
print mf_su_vcemin_q5
print mf_ss_vcemax_q5
print mf_ss_vcemin_q5
print mf_su_vbemax_q5
print mf_su_vbemin_q5
print mf_ss_vbemax_q5
print mf_ss_vbemin_q5
print mf_su_icmax_q5
print mf_su_icmin_q5
print mf_ss_icmax_q5
print mf_ss_icmin_q5
print mf_su_vcemax_q6
print mf_su_vcemin_q6
print mf_ss_vcemax_q6
print mf_ss_vcemin_q6
print mf_su_vbemax_q6
print mf_su_vbemin_q6
print mf_ss_vbemax_q6
print mf_ss_vbemin_q6
print mf_su_icmax_q6
print mf_su_icmin_q6
print mf_ss_icmax_q6
print mf_ss_icmin_q6
print mf_su_sinkmin_tail
print mf_ss_sinkmin_tail
linearize
let mf_l = length(time)
let mfw = (time ge 1.99995e-08) * (time lt 3.99995e-08)
let mf_n = mean(mfw) * mf_l
let mfs = mf_l / mf_n
let mf_prail = mean(v(vdd) * (0 - i(vdd)) * mfw) * mfs
let mfph = 2 * pi * 20200000000.0 * (time - 2e-08)
let mf_lodiff_re = 2 * mean((v(lo_p)-v(lo_n)) * mfw * cos(mfph)) * mfs
let mf_lodiff_im = 2 * mean((v(lo_p)-v(lo_n)) * mfw * sin(mfph)) * mfs
let mfph = 2 * pi * 1000000000.0 * (time - 2e-08)
let mf_if_re = 2 * mean((v(if_out)) * mfw * cos(mfph)) * mfs
let mf_if_im = 2 * mean((v(if_out)) * mfw * sin(mfph)) * mfs
let mfph = 2 * pi * 20200000000.0 * (time - 2e-08)
let mf_loif_re = 2 * mean((v(if_out)) * mfw * cos(mfph)) * mfs
let mf_loif_im = 2 * mean((v(if_out)) * mfw * sin(mfph)) * mfs
let mfph = 2 * pi * 20200000000.0 * (time - 2e-08)
let mf_lorf_re = 2 * mean((v(rf_port)) * mfw * cos(mfph)) * mfs
let mf_lorf_im = 2 * mean((v(rf_port)) * mfw * sin(mfph)) * mfs
let mfph = 2 * pi * 950000000.0 * (time - 2e-08)
let mf_flifa_re = 2 * mean((v(if_out)) * mfw * cos(mfph)) * mfs
let mf_flifa_im = 2 * mean((v(if_out)) * mfw * sin(mfph)) * mfs
let mfph = 2 * pi * 1050000000.0 * (time - 2e-08)
let mf_flifb_re = 2 * mean((v(if_out)) * mfw * cos(mfph)) * mfs
let mf_flifb_im = 2 * mean((v(if_out)) * mfw * sin(mfph)) * mfs
let mfph = 2 * pi * 20250000000.0 * (time - 2e-08)
let mf_fllorf_re = 2 * mean((v(rf_port)) * mfw * cos(mfph)) * mfs
let mf_fllorf_im = 2 * mean((v(rf_port)) * mfw * sin(mfph)) * mfs
let mfph = 2 * pi * 20250000000.0 * (time - 2e-08)
let mf_flloif_re = 2 * mean((v(if_out)) * mfw * cos(mfph)) * mfs
let mf_flloif_im = 2 * mean((v(if_out)) * mfw * sin(mfph)) * mfs
print mf_l
print mf_n
print mf_prail
print mf_lodiff_re
print mf_lodiff_im
print mf_if_re
print mf_if_im
print mf_loif_re
print mf_loif_im
print mf_lorf_re
print mf_lorf_im
print mf_flifa_re
print mf_flifa_im
print mf_flifb_re
print mf_flifb_im
print mf_fllorf_re
print mf_fllorf_im
print mf_flloif_re
print mf_flloif_im
destroy all
echo "MFEND ls_f21p20_m12_rf60"
echo "MFRUN ls_f21p20_m12_rf66"
alterparam f1 = 21200000000.0
alterparam f2 = 21200000000.0
alterparam flo = 20200000000.0
alterparam vrf1 = 0.00031697863849222284
alterparam vrf2 = 0.0
alterparam vlo = 0.22466995250459165
reset
op
let mf_dcirail = 0 - i(vdd)
let mf_dc_vce_q1 = v(c_q1)-v(e_q1)
let mf_dc_vbe_q1 = v(b_q1)-v(e_q1)
let mf_dc_ic_q1 = i(vic_q1)
let mf_dc_vce_q2 = v(c_q2)-v(e_q2)
let mf_dc_vbe_q2 = v(b_q2)-v(e_q2)
let mf_dc_ic_q2 = i(vic_q2)
let mf_dc_vce_q3 = v(c_q3)-v(x1)
let mf_dc_vbe_q3 = v(lo_p)-v(x1)
let mf_dc_ic_q3 = i(vic_q3)
let mf_dc_vce_q4 = v(c_q4)-v(x1)
let mf_dc_vbe_q4 = v(lo_n)-v(x1)
let mf_dc_ic_q4 = i(vic_q4)
let mf_dc_vce_q5 = v(c_q5)-v(x2)
let mf_dc_vbe_q5 = v(lo_p)-v(x2)
let mf_dc_ic_q5 = i(vic_q5)
let mf_dc_vce_q6 = v(c_q6)-v(x2)
let mf_dc_vbe_q6 = v(lo_n)-v(x2)
let mf_dc_ic_q6 = i(vic_q6)
let mf_dc_sink_tail = v(tail)
print mf_dcirail
print mf_dc_vce_q1
print mf_dc_vbe_q1
print mf_dc_ic_q1
print mf_dc_vce_q2
print mf_dc_vbe_q2
print mf_dc_ic_q2
print mf_dc_vce_q3
print mf_dc_vbe_q3
print mf_dc_ic_q3
print mf_dc_vce_q4
print mf_dc_vbe_q4
print mf_dc_ic_q4
print mf_dc_vce_q5
print mf_dc_vbe_q5
print mf_dc_ic_q5
print mf_dc_vce_q6
print mf_dc_vbe_q6
print mf_dc_ic_q6
print mf_dc_sink_tail
tran 1e-12 4e-08 0 1e-12
let mfq_vce_q1 = v(c_q1)-v(e_q1)
meas tran mf_su_vcemax_q1 MAX mfq_vce_q1 from=0.0 to=2e-08
meas tran mf_su_vcemin_q1 MIN mfq_vce_q1 from=0.0 to=2e-08
meas tran mf_ss_vcemax_q1 MAX mfq_vce_q1 from=2e-08 to=4e-08
meas tran mf_ss_vcemin_q1 MIN mfq_vce_q1 from=2e-08 to=4e-08
let mfq_vbe_q1 = v(b_q1)-v(e_q1)
meas tran mf_su_vbemax_q1 MAX mfq_vbe_q1 from=0.0 to=2e-08
meas tran mf_su_vbemin_q1 MIN mfq_vbe_q1 from=0.0 to=2e-08
meas tran mf_ss_vbemax_q1 MAX mfq_vbe_q1 from=2e-08 to=4e-08
meas tran mf_ss_vbemin_q1 MIN mfq_vbe_q1 from=2e-08 to=4e-08
let mfq_ic_q1 = i(vic_q1)
meas tran mf_su_icmax_q1 MAX mfq_ic_q1 from=0.0 to=2e-08
meas tran mf_su_icmin_q1 MIN mfq_ic_q1 from=0.0 to=2e-08
meas tran mf_ss_icmax_q1 MAX mfq_ic_q1 from=2e-08 to=4e-08
meas tran mf_ss_icmin_q1 MIN mfq_ic_q1 from=2e-08 to=4e-08
let mfq_vce_q2 = v(c_q2)-v(e_q2)
meas tran mf_su_vcemax_q2 MAX mfq_vce_q2 from=0.0 to=2e-08
meas tran mf_su_vcemin_q2 MIN mfq_vce_q2 from=0.0 to=2e-08
meas tran mf_ss_vcemax_q2 MAX mfq_vce_q2 from=2e-08 to=4e-08
meas tran mf_ss_vcemin_q2 MIN mfq_vce_q2 from=2e-08 to=4e-08
let mfq_vbe_q2 = v(b_q2)-v(e_q2)
meas tran mf_su_vbemax_q2 MAX mfq_vbe_q2 from=0.0 to=2e-08
meas tran mf_su_vbemin_q2 MIN mfq_vbe_q2 from=0.0 to=2e-08
meas tran mf_ss_vbemax_q2 MAX mfq_vbe_q2 from=2e-08 to=4e-08
meas tran mf_ss_vbemin_q2 MIN mfq_vbe_q2 from=2e-08 to=4e-08
let mfq_ic_q2 = i(vic_q2)
meas tran mf_su_icmax_q2 MAX mfq_ic_q2 from=0.0 to=2e-08
meas tran mf_su_icmin_q2 MIN mfq_ic_q2 from=0.0 to=2e-08
meas tran mf_ss_icmax_q2 MAX mfq_ic_q2 from=2e-08 to=4e-08
meas tran mf_ss_icmin_q2 MIN mfq_ic_q2 from=2e-08 to=4e-08
let mfq_vce_q3 = v(c_q3)-v(x1)
meas tran mf_su_vcemax_q3 MAX mfq_vce_q3 from=0.0 to=2e-08
meas tran mf_su_vcemin_q3 MIN mfq_vce_q3 from=0.0 to=2e-08
meas tran mf_ss_vcemax_q3 MAX mfq_vce_q3 from=2e-08 to=4e-08
meas tran mf_ss_vcemin_q3 MIN mfq_vce_q3 from=2e-08 to=4e-08
let mfq_vbe_q3 = v(lo_p)-v(x1)
meas tran mf_su_vbemax_q3 MAX mfq_vbe_q3 from=0.0 to=2e-08
meas tran mf_su_vbemin_q3 MIN mfq_vbe_q3 from=0.0 to=2e-08
meas tran mf_ss_vbemax_q3 MAX mfq_vbe_q3 from=2e-08 to=4e-08
meas tran mf_ss_vbemin_q3 MIN mfq_vbe_q3 from=2e-08 to=4e-08
let mfq_ic_q3 = i(vic_q3)
meas tran mf_su_icmax_q3 MAX mfq_ic_q3 from=0.0 to=2e-08
meas tran mf_su_icmin_q3 MIN mfq_ic_q3 from=0.0 to=2e-08
meas tran mf_ss_icmax_q3 MAX mfq_ic_q3 from=2e-08 to=4e-08
meas tran mf_ss_icmin_q3 MIN mfq_ic_q3 from=2e-08 to=4e-08
let mfq_vce_q4 = v(c_q4)-v(x1)
meas tran mf_su_vcemax_q4 MAX mfq_vce_q4 from=0.0 to=2e-08
meas tran mf_su_vcemin_q4 MIN mfq_vce_q4 from=0.0 to=2e-08
meas tran mf_ss_vcemax_q4 MAX mfq_vce_q4 from=2e-08 to=4e-08
meas tran mf_ss_vcemin_q4 MIN mfq_vce_q4 from=2e-08 to=4e-08
let mfq_vbe_q4 = v(lo_n)-v(x1)
meas tran mf_su_vbemax_q4 MAX mfq_vbe_q4 from=0.0 to=2e-08
meas tran mf_su_vbemin_q4 MIN mfq_vbe_q4 from=0.0 to=2e-08
meas tran mf_ss_vbemax_q4 MAX mfq_vbe_q4 from=2e-08 to=4e-08
meas tran mf_ss_vbemin_q4 MIN mfq_vbe_q4 from=2e-08 to=4e-08
let mfq_ic_q4 = i(vic_q4)
meas tran mf_su_icmax_q4 MAX mfq_ic_q4 from=0.0 to=2e-08
meas tran mf_su_icmin_q4 MIN mfq_ic_q4 from=0.0 to=2e-08
meas tran mf_ss_icmax_q4 MAX mfq_ic_q4 from=2e-08 to=4e-08
meas tran mf_ss_icmin_q4 MIN mfq_ic_q4 from=2e-08 to=4e-08
let mfq_vce_q5 = v(c_q5)-v(x2)
meas tran mf_su_vcemax_q5 MAX mfq_vce_q5 from=0.0 to=2e-08
meas tran mf_su_vcemin_q5 MIN mfq_vce_q5 from=0.0 to=2e-08
meas tran mf_ss_vcemax_q5 MAX mfq_vce_q5 from=2e-08 to=4e-08
meas tran mf_ss_vcemin_q5 MIN mfq_vce_q5 from=2e-08 to=4e-08
let mfq_vbe_q5 = v(lo_p)-v(x2)
meas tran mf_su_vbemax_q5 MAX mfq_vbe_q5 from=0.0 to=2e-08
meas tran mf_su_vbemin_q5 MIN mfq_vbe_q5 from=0.0 to=2e-08
meas tran mf_ss_vbemax_q5 MAX mfq_vbe_q5 from=2e-08 to=4e-08
meas tran mf_ss_vbemin_q5 MIN mfq_vbe_q5 from=2e-08 to=4e-08
let mfq_ic_q5 = i(vic_q5)
meas tran mf_su_icmax_q5 MAX mfq_ic_q5 from=0.0 to=2e-08
meas tran mf_su_icmin_q5 MIN mfq_ic_q5 from=0.0 to=2e-08
meas tran mf_ss_icmax_q5 MAX mfq_ic_q5 from=2e-08 to=4e-08
meas tran mf_ss_icmin_q5 MIN mfq_ic_q5 from=2e-08 to=4e-08
let mfq_vce_q6 = v(c_q6)-v(x2)
meas tran mf_su_vcemax_q6 MAX mfq_vce_q6 from=0.0 to=2e-08
meas tran mf_su_vcemin_q6 MIN mfq_vce_q6 from=0.0 to=2e-08
meas tran mf_ss_vcemax_q6 MAX mfq_vce_q6 from=2e-08 to=4e-08
meas tran mf_ss_vcemin_q6 MIN mfq_vce_q6 from=2e-08 to=4e-08
let mfq_vbe_q6 = v(lo_n)-v(x2)
meas tran mf_su_vbemax_q6 MAX mfq_vbe_q6 from=0.0 to=2e-08
meas tran mf_su_vbemin_q6 MIN mfq_vbe_q6 from=0.0 to=2e-08
meas tran mf_ss_vbemax_q6 MAX mfq_vbe_q6 from=2e-08 to=4e-08
meas tran mf_ss_vbemin_q6 MIN mfq_vbe_q6 from=2e-08 to=4e-08
let mfq_ic_q6 = i(vic_q6)
meas tran mf_su_icmax_q6 MAX mfq_ic_q6 from=0.0 to=2e-08
meas tran mf_su_icmin_q6 MIN mfq_ic_q6 from=0.0 to=2e-08
meas tran mf_ss_icmax_q6 MAX mfq_ic_q6 from=2e-08 to=4e-08
meas tran mf_ss_icmin_q6 MIN mfq_ic_q6 from=2e-08 to=4e-08
meas tran mf_su_sinkmin_tail MIN v(tail) from=0.0 to=2e-08
meas tran mf_ss_sinkmin_tail MIN v(tail) from=2e-08 to=4e-08
print mf_su_vcemax_q1
print mf_su_vcemin_q1
print mf_ss_vcemax_q1
print mf_ss_vcemin_q1
print mf_su_vbemax_q1
print mf_su_vbemin_q1
print mf_ss_vbemax_q1
print mf_ss_vbemin_q1
print mf_su_icmax_q1
print mf_su_icmin_q1
print mf_ss_icmax_q1
print mf_ss_icmin_q1
print mf_su_vcemax_q2
print mf_su_vcemin_q2
print mf_ss_vcemax_q2
print mf_ss_vcemin_q2
print mf_su_vbemax_q2
print mf_su_vbemin_q2
print mf_ss_vbemax_q2
print mf_ss_vbemin_q2
print mf_su_icmax_q2
print mf_su_icmin_q2
print mf_ss_icmax_q2
print mf_ss_icmin_q2
print mf_su_vcemax_q3
print mf_su_vcemin_q3
print mf_ss_vcemax_q3
print mf_ss_vcemin_q3
print mf_su_vbemax_q3
print mf_su_vbemin_q3
print mf_ss_vbemax_q3
print mf_ss_vbemin_q3
print mf_su_icmax_q3
print mf_su_icmin_q3
print mf_ss_icmax_q3
print mf_ss_icmin_q3
print mf_su_vcemax_q4
print mf_su_vcemin_q4
print mf_ss_vcemax_q4
print mf_ss_vcemin_q4
print mf_su_vbemax_q4
print mf_su_vbemin_q4
print mf_ss_vbemax_q4
print mf_ss_vbemin_q4
print mf_su_icmax_q4
print mf_su_icmin_q4
print mf_ss_icmax_q4
print mf_ss_icmin_q4
print mf_su_vcemax_q5
print mf_su_vcemin_q5
print mf_ss_vcemax_q5
print mf_ss_vcemin_q5
print mf_su_vbemax_q5
print mf_su_vbemin_q5
print mf_ss_vbemax_q5
print mf_ss_vbemin_q5
print mf_su_icmax_q5
print mf_su_icmin_q5
print mf_ss_icmax_q5
print mf_ss_icmin_q5
print mf_su_vcemax_q6
print mf_su_vcemin_q6
print mf_ss_vcemax_q6
print mf_ss_vcemin_q6
print mf_su_vbemax_q6
print mf_su_vbemin_q6
print mf_ss_vbemax_q6
print mf_ss_vbemin_q6
print mf_su_icmax_q6
print mf_su_icmin_q6
print mf_ss_icmax_q6
print mf_ss_icmin_q6
print mf_su_sinkmin_tail
print mf_ss_sinkmin_tail
linearize
let mf_l = length(time)
let mfw = (time ge 1.99995e-08) * (time lt 3.99995e-08)
let mf_n = mean(mfw) * mf_l
let mfs = mf_l / mf_n
let mf_prail = mean(v(vdd) * (0 - i(vdd)) * mfw) * mfs
let mfph = 2 * pi * 20200000000.0 * (time - 2e-08)
let mf_lodiff_re = 2 * mean((v(lo_p)-v(lo_n)) * mfw * cos(mfph)) * mfs
let mf_lodiff_im = 2 * mean((v(lo_p)-v(lo_n)) * mfw * sin(mfph)) * mfs
let mfph = 2 * pi * 1000000000.0 * (time - 2e-08)
let mf_if_re = 2 * mean((v(if_out)) * mfw * cos(mfph)) * mfs
let mf_if_im = 2 * mean((v(if_out)) * mfw * sin(mfph)) * mfs
let mfph = 2 * pi * 20200000000.0 * (time - 2e-08)
let mf_loif_re = 2 * mean((v(if_out)) * mfw * cos(mfph)) * mfs
let mf_loif_im = 2 * mean((v(if_out)) * mfw * sin(mfph)) * mfs
let mfph = 2 * pi * 20200000000.0 * (time - 2e-08)
let mf_lorf_re = 2 * mean((v(rf_port)) * mfw * cos(mfph)) * mfs
let mf_lorf_im = 2 * mean((v(rf_port)) * mfw * sin(mfph)) * mfs
let mfph = 2 * pi * 950000000.0 * (time - 2e-08)
let mf_flifa_re = 2 * mean((v(if_out)) * mfw * cos(mfph)) * mfs
let mf_flifa_im = 2 * mean((v(if_out)) * mfw * sin(mfph)) * mfs
let mfph = 2 * pi * 1050000000.0 * (time - 2e-08)
let mf_flifb_re = 2 * mean((v(if_out)) * mfw * cos(mfph)) * mfs
let mf_flifb_im = 2 * mean((v(if_out)) * mfw * sin(mfph)) * mfs
let mfph = 2 * pi * 20250000000.0 * (time - 2e-08)
let mf_fllorf_re = 2 * mean((v(rf_port)) * mfw * cos(mfph)) * mfs
let mf_fllorf_im = 2 * mean((v(rf_port)) * mfw * sin(mfph)) * mfs
let mfph = 2 * pi * 20250000000.0 * (time - 2e-08)
let mf_flloif_re = 2 * mean((v(if_out)) * mfw * cos(mfph)) * mfs
let mf_flloif_im = 2 * mean((v(if_out)) * mfw * sin(mfph)) * mfs
print mf_l
print mf_n
print mf_prail
print mf_lodiff_re
print mf_lodiff_im
print mf_if_re
print mf_if_im
print mf_loif_re
print mf_loif_im
print mf_lorf_re
print mf_lorf_im
print mf_flifa_re
print mf_flifa_im
print mf_flifb_re
print mf_flifb_im
print mf_fllorf_re
print mf_fllorf_im
print mf_flloif_re
print mf_flloif_im
destroy all
echo "MFEND ls_f21p20_m12_rf66"
echo "MFRUN ls_f21p20_m9_rf60"
alterparam f1 = 21200000000.0
alterparam f2 = 21200000000.0
alterparam flo = 20200000000.0
alterparam vrf1 = 0.0006324555320336759
alterparam vrf2 = 0.0
alterparam vlo = 0.31735474306134676
reset
op
let mf_dcirail = 0 - i(vdd)
let mf_dc_vce_q1 = v(c_q1)-v(e_q1)
let mf_dc_vbe_q1 = v(b_q1)-v(e_q1)
let mf_dc_ic_q1 = i(vic_q1)
let mf_dc_vce_q2 = v(c_q2)-v(e_q2)
let mf_dc_vbe_q2 = v(b_q2)-v(e_q2)
let mf_dc_ic_q2 = i(vic_q2)
let mf_dc_vce_q3 = v(c_q3)-v(x1)
let mf_dc_vbe_q3 = v(lo_p)-v(x1)
let mf_dc_ic_q3 = i(vic_q3)
let mf_dc_vce_q4 = v(c_q4)-v(x1)
let mf_dc_vbe_q4 = v(lo_n)-v(x1)
let mf_dc_ic_q4 = i(vic_q4)
let mf_dc_vce_q5 = v(c_q5)-v(x2)
let mf_dc_vbe_q5 = v(lo_p)-v(x2)
let mf_dc_ic_q5 = i(vic_q5)
let mf_dc_vce_q6 = v(c_q6)-v(x2)
let mf_dc_vbe_q6 = v(lo_n)-v(x2)
let mf_dc_ic_q6 = i(vic_q6)
let mf_dc_sink_tail = v(tail)
print mf_dcirail
print mf_dc_vce_q1
print mf_dc_vbe_q1
print mf_dc_ic_q1
print mf_dc_vce_q2
print mf_dc_vbe_q2
print mf_dc_ic_q2
print mf_dc_vce_q3
print mf_dc_vbe_q3
print mf_dc_ic_q3
print mf_dc_vce_q4
print mf_dc_vbe_q4
print mf_dc_ic_q4
print mf_dc_vce_q5
print mf_dc_vbe_q5
print mf_dc_ic_q5
print mf_dc_vce_q6
print mf_dc_vbe_q6
print mf_dc_ic_q6
print mf_dc_sink_tail
tran 1e-12 4e-08 0 1e-12
let mfq_vce_q1 = v(c_q1)-v(e_q1)
meas tran mf_su_vcemax_q1 MAX mfq_vce_q1 from=0.0 to=2e-08
meas tran mf_su_vcemin_q1 MIN mfq_vce_q1 from=0.0 to=2e-08
meas tran mf_ss_vcemax_q1 MAX mfq_vce_q1 from=2e-08 to=4e-08
meas tran mf_ss_vcemin_q1 MIN mfq_vce_q1 from=2e-08 to=4e-08
let mfq_vbe_q1 = v(b_q1)-v(e_q1)
meas tran mf_su_vbemax_q1 MAX mfq_vbe_q1 from=0.0 to=2e-08
meas tran mf_su_vbemin_q1 MIN mfq_vbe_q1 from=0.0 to=2e-08
meas tran mf_ss_vbemax_q1 MAX mfq_vbe_q1 from=2e-08 to=4e-08
meas tran mf_ss_vbemin_q1 MIN mfq_vbe_q1 from=2e-08 to=4e-08
let mfq_ic_q1 = i(vic_q1)
meas tran mf_su_icmax_q1 MAX mfq_ic_q1 from=0.0 to=2e-08
meas tran mf_su_icmin_q1 MIN mfq_ic_q1 from=0.0 to=2e-08
meas tran mf_ss_icmax_q1 MAX mfq_ic_q1 from=2e-08 to=4e-08
meas tran mf_ss_icmin_q1 MIN mfq_ic_q1 from=2e-08 to=4e-08
let mfq_vce_q2 = v(c_q2)-v(e_q2)
meas tran mf_su_vcemax_q2 MAX mfq_vce_q2 from=0.0 to=2e-08
meas tran mf_su_vcemin_q2 MIN mfq_vce_q2 from=0.0 to=2e-08
meas tran mf_ss_vcemax_q2 MAX mfq_vce_q2 from=2e-08 to=4e-08
meas tran mf_ss_vcemin_q2 MIN mfq_vce_q2 from=2e-08 to=4e-08
let mfq_vbe_q2 = v(b_q2)-v(e_q2)
meas tran mf_su_vbemax_q2 MAX mfq_vbe_q2 from=0.0 to=2e-08
meas tran mf_su_vbemin_q2 MIN mfq_vbe_q2 from=0.0 to=2e-08
meas tran mf_ss_vbemax_q2 MAX mfq_vbe_q2 from=2e-08 to=4e-08
meas tran mf_ss_vbemin_q2 MIN mfq_vbe_q2 from=2e-08 to=4e-08
let mfq_ic_q2 = i(vic_q2)
meas tran mf_su_icmax_q2 MAX mfq_ic_q2 from=0.0 to=2e-08
meas tran mf_su_icmin_q2 MIN mfq_ic_q2 from=0.0 to=2e-08
meas tran mf_ss_icmax_q2 MAX mfq_ic_q2 from=2e-08 to=4e-08
meas tran mf_ss_icmin_q2 MIN mfq_ic_q2 from=2e-08 to=4e-08
let mfq_vce_q3 = v(c_q3)-v(x1)
meas tran mf_su_vcemax_q3 MAX mfq_vce_q3 from=0.0 to=2e-08
meas tran mf_su_vcemin_q3 MIN mfq_vce_q3 from=0.0 to=2e-08
meas tran mf_ss_vcemax_q3 MAX mfq_vce_q3 from=2e-08 to=4e-08
meas tran mf_ss_vcemin_q3 MIN mfq_vce_q3 from=2e-08 to=4e-08
let mfq_vbe_q3 = v(lo_p)-v(x1)
meas tran mf_su_vbemax_q3 MAX mfq_vbe_q3 from=0.0 to=2e-08
meas tran mf_su_vbemin_q3 MIN mfq_vbe_q3 from=0.0 to=2e-08
meas tran mf_ss_vbemax_q3 MAX mfq_vbe_q3 from=2e-08 to=4e-08
meas tran mf_ss_vbemin_q3 MIN mfq_vbe_q3 from=2e-08 to=4e-08
let mfq_ic_q3 = i(vic_q3)
meas tran mf_su_icmax_q3 MAX mfq_ic_q3 from=0.0 to=2e-08
meas tran mf_su_icmin_q3 MIN mfq_ic_q3 from=0.0 to=2e-08
meas tran mf_ss_icmax_q3 MAX mfq_ic_q3 from=2e-08 to=4e-08
meas tran mf_ss_icmin_q3 MIN mfq_ic_q3 from=2e-08 to=4e-08
let mfq_vce_q4 = v(c_q4)-v(x1)
meas tran mf_su_vcemax_q4 MAX mfq_vce_q4 from=0.0 to=2e-08
meas tran mf_su_vcemin_q4 MIN mfq_vce_q4 from=0.0 to=2e-08
meas tran mf_ss_vcemax_q4 MAX mfq_vce_q4 from=2e-08 to=4e-08
meas tran mf_ss_vcemin_q4 MIN mfq_vce_q4 from=2e-08 to=4e-08
let mfq_vbe_q4 = v(lo_n)-v(x1)
meas tran mf_su_vbemax_q4 MAX mfq_vbe_q4 from=0.0 to=2e-08
meas tran mf_su_vbemin_q4 MIN mfq_vbe_q4 from=0.0 to=2e-08
meas tran mf_ss_vbemax_q4 MAX mfq_vbe_q4 from=2e-08 to=4e-08
meas tran mf_ss_vbemin_q4 MIN mfq_vbe_q4 from=2e-08 to=4e-08
let mfq_ic_q4 = i(vic_q4)
meas tran mf_su_icmax_q4 MAX mfq_ic_q4 from=0.0 to=2e-08
meas tran mf_su_icmin_q4 MIN mfq_ic_q4 from=0.0 to=2e-08
meas tran mf_ss_icmax_q4 MAX mfq_ic_q4 from=2e-08 to=4e-08
meas tran mf_ss_icmin_q4 MIN mfq_ic_q4 from=2e-08 to=4e-08
let mfq_vce_q5 = v(c_q5)-v(x2)
meas tran mf_su_vcemax_q5 MAX mfq_vce_q5 from=0.0 to=2e-08
meas tran mf_su_vcemin_q5 MIN mfq_vce_q5 from=0.0 to=2e-08
meas tran mf_ss_vcemax_q5 MAX mfq_vce_q5 from=2e-08 to=4e-08
meas tran mf_ss_vcemin_q5 MIN mfq_vce_q5 from=2e-08 to=4e-08
let mfq_vbe_q5 = v(lo_p)-v(x2)
meas tran mf_su_vbemax_q5 MAX mfq_vbe_q5 from=0.0 to=2e-08
meas tran mf_su_vbemin_q5 MIN mfq_vbe_q5 from=0.0 to=2e-08
meas tran mf_ss_vbemax_q5 MAX mfq_vbe_q5 from=2e-08 to=4e-08
meas tran mf_ss_vbemin_q5 MIN mfq_vbe_q5 from=2e-08 to=4e-08
let mfq_ic_q5 = i(vic_q5)
meas tran mf_su_icmax_q5 MAX mfq_ic_q5 from=0.0 to=2e-08
meas tran mf_su_icmin_q5 MIN mfq_ic_q5 from=0.0 to=2e-08
meas tran mf_ss_icmax_q5 MAX mfq_ic_q5 from=2e-08 to=4e-08
meas tran mf_ss_icmin_q5 MIN mfq_ic_q5 from=2e-08 to=4e-08
let mfq_vce_q6 = v(c_q6)-v(x2)
meas tran mf_su_vcemax_q6 MAX mfq_vce_q6 from=0.0 to=2e-08
meas tran mf_su_vcemin_q6 MIN mfq_vce_q6 from=0.0 to=2e-08
meas tran mf_ss_vcemax_q6 MAX mfq_vce_q6 from=2e-08 to=4e-08
meas tran mf_ss_vcemin_q6 MIN mfq_vce_q6 from=2e-08 to=4e-08
let mfq_vbe_q6 = v(lo_n)-v(x2)
meas tran mf_su_vbemax_q6 MAX mfq_vbe_q6 from=0.0 to=2e-08
meas tran mf_su_vbemin_q6 MIN mfq_vbe_q6 from=0.0 to=2e-08
meas tran mf_ss_vbemax_q6 MAX mfq_vbe_q6 from=2e-08 to=4e-08
meas tran mf_ss_vbemin_q6 MIN mfq_vbe_q6 from=2e-08 to=4e-08
let mfq_ic_q6 = i(vic_q6)
meas tran mf_su_icmax_q6 MAX mfq_ic_q6 from=0.0 to=2e-08
meas tran mf_su_icmin_q6 MIN mfq_ic_q6 from=0.0 to=2e-08
meas tran mf_ss_icmax_q6 MAX mfq_ic_q6 from=2e-08 to=4e-08
meas tran mf_ss_icmin_q6 MIN mfq_ic_q6 from=2e-08 to=4e-08
meas tran mf_su_sinkmin_tail MIN v(tail) from=0.0 to=2e-08
meas tran mf_ss_sinkmin_tail MIN v(tail) from=2e-08 to=4e-08
print mf_su_vcemax_q1
print mf_su_vcemin_q1
print mf_ss_vcemax_q1
print mf_ss_vcemin_q1
print mf_su_vbemax_q1
print mf_su_vbemin_q1
print mf_ss_vbemax_q1
print mf_ss_vbemin_q1
print mf_su_icmax_q1
print mf_su_icmin_q1
print mf_ss_icmax_q1
print mf_ss_icmin_q1
print mf_su_vcemax_q2
print mf_su_vcemin_q2
print mf_ss_vcemax_q2
print mf_ss_vcemin_q2
print mf_su_vbemax_q2
print mf_su_vbemin_q2
print mf_ss_vbemax_q2
print mf_ss_vbemin_q2
print mf_su_icmax_q2
print mf_su_icmin_q2
print mf_ss_icmax_q2
print mf_ss_icmin_q2
print mf_su_vcemax_q3
print mf_su_vcemin_q3
print mf_ss_vcemax_q3
print mf_ss_vcemin_q3
print mf_su_vbemax_q3
print mf_su_vbemin_q3
print mf_ss_vbemax_q3
print mf_ss_vbemin_q3
print mf_su_icmax_q3
print mf_su_icmin_q3
print mf_ss_icmax_q3
print mf_ss_icmin_q3
print mf_su_vcemax_q4
print mf_su_vcemin_q4
print mf_ss_vcemax_q4
print mf_ss_vcemin_q4
print mf_su_vbemax_q4
print mf_su_vbemin_q4
print mf_ss_vbemax_q4
print mf_ss_vbemin_q4
print mf_su_icmax_q4
print mf_su_icmin_q4
print mf_ss_icmax_q4
print mf_ss_icmin_q4
print mf_su_vcemax_q5
print mf_su_vcemin_q5
print mf_ss_vcemax_q5
print mf_ss_vcemin_q5
print mf_su_vbemax_q5
print mf_su_vbemin_q5
print mf_ss_vbemax_q5
print mf_ss_vbemin_q5
print mf_su_icmax_q5
print mf_su_icmin_q5
print mf_ss_icmax_q5
print mf_ss_icmin_q5
print mf_su_vcemax_q6
print mf_su_vcemin_q6
print mf_ss_vcemax_q6
print mf_ss_vcemin_q6
print mf_su_vbemax_q6
print mf_su_vbemin_q6
print mf_ss_vbemax_q6
print mf_ss_vbemin_q6
print mf_su_icmax_q6
print mf_su_icmin_q6
print mf_ss_icmax_q6
print mf_ss_icmin_q6
print mf_su_sinkmin_tail
print mf_ss_sinkmin_tail
linearize
let mf_l = length(time)
let mfw = (time ge 1.99995e-08) * (time lt 3.99995e-08)
let mf_n = mean(mfw) * mf_l
let mfs = mf_l / mf_n
let mf_prail = mean(v(vdd) * (0 - i(vdd)) * mfw) * mfs
let mfph = 2 * pi * 20200000000.0 * (time - 2e-08)
let mf_lodiff_re = 2 * mean((v(lo_p)-v(lo_n)) * mfw * cos(mfph)) * mfs
let mf_lodiff_im = 2 * mean((v(lo_p)-v(lo_n)) * mfw * sin(mfph)) * mfs
let mfph = 2 * pi * 1000000000.0 * (time - 2e-08)
let mf_if_re = 2 * mean((v(if_out)) * mfw * cos(mfph)) * mfs
let mf_if_im = 2 * mean((v(if_out)) * mfw * sin(mfph)) * mfs
let mfph = 2 * pi * 20200000000.0 * (time - 2e-08)
let mf_loif_re = 2 * mean((v(if_out)) * mfw * cos(mfph)) * mfs
let mf_loif_im = 2 * mean((v(if_out)) * mfw * sin(mfph)) * mfs
let mfph = 2 * pi * 20200000000.0 * (time - 2e-08)
let mf_lorf_re = 2 * mean((v(rf_port)) * mfw * cos(mfph)) * mfs
let mf_lorf_im = 2 * mean((v(rf_port)) * mfw * sin(mfph)) * mfs
let mfph = 2 * pi * 950000000.0 * (time - 2e-08)
let mf_flifa_re = 2 * mean((v(if_out)) * mfw * cos(mfph)) * mfs
let mf_flifa_im = 2 * mean((v(if_out)) * mfw * sin(mfph)) * mfs
let mfph = 2 * pi * 1050000000.0 * (time - 2e-08)
let mf_flifb_re = 2 * mean((v(if_out)) * mfw * cos(mfph)) * mfs
let mf_flifb_im = 2 * mean((v(if_out)) * mfw * sin(mfph)) * mfs
let mfph = 2 * pi * 20250000000.0 * (time - 2e-08)
let mf_fllorf_re = 2 * mean((v(rf_port)) * mfw * cos(mfph)) * mfs
let mf_fllorf_im = 2 * mean((v(rf_port)) * mfw * sin(mfph)) * mfs
let mfph = 2 * pi * 20250000000.0 * (time - 2e-08)
let mf_flloif_re = 2 * mean((v(if_out)) * mfw * cos(mfph)) * mfs
let mf_flloif_im = 2 * mean((v(if_out)) * mfw * sin(mfph)) * mfs
print mf_l
print mf_n
print mf_prail
print mf_lodiff_re
print mf_lodiff_im
print mf_if_re
print mf_if_im
print mf_loif_re
print mf_loif_im
print mf_lorf_re
print mf_lorf_im
print mf_flifa_re
print mf_flifa_im
print mf_flifb_re
print mf_flifb_im
print mf_fllorf_re
print mf_fllorf_im
print mf_flloif_re
print mf_flloif_im
destroy all
echo "MFEND ls_f21p20_m9_rf60"
echo "MFRUN ls_f21p20_m9_rf66"
alterparam f1 = 21200000000.0
alterparam f2 = 21200000000.0
alterparam flo = 20200000000.0
alterparam vrf1 = 0.00031697863849222284
alterparam vrf2 = 0.0
alterparam vlo = 0.31735474306134676
reset
op
let mf_dcirail = 0 - i(vdd)
let mf_dc_vce_q1 = v(c_q1)-v(e_q1)
let mf_dc_vbe_q1 = v(b_q1)-v(e_q1)
let mf_dc_ic_q1 = i(vic_q1)
let mf_dc_vce_q2 = v(c_q2)-v(e_q2)
let mf_dc_vbe_q2 = v(b_q2)-v(e_q2)
let mf_dc_ic_q2 = i(vic_q2)
let mf_dc_vce_q3 = v(c_q3)-v(x1)
let mf_dc_vbe_q3 = v(lo_p)-v(x1)
let mf_dc_ic_q3 = i(vic_q3)
let mf_dc_vce_q4 = v(c_q4)-v(x1)
let mf_dc_vbe_q4 = v(lo_n)-v(x1)
let mf_dc_ic_q4 = i(vic_q4)
let mf_dc_vce_q5 = v(c_q5)-v(x2)
let mf_dc_vbe_q5 = v(lo_p)-v(x2)
let mf_dc_ic_q5 = i(vic_q5)
let mf_dc_vce_q6 = v(c_q6)-v(x2)
let mf_dc_vbe_q6 = v(lo_n)-v(x2)
let mf_dc_ic_q6 = i(vic_q6)
let mf_dc_sink_tail = v(tail)
print mf_dcirail
print mf_dc_vce_q1
print mf_dc_vbe_q1
print mf_dc_ic_q1
print mf_dc_vce_q2
print mf_dc_vbe_q2
print mf_dc_ic_q2
print mf_dc_vce_q3
print mf_dc_vbe_q3
print mf_dc_ic_q3
print mf_dc_vce_q4
print mf_dc_vbe_q4
print mf_dc_ic_q4
print mf_dc_vce_q5
print mf_dc_vbe_q5
print mf_dc_ic_q5
print mf_dc_vce_q6
print mf_dc_vbe_q6
print mf_dc_ic_q6
print mf_dc_sink_tail
tran 1e-12 4e-08 0 1e-12
let mfq_vce_q1 = v(c_q1)-v(e_q1)
meas tran mf_su_vcemax_q1 MAX mfq_vce_q1 from=0.0 to=2e-08
meas tran mf_su_vcemin_q1 MIN mfq_vce_q1 from=0.0 to=2e-08
meas tran mf_ss_vcemax_q1 MAX mfq_vce_q1 from=2e-08 to=4e-08
meas tran mf_ss_vcemin_q1 MIN mfq_vce_q1 from=2e-08 to=4e-08
let mfq_vbe_q1 = v(b_q1)-v(e_q1)
meas tran mf_su_vbemax_q1 MAX mfq_vbe_q1 from=0.0 to=2e-08
meas tran mf_su_vbemin_q1 MIN mfq_vbe_q1 from=0.0 to=2e-08
meas tran mf_ss_vbemax_q1 MAX mfq_vbe_q1 from=2e-08 to=4e-08
meas tran mf_ss_vbemin_q1 MIN mfq_vbe_q1 from=2e-08 to=4e-08
let mfq_ic_q1 = i(vic_q1)
meas tran mf_su_icmax_q1 MAX mfq_ic_q1 from=0.0 to=2e-08
meas tran mf_su_icmin_q1 MIN mfq_ic_q1 from=0.0 to=2e-08
meas tran mf_ss_icmax_q1 MAX mfq_ic_q1 from=2e-08 to=4e-08
meas tran mf_ss_icmin_q1 MIN mfq_ic_q1 from=2e-08 to=4e-08
let mfq_vce_q2 = v(c_q2)-v(e_q2)
meas tran mf_su_vcemax_q2 MAX mfq_vce_q2 from=0.0 to=2e-08
meas tran mf_su_vcemin_q2 MIN mfq_vce_q2 from=0.0 to=2e-08
meas tran mf_ss_vcemax_q2 MAX mfq_vce_q2 from=2e-08 to=4e-08
meas tran mf_ss_vcemin_q2 MIN mfq_vce_q2 from=2e-08 to=4e-08
let mfq_vbe_q2 = v(b_q2)-v(e_q2)
meas tran mf_su_vbemax_q2 MAX mfq_vbe_q2 from=0.0 to=2e-08
meas tran mf_su_vbemin_q2 MIN mfq_vbe_q2 from=0.0 to=2e-08
meas tran mf_ss_vbemax_q2 MAX mfq_vbe_q2 from=2e-08 to=4e-08
meas tran mf_ss_vbemin_q2 MIN mfq_vbe_q2 from=2e-08 to=4e-08
let mfq_ic_q2 = i(vic_q2)
meas tran mf_su_icmax_q2 MAX mfq_ic_q2 from=0.0 to=2e-08
meas tran mf_su_icmin_q2 MIN mfq_ic_q2 from=0.0 to=2e-08
meas tran mf_ss_icmax_q2 MAX mfq_ic_q2 from=2e-08 to=4e-08
meas tran mf_ss_icmin_q2 MIN mfq_ic_q2 from=2e-08 to=4e-08
let mfq_vce_q3 = v(c_q3)-v(x1)
meas tran mf_su_vcemax_q3 MAX mfq_vce_q3 from=0.0 to=2e-08
meas tran mf_su_vcemin_q3 MIN mfq_vce_q3 from=0.0 to=2e-08
meas tran mf_ss_vcemax_q3 MAX mfq_vce_q3 from=2e-08 to=4e-08
meas tran mf_ss_vcemin_q3 MIN mfq_vce_q3 from=2e-08 to=4e-08
let mfq_vbe_q3 = v(lo_p)-v(x1)
meas tran mf_su_vbemax_q3 MAX mfq_vbe_q3 from=0.0 to=2e-08
meas tran mf_su_vbemin_q3 MIN mfq_vbe_q3 from=0.0 to=2e-08
meas tran mf_ss_vbemax_q3 MAX mfq_vbe_q3 from=2e-08 to=4e-08
meas tran mf_ss_vbemin_q3 MIN mfq_vbe_q3 from=2e-08 to=4e-08
let mfq_ic_q3 = i(vic_q3)
meas tran mf_su_icmax_q3 MAX mfq_ic_q3 from=0.0 to=2e-08
meas tran mf_su_icmin_q3 MIN mfq_ic_q3 from=0.0 to=2e-08
meas tran mf_ss_icmax_q3 MAX mfq_ic_q3 from=2e-08 to=4e-08
meas tran mf_ss_icmin_q3 MIN mfq_ic_q3 from=2e-08 to=4e-08
let mfq_vce_q4 = v(c_q4)-v(x1)
meas tran mf_su_vcemax_q4 MAX mfq_vce_q4 from=0.0 to=2e-08
meas tran mf_su_vcemin_q4 MIN mfq_vce_q4 from=0.0 to=2e-08
meas tran mf_ss_vcemax_q4 MAX mfq_vce_q4 from=2e-08 to=4e-08
meas tran mf_ss_vcemin_q4 MIN mfq_vce_q4 from=2e-08 to=4e-08
let mfq_vbe_q4 = v(lo_n)-v(x1)
meas tran mf_su_vbemax_q4 MAX mfq_vbe_q4 from=0.0 to=2e-08
meas tran mf_su_vbemin_q4 MIN mfq_vbe_q4 from=0.0 to=2e-08
meas tran mf_ss_vbemax_q4 MAX mfq_vbe_q4 from=2e-08 to=4e-08
meas tran mf_ss_vbemin_q4 MIN mfq_vbe_q4 from=2e-08 to=4e-08
let mfq_ic_q4 = i(vic_q4)
meas tran mf_su_icmax_q4 MAX mfq_ic_q4 from=0.0 to=2e-08
meas tran mf_su_icmin_q4 MIN mfq_ic_q4 from=0.0 to=2e-08
meas tran mf_ss_icmax_q4 MAX mfq_ic_q4 from=2e-08 to=4e-08
meas tran mf_ss_icmin_q4 MIN mfq_ic_q4 from=2e-08 to=4e-08
let mfq_vce_q5 = v(c_q5)-v(x2)
meas tran mf_su_vcemax_q5 MAX mfq_vce_q5 from=0.0 to=2e-08
meas tran mf_su_vcemin_q5 MIN mfq_vce_q5 from=0.0 to=2e-08
meas tran mf_ss_vcemax_q5 MAX mfq_vce_q5 from=2e-08 to=4e-08
meas tran mf_ss_vcemin_q5 MIN mfq_vce_q5 from=2e-08 to=4e-08
let mfq_vbe_q5 = v(lo_p)-v(x2)
meas tran mf_su_vbemax_q5 MAX mfq_vbe_q5 from=0.0 to=2e-08
meas tran mf_su_vbemin_q5 MIN mfq_vbe_q5 from=0.0 to=2e-08
meas tran mf_ss_vbemax_q5 MAX mfq_vbe_q5 from=2e-08 to=4e-08
meas tran mf_ss_vbemin_q5 MIN mfq_vbe_q5 from=2e-08 to=4e-08
let mfq_ic_q5 = i(vic_q5)
meas tran mf_su_icmax_q5 MAX mfq_ic_q5 from=0.0 to=2e-08
meas tran mf_su_icmin_q5 MIN mfq_ic_q5 from=0.0 to=2e-08
meas tran mf_ss_icmax_q5 MAX mfq_ic_q5 from=2e-08 to=4e-08
meas tran mf_ss_icmin_q5 MIN mfq_ic_q5 from=2e-08 to=4e-08
let mfq_vce_q6 = v(c_q6)-v(x2)
meas tran mf_su_vcemax_q6 MAX mfq_vce_q6 from=0.0 to=2e-08
meas tran mf_su_vcemin_q6 MIN mfq_vce_q6 from=0.0 to=2e-08
meas tran mf_ss_vcemax_q6 MAX mfq_vce_q6 from=2e-08 to=4e-08
meas tran mf_ss_vcemin_q6 MIN mfq_vce_q6 from=2e-08 to=4e-08
let mfq_vbe_q6 = v(lo_n)-v(x2)
meas tran mf_su_vbemax_q6 MAX mfq_vbe_q6 from=0.0 to=2e-08
meas tran mf_su_vbemin_q6 MIN mfq_vbe_q6 from=0.0 to=2e-08
meas tran mf_ss_vbemax_q6 MAX mfq_vbe_q6 from=2e-08 to=4e-08
meas tran mf_ss_vbemin_q6 MIN mfq_vbe_q6 from=2e-08 to=4e-08
let mfq_ic_q6 = i(vic_q6)
meas tran mf_su_icmax_q6 MAX mfq_ic_q6 from=0.0 to=2e-08
meas tran mf_su_icmin_q6 MIN mfq_ic_q6 from=0.0 to=2e-08
meas tran mf_ss_icmax_q6 MAX mfq_ic_q6 from=2e-08 to=4e-08
meas tran mf_ss_icmin_q6 MIN mfq_ic_q6 from=2e-08 to=4e-08
meas tran mf_su_sinkmin_tail MIN v(tail) from=0.0 to=2e-08
meas tran mf_ss_sinkmin_tail MIN v(tail) from=2e-08 to=4e-08
print mf_su_vcemax_q1
print mf_su_vcemin_q1
print mf_ss_vcemax_q1
print mf_ss_vcemin_q1
print mf_su_vbemax_q1
print mf_su_vbemin_q1
print mf_ss_vbemax_q1
print mf_ss_vbemin_q1
print mf_su_icmax_q1
print mf_su_icmin_q1
print mf_ss_icmax_q1
print mf_ss_icmin_q1
print mf_su_vcemax_q2
print mf_su_vcemin_q2
print mf_ss_vcemax_q2
print mf_ss_vcemin_q2
print mf_su_vbemax_q2
print mf_su_vbemin_q2
print mf_ss_vbemax_q2
print mf_ss_vbemin_q2
print mf_su_icmax_q2
print mf_su_icmin_q2
print mf_ss_icmax_q2
print mf_ss_icmin_q2
print mf_su_vcemax_q3
print mf_su_vcemin_q3
print mf_ss_vcemax_q3
print mf_ss_vcemin_q3
print mf_su_vbemax_q3
print mf_su_vbemin_q3
print mf_ss_vbemax_q3
print mf_ss_vbemin_q3
print mf_su_icmax_q3
print mf_su_icmin_q3
print mf_ss_icmax_q3
print mf_ss_icmin_q3
print mf_su_vcemax_q4
print mf_su_vcemin_q4
print mf_ss_vcemax_q4
print mf_ss_vcemin_q4
print mf_su_vbemax_q4
print mf_su_vbemin_q4
print mf_ss_vbemax_q4
print mf_ss_vbemin_q4
print mf_su_icmax_q4
print mf_su_icmin_q4
print mf_ss_icmax_q4
print mf_ss_icmin_q4
print mf_su_vcemax_q5
print mf_su_vcemin_q5
print mf_ss_vcemax_q5
print mf_ss_vcemin_q5
print mf_su_vbemax_q5
print mf_su_vbemin_q5
print mf_ss_vbemax_q5
print mf_ss_vbemin_q5
print mf_su_icmax_q5
print mf_su_icmin_q5
print mf_ss_icmax_q5
print mf_ss_icmin_q5
print mf_su_vcemax_q6
print mf_su_vcemin_q6
print mf_ss_vcemax_q6
print mf_ss_vcemin_q6
print mf_su_vbemax_q6
print mf_su_vbemin_q6
print mf_ss_vbemax_q6
print mf_ss_vbemin_q6
print mf_su_icmax_q6
print mf_su_icmin_q6
print mf_ss_icmax_q6
print mf_ss_icmin_q6
print mf_su_sinkmin_tail
print mf_ss_sinkmin_tail
linearize
let mf_l = length(time)
let mfw = (time ge 1.99995e-08) * (time lt 3.99995e-08)
let mf_n = mean(mfw) * mf_l
let mfs = mf_l / mf_n
let mf_prail = mean(v(vdd) * (0 - i(vdd)) * mfw) * mfs
let mfph = 2 * pi * 20200000000.0 * (time - 2e-08)
let mf_lodiff_re = 2 * mean((v(lo_p)-v(lo_n)) * mfw * cos(mfph)) * mfs
let mf_lodiff_im = 2 * mean((v(lo_p)-v(lo_n)) * mfw * sin(mfph)) * mfs
let mfph = 2 * pi * 1000000000.0 * (time - 2e-08)
let mf_if_re = 2 * mean((v(if_out)) * mfw * cos(mfph)) * mfs
let mf_if_im = 2 * mean((v(if_out)) * mfw * sin(mfph)) * mfs
let mfph = 2 * pi * 20200000000.0 * (time - 2e-08)
let mf_loif_re = 2 * mean((v(if_out)) * mfw * cos(mfph)) * mfs
let mf_loif_im = 2 * mean((v(if_out)) * mfw * sin(mfph)) * mfs
let mfph = 2 * pi * 20200000000.0 * (time - 2e-08)
let mf_lorf_re = 2 * mean((v(rf_port)) * mfw * cos(mfph)) * mfs
let mf_lorf_im = 2 * mean((v(rf_port)) * mfw * sin(mfph)) * mfs
let mfph = 2 * pi * 950000000.0 * (time - 2e-08)
let mf_flifa_re = 2 * mean((v(if_out)) * mfw * cos(mfph)) * mfs
let mf_flifa_im = 2 * mean((v(if_out)) * mfw * sin(mfph)) * mfs
let mfph = 2 * pi * 1050000000.0 * (time - 2e-08)
let mf_flifb_re = 2 * mean((v(if_out)) * mfw * cos(mfph)) * mfs
let mf_flifb_im = 2 * mean((v(if_out)) * mfw * sin(mfph)) * mfs
let mfph = 2 * pi * 20250000000.0 * (time - 2e-08)
let mf_fllorf_re = 2 * mean((v(rf_port)) * mfw * cos(mfph)) * mfs
let mf_fllorf_im = 2 * mean((v(rf_port)) * mfw * sin(mfph)) * mfs
let mfph = 2 * pi * 20250000000.0 * (time - 2e-08)
let mf_flloif_re = 2 * mean((v(if_out)) * mfw * cos(mfph)) * mfs
let mf_flloif_im = 2 * mean((v(if_out)) * mfw * sin(mfph)) * mfs
print mf_l
print mf_n
print mf_prail
print mf_lodiff_re
print mf_lodiff_im
print mf_if_re
print mf_if_im
print mf_loif_re
print mf_loif_im
print mf_lorf_re
print mf_lorf_im
print mf_flifa_re
print mf_flifa_im
print mf_flifb_re
print mf_flifb_im
print mf_fllorf_re
print mf_fllorf_im
print mf_flloif_re
print mf_flloif_im
destroy all
echo "MFEND ls_f21p20_m9_rf66"
echo "MFRUN ls_f21p20_m6_rf60"
alterparam f1 = 21200000000.0
alterparam f2 = 21200000000.0
alterparam flo = 20200000000.0
alterparam vrf1 = 0.0006324555320336759
alterparam vrf2 = 0.0
alterparam vlo = 0.44827548953825974
reset
op
let mf_dcirail = 0 - i(vdd)
let mf_dc_vce_q1 = v(c_q1)-v(e_q1)
let mf_dc_vbe_q1 = v(b_q1)-v(e_q1)
let mf_dc_ic_q1 = i(vic_q1)
let mf_dc_vce_q2 = v(c_q2)-v(e_q2)
let mf_dc_vbe_q2 = v(b_q2)-v(e_q2)
let mf_dc_ic_q2 = i(vic_q2)
let mf_dc_vce_q3 = v(c_q3)-v(x1)
let mf_dc_vbe_q3 = v(lo_p)-v(x1)
let mf_dc_ic_q3 = i(vic_q3)
let mf_dc_vce_q4 = v(c_q4)-v(x1)
let mf_dc_vbe_q4 = v(lo_n)-v(x1)
let mf_dc_ic_q4 = i(vic_q4)
let mf_dc_vce_q5 = v(c_q5)-v(x2)
let mf_dc_vbe_q5 = v(lo_p)-v(x2)
let mf_dc_ic_q5 = i(vic_q5)
let mf_dc_vce_q6 = v(c_q6)-v(x2)
let mf_dc_vbe_q6 = v(lo_n)-v(x2)
let mf_dc_ic_q6 = i(vic_q6)
let mf_dc_sink_tail = v(tail)
print mf_dcirail
print mf_dc_vce_q1
print mf_dc_vbe_q1
print mf_dc_ic_q1
print mf_dc_vce_q2
print mf_dc_vbe_q2
print mf_dc_ic_q2
print mf_dc_vce_q3
print mf_dc_vbe_q3
print mf_dc_ic_q3
print mf_dc_vce_q4
print mf_dc_vbe_q4
print mf_dc_ic_q4
print mf_dc_vce_q5
print mf_dc_vbe_q5
print mf_dc_ic_q5
print mf_dc_vce_q6
print mf_dc_vbe_q6
print mf_dc_ic_q6
print mf_dc_sink_tail
tran 1e-12 4e-08 0 1e-12
let mfq_vce_q1 = v(c_q1)-v(e_q1)
meas tran mf_su_vcemax_q1 MAX mfq_vce_q1 from=0.0 to=2e-08
meas tran mf_su_vcemin_q1 MIN mfq_vce_q1 from=0.0 to=2e-08
meas tran mf_ss_vcemax_q1 MAX mfq_vce_q1 from=2e-08 to=4e-08
meas tran mf_ss_vcemin_q1 MIN mfq_vce_q1 from=2e-08 to=4e-08
let mfq_vbe_q1 = v(b_q1)-v(e_q1)
meas tran mf_su_vbemax_q1 MAX mfq_vbe_q1 from=0.0 to=2e-08
meas tran mf_su_vbemin_q1 MIN mfq_vbe_q1 from=0.0 to=2e-08
meas tran mf_ss_vbemax_q1 MAX mfq_vbe_q1 from=2e-08 to=4e-08
meas tran mf_ss_vbemin_q1 MIN mfq_vbe_q1 from=2e-08 to=4e-08
let mfq_ic_q1 = i(vic_q1)
meas tran mf_su_icmax_q1 MAX mfq_ic_q1 from=0.0 to=2e-08
meas tran mf_su_icmin_q1 MIN mfq_ic_q1 from=0.0 to=2e-08
meas tran mf_ss_icmax_q1 MAX mfq_ic_q1 from=2e-08 to=4e-08
meas tran mf_ss_icmin_q1 MIN mfq_ic_q1 from=2e-08 to=4e-08
let mfq_vce_q2 = v(c_q2)-v(e_q2)
meas tran mf_su_vcemax_q2 MAX mfq_vce_q2 from=0.0 to=2e-08
meas tran mf_su_vcemin_q2 MIN mfq_vce_q2 from=0.0 to=2e-08
meas tran mf_ss_vcemax_q2 MAX mfq_vce_q2 from=2e-08 to=4e-08
meas tran mf_ss_vcemin_q2 MIN mfq_vce_q2 from=2e-08 to=4e-08
let mfq_vbe_q2 = v(b_q2)-v(e_q2)
meas tran mf_su_vbemax_q2 MAX mfq_vbe_q2 from=0.0 to=2e-08
meas tran mf_su_vbemin_q2 MIN mfq_vbe_q2 from=0.0 to=2e-08
meas tran mf_ss_vbemax_q2 MAX mfq_vbe_q2 from=2e-08 to=4e-08
meas tran mf_ss_vbemin_q2 MIN mfq_vbe_q2 from=2e-08 to=4e-08
let mfq_ic_q2 = i(vic_q2)
meas tran mf_su_icmax_q2 MAX mfq_ic_q2 from=0.0 to=2e-08
meas tran mf_su_icmin_q2 MIN mfq_ic_q2 from=0.0 to=2e-08
meas tran mf_ss_icmax_q2 MAX mfq_ic_q2 from=2e-08 to=4e-08
meas tran mf_ss_icmin_q2 MIN mfq_ic_q2 from=2e-08 to=4e-08
let mfq_vce_q3 = v(c_q3)-v(x1)
meas tran mf_su_vcemax_q3 MAX mfq_vce_q3 from=0.0 to=2e-08
meas tran mf_su_vcemin_q3 MIN mfq_vce_q3 from=0.0 to=2e-08
meas tran mf_ss_vcemax_q3 MAX mfq_vce_q3 from=2e-08 to=4e-08
meas tran mf_ss_vcemin_q3 MIN mfq_vce_q3 from=2e-08 to=4e-08
let mfq_vbe_q3 = v(lo_p)-v(x1)
meas tran mf_su_vbemax_q3 MAX mfq_vbe_q3 from=0.0 to=2e-08
meas tran mf_su_vbemin_q3 MIN mfq_vbe_q3 from=0.0 to=2e-08
meas tran mf_ss_vbemax_q3 MAX mfq_vbe_q3 from=2e-08 to=4e-08
meas tran mf_ss_vbemin_q3 MIN mfq_vbe_q3 from=2e-08 to=4e-08
let mfq_ic_q3 = i(vic_q3)
meas tran mf_su_icmax_q3 MAX mfq_ic_q3 from=0.0 to=2e-08
meas tran mf_su_icmin_q3 MIN mfq_ic_q3 from=0.0 to=2e-08
meas tran mf_ss_icmax_q3 MAX mfq_ic_q3 from=2e-08 to=4e-08
meas tran mf_ss_icmin_q3 MIN mfq_ic_q3 from=2e-08 to=4e-08
let mfq_vce_q4 = v(c_q4)-v(x1)
meas tran mf_su_vcemax_q4 MAX mfq_vce_q4 from=0.0 to=2e-08
meas tran mf_su_vcemin_q4 MIN mfq_vce_q4 from=0.0 to=2e-08
meas tran mf_ss_vcemax_q4 MAX mfq_vce_q4 from=2e-08 to=4e-08
meas tran mf_ss_vcemin_q4 MIN mfq_vce_q4 from=2e-08 to=4e-08
let mfq_vbe_q4 = v(lo_n)-v(x1)
meas tran mf_su_vbemax_q4 MAX mfq_vbe_q4 from=0.0 to=2e-08
meas tran mf_su_vbemin_q4 MIN mfq_vbe_q4 from=0.0 to=2e-08
meas tran mf_ss_vbemax_q4 MAX mfq_vbe_q4 from=2e-08 to=4e-08
meas tran mf_ss_vbemin_q4 MIN mfq_vbe_q4 from=2e-08 to=4e-08
let mfq_ic_q4 = i(vic_q4)
meas tran mf_su_icmax_q4 MAX mfq_ic_q4 from=0.0 to=2e-08
meas tran mf_su_icmin_q4 MIN mfq_ic_q4 from=0.0 to=2e-08
meas tran mf_ss_icmax_q4 MAX mfq_ic_q4 from=2e-08 to=4e-08
meas tran mf_ss_icmin_q4 MIN mfq_ic_q4 from=2e-08 to=4e-08
let mfq_vce_q5 = v(c_q5)-v(x2)
meas tran mf_su_vcemax_q5 MAX mfq_vce_q5 from=0.0 to=2e-08
meas tran mf_su_vcemin_q5 MIN mfq_vce_q5 from=0.0 to=2e-08
meas tran mf_ss_vcemax_q5 MAX mfq_vce_q5 from=2e-08 to=4e-08
meas tran mf_ss_vcemin_q5 MIN mfq_vce_q5 from=2e-08 to=4e-08
let mfq_vbe_q5 = v(lo_p)-v(x2)
meas tran mf_su_vbemax_q5 MAX mfq_vbe_q5 from=0.0 to=2e-08
meas tran mf_su_vbemin_q5 MIN mfq_vbe_q5 from=0.0 to=2e-08
meas tran mf_ss_vbemax_q5 MAX mfq_vbe_q5 from=2e-08 to=4e-08
meas tran mf_ss_vbemin_q5 MIN mfq_vbe_q5 from=2e-08 to=4e-08
let mfq_ic_q5 = i(vic_q5)
meas tran mf_su_icmax_q5 MAX mfq_ic_q5 from=0.0 to=2e-08
meas tran mf_su_icmin_q5 MIN mfq_ic_q5 from=0.0 to=2e-08
meas tran mf_ss_icmax_q5 MAX mfq_ic_q5 from=2e-08 to=4e-08
meas tran mf_ss_icmin_q5 MIN mfq_ic_q5 from=2e-08 to=4e-08
let mfq_vce_q6 = v(c_q6)-v(x2)
meas tran mf_su_vcemax_q6 MAX mfq_vce_q6 from=0.0 to=2e-08
meas tran mf_su_vcemin_q6 MIN mfq_vce_q6 from=0.0 to=2e-08
meas tran mf_ss_vcemax_q6 MAX mfq_vce_q6 from=2e-08 to=4e-08
meas tran mf_ss_vcemin_q6 MIN mfq_vce_q6 from=2e-08 to=4e-08
let mfq_vbe_q6 = v(lo_n)-v(x2)
meas tran mf_su_vbemax_q6 MAX mfq_vbe_q6 from=0.0 to=2e-08
meas tran mf_su_vbemin_q6 MIN mfq_vbe_q6 from=0.0 to=2e-08
meas tran mf_ss_vbemax_q6 MAX mfq_vbe_q6 from=2e-08 to=4e-08
meas tran mf_ss_vbemin_q6 MIN mfq_vbe_q6 from=2e-08 to=4e-08
let mfq_ic_q6 = i(vic_q6)
meas tran mf_su_icmax_q6 MAX mfq_ic_q6 from=0.0 to=2e-08
meas tran mf_su_icmin_q6 MIN mfq_ic_q6 from=0.0 to=2e-08
meas tran mf_ss_icmax_q6 MAX mfq_ic_q6 from=2e-08 to=4e-08
meas tran mf_ss_icmin_q6 MIN mfq_ic_q6 from=2e-08 to=4e-08
meas tran mf_su_sinkmin_tail MIN v(tail) from=0.0 to=2e-08
meas tran mf_ss_sinkmin_tail MIN v(tail) from=2e-08 to=4e-08
print mf_su_vcemax_q1
print mf_su_vcemin_q1
print mf_ss_vcemax_q1
print mf_ss_vcemin_q1
print mf_su_vbemax_q1
print mf_su_vbemin_q1
print mf_ss_vbemax_q1
print mf_ss_vbemin_q1
print mf_su_icmax_q1
print mf_su_icmin_q1
print mf_ss_icmax_q1
print mf_ss_icmin_q1
print mf_su_vcemax_q2
print mf_su_vcemin_q2
print mf_ss_vcemax_q2
print mf_ss_vcemin_q2
print mf_su_vbemax_q2
print mf_su_vbemin_q2
print mf_ss_vbemax_q2
print mf_ss_vbemin_q2
print mf_su_icmax_q2
print mf_su_icmin_q2
print mf_ss_icmax_q2
print mf_ss_icmin_q2
print mf_su_vcemax_q3
print mf_su_vcemin_q3
print mf_ss_vcemax_q3
print mf_ss_vcemin_q3
print mf_su_vbemax_q3
print mf_su_vbemin_q3
print mf_ss_vbemax_q3
print mf_ss_vbemin_q3
print mf_su_icmax_q3
print mf_su_icmin_q3
print mf_ss_icmax_q3
print mf_ss_icmin_q3
print mf_su_vcemax_q4
print mf_su_vcemin_q4
print mf_ss_vcemax_q4
print mf_ss_vcemin_q4
print mf_su_vbemax_q4
print mf_su_vbemin_q4
print mf_ss_vbemax_q4
print mf_ss_vbemin_q4
print mf_su_icmax_q4
print mf_su_icmin_q4
print mf_ss_icmax_q4
print mf_ss_icmin_q4
print mf_su_vcemax_q5
print mf_su_vcemin_q5
print mf_ss_vcemax_q5
print mf_ss_vcemin_q5
print mf_su_vbemax_q5
print mf_su_vbemin_q5
print mf_ss_vbemax_q5
print mf_ss_vbemin_q5
print mf_su_icmax_q5
print mf_su_icmin_q5
print mf_ss_icmax_q5
print mf_ss_icmin_q5
print mf_su_vcemax_q6
print mf_su_vcemin_q6
print mf_ss_vcemax_q6
print mf_ss_vcemin_q6
print mf_su_vbemax_q6
print mf_su_vbemin_q6
print mf_ss_vbemax_q6
print mf_ss_vbemin_q6
print mf_su_icmax_q6
print mf_su_icmin_q6
print mf_ss_icmax_q6
print mf_ss_icmin_q6
print mf_su_sinkmin_tail
print mf_ss_sinkmin_tail
linearize
let mf_l = length(time)
let mfw = (time ge 1.99995e-08) * (time lt 3.99995e-08)
let mf_n = mean(mfw) * mf_l
let mfs = mf_l / mf_n
let mf_prail = mean(v(vdd) * (0 - i(vdd)) * mfw) * mfs
let mfph = 2 * pi * 20200000000.0 * (time - 2e-08)
let mf_lodiff_re = 2 * mean((v(lo_p)-v(lo_n)) * mfw * cos(mfph)) * mfs
let mf_lodiff_im = 2 * mean((v(lo_p)-v(lo_n)) * mfw * sin(mfph)) * mfs
let mfph = 2 * pi * 1000000000.0 * (time - 2e-08)
let mf_if_re = 2 * mean((v(if_out)) * mfw * cos(mfph)) * mfs
let mf_if_im = 2 * mean((v(if_out)) * mfw * sin(mfph)) * mfs
let mfph = 2 * pi * 20200000000.0 * (time - 2e-08)
let mf_loif_re = 2 * mean((v(if_out)) * mfw * cos(mfph)) * mfs
let mf_loif_im = 2 * mean((v(if_out)) * mfw * sin(mfph)) * mfs
let mfph = 2 * pi * 20200000000.0 * (time - 2e-08)
let mf_lorf_re = 2 * mean((v(rf_port)) * mfw * cos(mfph)) * mfs
let mf_lorf_im = 2 * mean((v(rf_port)) * mfw * sin(mfph)) * mfs
let mfph = 2 * pi * 950000000.0 * (time - 2e-08)
let mf_flifa_re = 2 * mean((v(if_out)) * mfw * cos(mfph)) * mfs
let mf_flifa_im = 2 * mean((v(if_out)) * mfw * sin(mfph)) * mfs
let mfph = 2 * pi * 1050000000.0 * (time - 2e-08)
let mf_flifb_re = 2 * mean((v(if_out)) * mfw * cos(mfph)) * mfs
let mf_flifb_im = 2 * mean((v(if_out)) * mfw * sin(mfph)) * mfs
let mfph = 2 * pi * 20250000000.0 * (time - 2e-08)
let mf_fllorf_re = 2 * mean((v(rf_port)) * mfw * cos(mfph)) * mfs
let mf_fllorf_im = 2 * mean((v(rf_port)) * mfw * sin(mfph)) * mfs
let mfph = 2 * pi * 20250000000.0 * (time - 2e-08)
let mf_flloif_re = 2 * mean((v(if_out)) * mfw * cos(mfph)) * mfs
let mf_flloif_im = 2 * mean((v(if_out)) * mfw * sin(mfph)) * mfs
print mf_l
print mf_n
print mf_prail
print mf_lodiff_re
print mf_lodiff_im
print mf_if_re
print mf_if_im
print mf_loif_re
print mf_loif_im
print mf_lorf_re
print mf_lorf_im
print mf_flifa_re
print mf_flifa_im
print mf_flifb_re
print mf_flifb_im
print mf_fllorf_re
print mf_fllorf_im
print mf_flloif_re
print mf_flloif_im
destroy all
echo "MFEND ls_f21p20_m6_rf60"
echo "MFRUN ls_f21p20_m6_rf66"
alterparam f1 = 21200000000.0
alterparam f2 = 21200000000.0
alterparam flo = 20200000000.0
alterparam vrf1 = 0.00031697863849222284
alterparam vrf2 = 0.0
alterparam vlo = 0.44827548953825974
reset
op
let mf_dcirail = 0 - i(vdd)
let mf_dc_vce_q1 = v(c_q1)-v(e_q1)
let mf_dc_vbe_q1 = v(b_q1)-v(e_q1)
let mf_dc_ic_q1 = i(vic_q1)
let mf_dc_vce_q2 = v(c_q2)-v(e_q2)
let mf_dc_vbe_q2 = v(b_q2)-v(e_q2)
let mf_dc_ic_q2 = i(vic_q2)
let mf_dc_vce_q3 = v(c_q3)-v(x1)
let mf_dc_vbe_q3 = v(lo_p)-v(x1)
let mf_dc_ic_q3 = i(vic_q3)
let mf_dc_vce_q4 = v(c_q4)-v(x1)
let mf_dc_vbe_q4 = v(lo_n)-v(x1)
let mf_dc_ic_q4 = i(vic_q4)
let mf_dc_vce_q5 = v(c_q5)-v(x2)
let mf_dc_vbe_q5 = v(lo_p)-v(x2)
let mf_dc_ic_q5 = i(vic_q5)
let mf_dc_vce_q6 = v(c_q6)-v(x2)
let mf_dc_vbe_q6 = v(lo_n)-v(x2)
let mf_dc_ic_q6 = i(vic_q6)
let mf_dc_sink_tail = v(tail)
print mf_dcirail
print mf_dc_vce_q1
print mf_dc_vbe_q1
print mf_dc_ic_q1
print mf_dc_vce_q2
print mf_dc_vbe_q2
print mf_dc_ic_q2
print mf_dc_vce_q3
print mf_dc_vbe_q3
print mf_dc_ic_q3
print mf_dc_vce_q4
print mf_dc_vbe_q4
print mf_dc_ic_q4
print mf_dc_vce_q5
print mf_dc_vbe_q5
print mf_dc_ic_q5
print mf_dc_vce_q6
print mf_dc_vbe_q6
print mf_dc_ic_q6
print mf_dc_sink_tail
tran 1e-12 4e-08 0 1e-12
let mfq_vce_q1 = v(c_q1)-v(e_q1)
meas tran mf_su_vcemax_q1 MAX mfq_vce_q1 from=0.0 to=2e-08
meas tran mf_su_vcemin_q1 MIN mfq_vce_q1 from=0.0 to=2e-08
meas tran mf_ss_vcemax_q1 MAX mfq_vce_q1 from=2e-08 to=4e-08
meas tran mf_ss_vcemin_q1 MIN mfq_vce_q1 from=2e-08 to=4e-08
let mfq_vbe_q1 = v(b_q1)-v(e_q1)
meas tran mf_su_vbemax_q1 MAX mfq_vbe_q1 from=0.0 to=2e-08
meas tran mf_su_vbemin_q1 MIN mfq_vbe_q1 from=0.0 to=2e-08
meas tran mf_ss_vbemax_q1 MAX mfq_vbe_q1 from=2e-08 to=4e-08
meas tran mf_ss_vbemin_q1 MIN mfq_vbe_q1 from=2e-08 to=4e-08
let mfq_ic_q1 = i(vic_q1)
meas tran mf_su_icmax_q1 MAX mfq_ic_q1 from=0.0 to=2e-08
meas tran mf_su_icmin_q1 MIN mfq_ic_q1 from=0.0 to=2e-08
meas tran mf_ss_icmax_q1 MAX mfq_ic_q1 from=2e-08 to=4e-08
meas tran mf_ss_icmin_q1 MIN mfq_ic_q1 from=2e-08 to=4e-08
let mfq_vce_q2 = v(c_q2)-v(e_q2)
meas tran mf_su_vcemax_q2 MAX mfq_vce_q2 from=0.0 to=2e-08
meas tran mf_su_vcemin_q2 MIN mfq_vce_q2 from=0.0 to=2e-08
meas tran mf_ss_vcemax_q2 MAX mfq_vce_q2 from=2e-08 to=4e-08
meas tran mf_ss_vcemin_q2 MIN mfq_vce_q2 from=2e-08 to=4e-08
let mfq_vbe_q2 = v(b_q2)-v(e_q2)
meas tran mf_su_vbemax_q2 MAX mfq_vbe_q2 from=0.0 to=2e-08
meas tran mf_su_vbemin_q2 MIN mfq_vbe_q2 from=0.0 to=2e-08
meas tran mf_ss_vbemax_q2 MAX mfq_vbe_q2 from=2e-08 to=4e-08
meas tran mf_ss_vbemin_q2 MIN mfq_vbe_q2 from=2e-08 to=4e-08
let mfq_ic_q2 = i(vic_q2)
meas tran mf_su_icmax_q2 MAX mfq_ic_q2 from=0.0 to=2e-08
meas tran mf_su_icmin_q2 MIN mfq_ic_q2 from=0.0 to=2e-08
meas tran mf_ss_icmax_q2 MAX mfq_ic_q2 from=2e-08 to=4e-08
meas tran mf_ss_icmin_q2 MIN mfq_ic_q2 from=2e-08 to=4e-08
let mfq_vce_q3 = v(c_q3)-v(x1)
meas tran mf_su_vcemax_q3 MAX mfq_vce_q3 from=0.0 to=2e-08
meas tran mf_su_vcemin_q3 MIN mfq_vce_q3 from=0.0 to=2e-08
meas tran mf_ss_vcemax_q3 MAX mfq_vce_q3 from=2e-08 to=4e-08
meas tran mf_ss_vcemin_q3 MIN mfq_vce_q3 from=2e-08 to=4e-08
let mfq_vbe_q3 = v(lo_p)-v(x1)
meas tran mf_su_vbemax_q3 MAX mfq_vbe_q3 from=0.0 to=2e-08
meas tran mf_su_vbemin_q3 MIN mfq_vbe_q3 from=0.0 to=2e-08
meas tran mf_ss_vbemax_q3 MAX mfq_vbe_q3 from=2e-08 to=4e-08
meas tran mf_ss_vbemin_q3 MIN mfq_vbe_q3 from=2e-08 to=4e-08
let mfq_ic_q3 = i(vic_q3)
meas tran mf_su_icmax_q3 MAX mfq_ic_q3 from=0.0 to=2e-08
meas tran mf_su_icmin_q3 MIN mfq_ic_q3 from=0.0 to=2e-08
meas tran mf_ss_icmax_q3 MAX mfq_ic_q3 from=2e-08 to=4e-08
meas tran mf_ss_icmin_q3 MIN mfq_ic_q3 from=2e-08 to=4e-08
let mfq_vce_q4 = v(c_q4)-v(x1)
meas tran mf_su_vcemax_q4 MAX mfq_vce_q4 from=0.0 to=2e-08
meas tran mf_su_vcemin_q4 MIN mfq_vce_q4 from=0.0 to=2e-08
meas tran mf_ss_vcemax_q4 MAX mfq_vce_q4 from=2e-08 to=4e-08
meas tran mf_ss_vcemin_q4 MIN mfq_vce_q4 from=2e-08 to=4e-08
let mfq_vbe_q4 = v(lo_n)-v(x1)
meas tran mf_su_vbemax_q4 MAX mfq_vbe_q4 from=0.0 to=2e-08
meas tran mf_su_vbemin_q4 MIN mfq_vbe_q4 from=0.0 to=2e-08
meas tran mf_ss_vbemax_q4 MAX mfq_vbe_q4 from=2e-08 to=4e-08
meas tran mf_ss_vbemin_q4 MIN mfq_vbe_q4 from=2e-08 to=4e-08
let mfq_ic_q4 = i(vic_q4)
meas tran mf_su_icmax_q4 MAX mfq_ic_q4 from=0.0 to=2e-08
meas tran mf_su_icmin_q4 MIN mfq_ic_q4 from=0.0 to=2e-08
meas tran mf_ss_icmax_q4 MAX mfq_ic_q4 from=2e-08 to=4e-08
meas tran mf_ss_icmin_q4 MIN mfq_ic_q4 from=2e-08 to=4e-08
let mfq_vce_q5 = v(c_q5)-v(x2)
meas tran mf_su_vcemax_q5 MAX mfq_vce_q5 from=0.0 to=2e-08
meas tran mf_su_vcemin_q5 MIN mfq_vce_q5 from=0.0 to=2e-08
meas tran mf_ss_vcemax_q5 MAX mfq_vce_q5 from=2e-08 to=4e-08
meas tran mf_ss_vcemin_q5 MIN mfq_vce_q5 from=2e-08 to=4e-08
let mfq_vbe_q5 = v(lo_p)-v(x2)
meas tran mf_su_vbemax_q5 MAX mfq_vbe_q5 from=0.0 to=2e-08
meas tran mf_su_vbemin_q5 MIN mfq_vbe_q5 from=0.0 to=2e-08
meas tran mf_ss_vbemax_q5 MAX mfq_vbe_q5 from=2e-08 to=4e-08
meas tran mf_ss_vbemin_q5 MIN mfq_vbe_q5 from=2e-08 to=4e-08
let mfq_ic_q5 = i(vic_q5)
meas tran mf_su_icmax_q5 MAX mfq_ic_q5 from=0.0 to=2e-08
meas tran mf_su_icmin_q5 MIN mfq_ic_q5 from=0.0 to=2e-08
meas tran mf_ss_icmax_q5 MAX mfq_ic_q5 from=2e-08 to=4e-08
meas tran mf_ss_icmin_q5 MIN mfq_ic_q5 from=2e-08 to=4e-08
let mfq_vce_q6 = v(c_q6)-v(x2)
meas tran mf_su_vcemax_q6 MAX mfq_vce_q6 from=0.0 to=2e-08
meas tran mf_su_vcemin_q6 MIN mfq_vce_q6 from=0.0 to=2e-08
meas tran mf_ss_vcemax_q6 MAX mfq_vce_q6 from=2e-08 to=4e-08
meas tran mf_ss_vcemin_q6 MIN mfq_vce_q6 from=2e-08 to=4e-08
let mfq_vbe_q6 = v(lo_n)-v(x2)
meas tran mf_su_vbemax_q6 MAX mfq_vbe_q6 from=0.0 to=2e-08
meas tran mf_su_vbemin_q6 MIN mfq_vbe_q6 from=0.0 to=2e-08
meas tran mf_ss_vbemax_q6 MAX mfq_vbe_q6 from=2e-08 to=4e-08
meas tran mf_ss_vbemin_q6 MIN mfq_vbe_q6 from=2e-08 to=4e-08
let mfq_ic_q6 = i(vic_q6)
meas tran mf_su_icmax_q6 MAX mfq_ic_q6 from=0.0 to=2e-08
meas tran mf_su_icmin_q6 MIN mfq_ic_q6 from=0.0 to=2e-08
meas tran mf_ss_icmax_q6 MAX mfq_ic_q6 from=2e-08 to=4e-08
meas tran mf_ss_icmin_q6 MIN mfq_ic_q6 from=2e-08 to=4e-08
meas tran mf_su_sinkmin_tail MIN v(tail) from=0.0 to=2e-08
meas tran mf_ss_sinkmin_tail MIN v(tail) from=2e-08 to=4e-08
print mf_su_vcemax_q1
print mf_su_vcemin_q1
print mf_ss_vcemax_q1
print mf_ss_vcemin_q1
print mf_su_vbemax_q1
print mf_su_vbemin_q1
print mf_ss_vbemax_q1
print mf_ss_vbemin_q1
print mf_su_icmax_q1
print mf_su_icmin_q1
print mf_ss_icmax_q1
print mf_ss_icmin_q1
print mf_su_vcemax_q2
print mf_su_vcemin_q2
print mf_ss_vcemax_q2
print mf_ss_vcemin_q2
print mf_su_vbemax_q2
print mf_su_vbemin_q2
print mf_ss_vbemax_q2
print mf_ss_vbemin_q2
print mf_su_icmax_q2
print mf_su_icmin_q2
print mf_ss_icmax_q2
print mf_ss_icmin_q2
print mf_su_vcemax_q3
print mf_su_vcemin_q3
print mf_ss_vcemax_q3
print mf_ss_vcemin_q3
print mf_su_vbemax_q3
print mf_su_vbemin_q3
print mf_ss_vbemax_q3
print mf_ss_vbemin_q3
print mf_su_icmax_q3
print mf_su_icmin_q3
print mf_ss_icmax_q3
print mf_ss_icmin_q3
print mf_su_vcemax_q4
print mf_su_vcemin_q4
print mf_ss_vcemax_q4
print mf_ss_vcemin_q4
print mf_su_vbemax_q4
print mf_su_vbemin_q4
print mf_ss_vbemax_q4
print mf_ss_vbemin_q4
print mf_su_icmax_q4
print mf_su_icmin_q4
print mf_ss_icmax_q4
print mf_ss_icmin_q4
print mf_su_vcemax_q5
print mf_su_vcemin_q5
print mf_ss_vcemax_q5
print mf_ss_vcemin_q5
print mf_su_vbemax_q5
print mf_su_vbemin_q5
print mf_ss_vbemax_q5
print mf_ss_vbemin_q5
print mf_su_icmax_q5
print mf_su_icmin_q5
print mf_ss_icmax_q5
print mf_ss_icmin_q5
print mf_su_vcemax_q6
print mf_su_vcemin_q6
print mf_ss_vcemax_q6
print mf_ss_vcemin_q6
print mf_su_vbemax_q6
print mf_su_vbemin_q6
print mf_ss_vbemax_q6
print mf_ss_vbemin_q6
print mf_su_icmax_q6
print mf_su_icmin_q6
print mf_ss_icmax_q6
print mf_ss_icmin_q6
print mf_su_sinkmin_tail
print mf_ss_sinkmin_tail
linearize
let mf_l = length(time)
let mfw = (time ge 1.99995e-08) * (time lt 3.99995e-08)
let mf_n = mean(mfw) * mf_l
let mfs = mf_l / mf_n
let mf_prail = mean(v(vdd) * (0 - i(vdd)) * mfw) * mfs
let mfph = 2 * pi * 20200000000.0 * (time - 2e-08)
let mf_lodiff_re = 2 * mean((v(lo_p)-v(lo_n)) * mfw * cos(mfph)) * mfs
let mf_lodiff_im = 2 * mean((v(lo_p)-v(lo_n)) * mfw * sin(mfph)) * mfs
let mfph = 2 * pi * 1000000000.0 * (time - 2e-08)
let mf_if_re = 2 * mean((v(if_out)) * mfw * cos(mfph)) * mfs
let mf_if_im = 2 * mean((v(if_out)) * mfw * sin(mfph)) * mfs
let mfph = 2 * pi * 20200000000.0 * (time - 2e-08)
let mf_loif_re = 2 * mean((v(if_out)) * mfw * cos(mfph)) * mfs
let mf_loif_im = 2 * mean((v(if_out)) * mfw * sin(mfph)) * mfs
let mfph = 2 * pi * 20200000000.0 * (time - 2e-08)
let mf_lorf_re = 2 * mean((v(rf_port)) * mfw * cos(mfph)) * mfs
let mf_lorf_im = 2 * mean((v(rf_port)) * mfw * sin(mfph)) * mfs
let mfph = 2 * pi * 950000000.0 * (time - 2e-08)
let mf_flifa_re = 2 * mean((v(if_out)) * mfw * cos(mfph)) * mfs
let mf_flifa_im = 2 * mean((v(if_out)) * mfw * sin(mfph)) * mfs
let mfph = 2 * pi * 1050000000.0 * (time - 2e-08)
let mf_flifb_re = 2 * mean((v(if_out)) * mfw * cos(mfph)) * mfs
let mf_flifb_im = 2 * mean((v(if_out)) * mfw * sin(mfph)) * mfs
let mfph = 2 * pi * 20250000000.0 * (time - 2e-08)
let mf_fllorf_re = 2 * mean((v(rf_port)) * mfw * cos(mfph)) * mfs
let mf_fllorf_im = 2 * mean((v(rf_port)) * mfw * sin(mfph)) * mfs
let mfph = 2 * pi * 20250000000.0 * (time - 2e-08)
let mf_flloif_re = 2 * mean((v(if_out)) * mfw * cos(mfph)) * mfs
let mf_flloif_im = 2 * mean((v(if_out)) * mfw * sin(mfph)) * mfs
print mf_l
print mf_n
print mf_prail
print mf_lodiff_re
print mf_lodiff_im
print mf_if_re
print mf_if_im
print mf_loif_re
print mf_loif_im
print mf_lorf_re
print mf_lorf_im
print mf_flifa_re
print mf_flifa_im
print mf_flifb_re
print mf_flifb_im
print mf_fllorf_re
print mf_fllorf_im
print mf_flloif_re
print mf_flloif_im
destroy all
echo "MFEND ls_f21p20_m6_rf66"
echo "MFRUN ls_f21p20_m3_rf60"
alterparam f1 = 21200000000.0
alterparam f2 = 21200000000.0
alterparam flo = 20200000000.0
alterparam vrf1 = 0.0006324555320336759
alterparam vrf2 = 0.0
alterparam vlo = 0.6332059593069366
reset
op
let mf_dcirail = 0 - i(vdd)
let mf_dc_vce_q1 = v(c_q1)-v(e_q1)
let mf_dc_vbe_q1 = v(b_q1)-v(e_q1)
let mf_dc_ic_q1 = i(vic_q1)
let mf_dc_vce_q2 = v(c_q2)-v(e_q2)
let mf_dc_vbe_q2 = v(b_q2)-v(e_q2)
let mf_dc_ic_q2 = i(vic_q2)
let mf_dc_vce_q3 = v(c_q3)-v(x1)
let mf_dc_vbe_q3 = v(lo_p)-v(x1)
let mf_dc_ic_q3 = i(vic_q3)
let mf_dc_vce_q4 = v(c_q4)-v(x1)
let mf_dc_vbe_q4 = v(lo_n)-v(x1)
let mf_dc_ic_q4 = i(vic_q4)
let mf_dc_vce_q5 = v(c_q5)-v(x2)
let mf_dc_vbe_q5 = v(lo_p)-v(x2)
let mf_dc_ic_q5 = i(vic_q5)
let mf_dc_vce_q6 = v(c_q6)-v(x2)
let mf_dc_vbe_q6 = v(lo_n)-v(x2)
let mf_dc_ic_q6 = i(vic_q6)
let mf_dc_sink_tail = v(tail)
print mf_dcirail
print mf_dc_vce_q1
print mf_dc_vbe_q1
print mf_dc_ic_q1
print mf_dc_vce_q2
print mf_dc_vbe_q2
print mf_dc_ic_q2
print mf_dc_vce_q3
print mf_dc_vbe_q3
print mf_dc_ic_q3
print mf_dc_vce_q4
print mf_dc_vbe_q4
print mf_dc_ic_q4
print mf_dc_vce_q5
print mf_dc_vbe_q5
print mf_dc_ic_q5
print mf_dc_vce_q6
print mf_dc_vbe_q6
print mf_dc_ic_q6
print mf_dc_sink_tail
tran 1e-12 4e-08 0 1e-12
let mfq_vce_q1 = v(c_q1)-v(e_q1)
meas tran mf_su_vcemax_q1 MAX mfq_vce_q1 from=0.0 to=2e-08
meas tran mf_su_vcemin_q1 MIN mfq_vce_q1 from=0.0 to=2e-08
meas tran mf_ss_vcemax_q1 MAX mfq_vce_q1 from=2e-08 to=4e-08
meas tran mf_ss_vcemin_q1 MIN mfq_vce_q1 from=2e-08 to=4e-08
let mfq_vbe_q1 = v(b_q1)-v(e_q1)
meas tran mf_su_vbemax_q1 MAX mfq_vbe_q1 from=0.0 to=2e-08
meas tran mf_su_vbemin_q1 MIN mfq_vbe_q1 from=0.0 to=2e-08
meas tran mf_ss_vbemax_q1 MAX mfq_vbe_q1 from=2e-08 to=4e-08
meas tran mf_ss_vbemin_q1 MIN mfq_vbe_q1 from=2e-08 to=4e-08
let mfq_ic_q1 = i(vic_q1)
meas tran mf_su_icmax_q1 MAX mfq_ic_q1 from=0.0 to=2e-08
meas tran mf_su_icmin_q1 MIN mfq_ic_q1 from=0.0 to=2e-08
meas tran mf_ss_icmax_q1 MAX mfq_ic_q1 from=2e-08 to=4e-08
meas tran mf_ss_icmin_q1 MIN mfq_ic_q1 from=2e-08 to=4e-08
let mfq_vce_q2 = v(c_q2)-v(e_q2)
meas tran mf_su_vcemax_q2 MAX mfq_vce_q2 from=0.0 to=2e-08
meas tran mf_su_vcemin_q2 MIN mfq_vce_q2 from=0.0 to=2e-08
meas tran mf_ss_vcemax_q2 MAX mfq_vce_q2 from=2e-08 to=4e-08
meas tran mf_ss_vcemin_q2 MIN mfq_vce_q2 from=2e-08 to=4e-08
let mfq_vbe_q2 = v(b_q2)-v(e_q2)
meas tran mf_su_vbemax_q2 MAX mfq_vbe_q2 from=0.0 to=2e-08
meas tran mf_su_vbemin_q2 MIN mfq_vbe_q2 from=0.0 to=2e-08
meas tran mf_ss_vbemax_q2 MAX mfq_vbe_q2 from=2e-08 to=4e-08
meas tran mf_ss_vbemin_q2 MIN mfq_vbe_q2 from=2e-08 to=4e-08
let mfq_ic_q2 = i(vic_q2)
meas tran mf_su_icmax_q2 MAX mfq_ic_q2 from=0.0 to=2e-08
meas tran mf_su_icmin_q2 MIN mfq_ic_q2 from=0.0 to=2e-08
meas tran mf_ss_icmax_q2 MAX mfq_ic_q2 from=2e-08 to=4e-08
meas tran mf_ss_icmin_q2 MIN mfq_ic_q2 from=2e-08 to=4e-08
let mfq_vce_q3 = v(c_q3)-v(x1)
meas tran mf_su_vcemax_q3 MAX mfq_vce_q3 from=0.0 to=2e-08
meas tran mf_su_vcemin_q3 MIN mfq_vce_q3 from=0.0 to=2e-08
meas tran mf_ss_vcemax_q3 MAX mfq_vce_q3 from=2e-08 to=4e-08
meas tran mf_ss_vcemin_q3 MIN mfq_vce_q3 from=2e-08 to=4e-08
let mfq_vbe_q3 = v(lo_p)-v(x1)
meas tran mf_su_vbemax_q3 MAX mfq_vbe_q3 from=0.0 to=2e-08
meas tran mf_su_vbemin_q3 MIN mfq_vbe_q3 from=0.0 to=2e-08
meas tran mf_ss_vbemax_q3 MAX mfq_vbe_q3 from=2e-08 to=4e-08
meas tran mf_ss_vbemin_q3 MIN mfq_vbe_q3 from=2e-08 to=4e-08
let mfq_ic_q3 = i(vic_q3)
meas tran mf_su_icmax_q3 MAX mfq_ic_q3 from=0.0 to=2e-08
meas tran mf_su_icmin_q3 MIN mfq_ic_q3 from=0.0 to=2e-08
meas tran mf_ss_icmax_q3 MAX mfq_ic_q3 from=2e-08 to=4e-08
meas tran mf_ss_icmin_q3 MIN mfq_ic_q3 from=2e-08 to=4e-08
let mfq_vce_q4 = v(c_q4)-v(x1)
meas tran mf_su_vcemax_q4 MAX mfq_vce_q4 from=0.0 to=2e-08
meas tran mf_su_vcemin_q4 MIN mfq_vce_q4 from=0.0 to=2e-08
meas tran mf_ss_vcemax_q4 MAX mfq_vce_q4 from=2e-08 to=4e-08
meas tran mf_ss_vcemin_q4 MIN mfq_vce_q4 from=2e-08 to=4e-08
let mfq_vbe_q4 = v(lo_n)-v(x1)
meas tran mf_su_vbemax_q4 MAX mfq_vbe_q4 from=0.0 to=2e-08
meas tran mf_su_vbemin_q4 MIN mfq_vbe_q4 from=0.0 to=2e-08
meas tran mf_ss_vbemax_q4 MAX mfq_vbe_q4 from=2e-08 to=4e-08
meas tran mf_ss_vbemin_q4 MIN mfq_vbe_q4 from=2e-08 to=4e-08
let mfq_ic_q4 = i(vic_q4)
meas tran mf_su_icmax_q4 MAX mfq_ic_q4 from=0.0 to=2e-08
meas tran mf_su_icmin_q4 MIN mfq_ic_q4 from=0.0 to=2e-08
meas tran mf_ss_icmax_q4 MAX mfq_ic_q4 from=2e-08 to=4e-08
meas tran mf_ss_icmin_q4 MIN mfq_ic_q4 from=2e-08 to=4e-08
let mfq_vce_q5 = v(c_q5)-v(x2)
meas tran mf_su_vcemax_q5 MAX mfq_vce_q5 from=0.0 to=2e-08
meas tran mf_su_vcemin_q5 MIN mfq_vce_q5 from=0.0 to=2e-08
meas tran mf_ss_vcemax_q5 MAX mfq_vce_q5 from=2e-08 to=4e-08
meas tran mf_ss_vcemin_q5 MIN mfq_vce_q5 from=2e-08 to=4e-08
let mfq_vbe_q5 = v(lo_p)-v(x2)
meas tran mf_su_vbemax_q5 MAX mfq_vbe_q5 from=0.0 to=2e-08
meas tran mf_su_vbemin_q5 MIN mfq_vbe_q5 from=0.0 to=2e-08
meas tran mf_ss_vbemax_q5 MAX mfq_vbe_q5 from=2e-08 to=4e-08
meas tran mf_ss_vbemin_q5 MIN mfq_vbe_q5 from=2e-08 to=4e-08
let mfq_ic_q5 = i(vic_q5)
meas tran mf_su_icmax_q5 MAX mfq_ic_q5 from=0.0 to=2e-08
meas tran mf_su_icmin_q5 MIN mfq_ic_q5 from=0.0 to=2e-08
meas tran mf_ss_icmax_q5 MAX mfq_ic_q5 from=2e-08 to=4e-08
meas tran mf_ss_icmin_q5 MIN mfq_ic_q5 from=2e-08 to=4e-08
let mfq_vce_q6 = v(c_q6)-v(x2)
meas tran mf_su_vcemax_q6 MAX mfq_vce_q6 from=0.0 to=2e-08
meas tran mf_su_vcemin_q6 MIN mfq_vce_q6 from=0.0 to=2e-08
meas tran mf_ss_vcemax_q6 MAX mfq_vce_q6 from=2e-08 to=4e-08
meas tran mf_ss_vcemin_q6 MIN mfq_vce_q6 from=2e-08 to=4e-08
let mfq_vbe_q6 = v(lo_n)-v(x2)
meas tran mf_su_vbemax_q6 MAX mfq_vbe_q6 from=0.0 to=2e-08
meas tran mf_su_vbemin_q6 MIN mfq_vbe_q6 from=0.0 to=2e-08
meas tran mf_ss_vbemax_q6 MAX mfq_vbe_q6 from=2e-08 to=4e-08
meas tran mf_ss_vbemin_q6 MIN mfq_vbe_q6 from=2e-08 to=4e-08
let mfq_ic_q6 = i(vic_q6)
meas tran mf_su_icmax_q6 MAX mfq_ic_q6 from=0.0 to=2e-08
meas tran mf_su_icmin_q6 MIN mfq_ic_q6 from=0.0 to=2e-08
meas tran mf_ss_icmax_q6 MAX mfq_ic_q6 from=2e-08 to=4e-08
meas tran mf_ss_icmin_q6 MIN mfq_ic_q6 from=2e-08 to=4e-08
meas tran mf_su_sinkmin_tail MIN v(tail) from=0.0 to=2e-08
meas tran mf_ss_sinkmin_tail MIN v(tail) from=2e-08 to=4e-08
print mf_su_vcemax_q1
print mf_su_vcemin_q1
print mf_ss_vcemax_q1
print mf_ss_vcemin_q1
print mf_su_vbemax_q1
print mf_su_vbemin_q1
print mf_ss_vbemax_q1
print mf_ss_vbemin_q1
print mf_su_icmax_q1
print mf_su_icmin_q1
print mf_ss_icmax_q1
print mf_ss_icmin_q1
print mf_su_vcemax_q2
print mf_su_vcemin_q2
print mf_ss_vcemax_q2
print mf_ss_vcemin_q2
print mf_su_vbemax_q2
print mf_su_vbemin_q2
print mf_ss_vbemax_q2
print mf_ss_vbemin_q2
print mf_su_icmax_q2
print mf_su_icmin_q2
print mf_ss_icmax_q2
print mf_ss_icmin_q2
print mf_su_vcemax_q3
print mf_su_vcemin_q3
print mf_ss_vcemax_q3
print mf_ss_vcemin_q3
print mf_su_vbemax_q3
print mf_su_vbemin_q3
print mf_ss_vbemax_q3
print mf_ss_vbemin_q3
print mf_su_icmax_q3
print mf_su_icmin_q3
print mf_ss_icmax_q3
print mf_ss_icmin_q3
print mf_su_vcemax_q4
print mf_su_vcemin_q4
print mf_ss_vcemax_q4
print mf_ss_vcemin_q4
print mf_su_vbemax_q4
print mf_su_vbemin_q4
print mf_ss_vbemax_q4
print mf_ss_vbemin_q4
print mf_su_icmax_q4
print mf_su_icmin_q4
print mf_ss_icmax_q4
print mf_ss_icmin_q4
print mf_su_vcemax_q5
print mf_su_vcemin_q5
print mf_ss_vcemax_q5
print mf_ss_vcemin_q5
print mf_su_vbemax_q5
print mf_su_vbemin_q5
print mf_ss_vbemax_q5
print mf_ss_vbemin_q5
print mf_su_icmax_q5
print mf_su_icmin_q5
print mf_ss_icmax_q5
print mf_ss_icmin_q5
print mf_su_vcemax_q6
print mf_su_vcemin_q6
print mf_ss_vcemax_q6
print mf_ss_vcemin_q6
print mf_su_vbemax_q6
print mf_su_vbemin_q6
print mf_ss_vbemax_q6
print mf_ss_vbemin_q6
print mf_su_icmax_q6
print mf_su_icmin_q6
print mf_ss_icmax_q6
print mf_ss_icmin_q6
print mf_su_sinkmin_tail
print mf_ss_sinkmin_tail
linearize
let mf_l = length(time)
let mfw = (time ge 1.99995e-08) * (time lt 3.99995e-08)
let mf_n = mean(mfw) * mf_l
let mfs = mf_l / mf_n
let mf_prail = mean(v(vdd) * (0 - i(vdd)) * mfw) * mfs
let mfph = 2 * pi * 20200000000.0 * (time - 2e-08)
let mf_lodiff_re = 2 * mean((v(lo_p)-v(lo_n)) * mfw * cos(mfph)) * mfs
let mf_lodiff_im = 2 * mean((v(lo_p)-v(lo_n)) * mfw * sin(mfph)) * mfs
let mfph = 2 * pi * 1000000000.0 * (time - 2e-08)
let mf_if_re = 2 * mean((v(if_out)) * mfw * cos(mfph)) * mfs
let mf_if_im = 2 * mean((v(if_out)) * mfw * sin(mfph)) * mfs
let mfph = 2 * pi * 20200000000.0 * (time - 2e-08)
let mf_loif_re = 2 * mean((v(if_out)) * mfw * cos(mfph)) * mfs
let mf_loif_im = 2 * mean((v(if_out)) * mfw * sin(mfph)) * mfs
let mfph = 2 * pi * 20200000000.0 * (time - 2e-08)
let mf_lorf_re = 2 * mean((v(rf_port)) * mfw * cos(mfph)) * mfs
let mf_lorf_im = 2 * mean((v(rf_port)) * mfw * sin(mfph)) * mfs
let mfph = 2 * pi * 950000000.0 * (time - 2e-08)
let mf_flifa_re = 2 * mean((v(if_out)) * mfw * cos(mfph)) * mfs
let mf_flifa_im = 2 * mean((v(if_out)) * mfw * sin(mfph)) * mfs
let mfph = 2 * pi * 1050000000.0 * (time - 2e-08)
let mf_flifb_re = 2 * mean((v(if_out)) * mfw * cos(mfph)) * mfs
let mf_flifb_im = 2 * mean((v(if_out)) * mfw * sin(mfph)) * mfs
let mfph = 2 * pi * 20250000000.0 * (time - 2e-08)
let mf_fllorf_re = 2 * mean((v(rf_port)) * mfw * cos(mfph)) * mfs
let mf_fllorf_im = 2 * mean((v(rf_port)) * mfw * sin(mfph)) * mfs
let mfph = 2 * pi * 20250000000.0 * (time - 2e-08)
let mf_flloif_re = 2 * mean((v(if_out)) * mfw * cos(mfph)) * mfs
let mf_flloif_im = 2 * mean((v(if_out)) * mfw * sin(mfph)) * mfs
print mf_l
print mf_n
print mf_prail
print mf_lodiff_re
print mf_lodiff_im
print mf_if_re
print mf_if_im
print mf_loif_re
print mf_loif_im
print mf_lorf_re
print mf_lorf_im
print mf_flifa_re
print mf_flifa_im
print mf_flifb_re
print mf_flifb_im
print mf_fllorf_re
print mf_fllorf_im
print mf_flloif_re
print mf_flloif_im
destroy all
echo "MFEND ls_f21p20_m3_rf60"
echo "MFRUN ls_f21p20_m3_rf66"
alterparam f1 = 21200000000.0
alterparam f2 = 21200000000.0
alterparam flo = 20200000000.0
alterparam vrf1 = 0.00031697863849222284
alterparam vrf2 = 0.0
alterparam vlo = 0.6332059593069366
reset
op
let mf_dcirail = 0 - i(vdd)
let mf_dc_vce_q1 = v(c_q1)-v(e_q1)
let mf_dc_vbe_q1 = v(b_q1)-v(e_q1)
let mf_dc_ic_q1 = i(vic_q1)
let mf_dc_vce_q2 = v(c_q2)-v(e_q2)
let mf_dc_vbe_q2 = v(b_q2)-v(e_q2)
let mf_dc_ic_q2 = i(vic_q2)
let mf_dc_vce_q3 = v(c_q3)-v(x1)
let mf_dc_vbe_q3 = v(lo_p)-v(x1)
let mf_dc_ic_q3 = i(vic_q3)
let mf_dc_vce_q4 = v(c_q4)-v(x1)
let mf_dc_vbe_q4 = v(lo_n)-v(x1)
let mf_dc_ic_q4 = i(vic_q4)
let mf_dc_vce_q5 = v(c_q5)-v(x2)
let mf_dc_vbe_q5 = v(lo_p)-v(x2)
let mf_dc_ic_q5 = i(vic_q5)
let mf_dc_vce_q6 = v(c_q6)-v(x2)
let mf_dc_vbe_q6 = v(lo_n)-v(x2)
let mf_dc_ic_q6 = i(vic_q6)
let mf_dc_sink_tail = v(tail)
print mf_dcirail
print mf_dc_vce_q1
print mf_dc_vbe_q1
print mf_dc_ic_q1
print mf_dc_vce_q2
print mf_dc_vbe_q2
print mf_dc_ic_q2
print mf_dc_vce_q3
print mf_dc_vbe_q3
print mf_dc_ic_q3
print mf_dc_vce_q4
print mf_dc_vbe_q4
print mf_dc_ic_q4
print mf_dc_vce_q5
print mf_dc_vbe_q5
print mf_dc_ic_q5
print mf_dc_vce_q6
print mf_dc_vbe_q6
print mf_dc_ic_q6
print mf_dc_sink_tail
tran 1e-12 4e-08 0 1e-12
let mfq_vce_q1 = v(c_q1)-v(e_q1)
meas tran mf_su_vcemax_q1 MAX mfq_vce_q1 from=0.0 to=2e-08
meas tran mf_su_vcemin_q1 MIN mfq_vce_q1 from=0.0 to=2e-08
meas tran mf_ss_vcemax_q1 MAX mfq_vce_q1 from=2e-08 to=4e-08
meas tran mf_ss_vcemin_q1 MIN mfq_vce_q1 from=2e-08 to=4e-08
let mfq_vbe_q1 = v(b_q1)-v(e_q1)
meas tran mf_su_vbemax_q1 MAX mfq_vbe_q1 from=0.0 to=2e-08
meas tran mf_su_vbemin_q1 MIN mfq_vbe_q1 from=0.0 to=2e-08
meas tran mf_ss_vbemax_q1 MAX mfq_vbe_q1 from=2e-08 to=4e-08
meas tran mf_ss_vbemin_q1 MIN mfq_vbe_q1 from=2e-08 to=4e-08
let mfq_ic_q1 = i(vic_q1)
meas tran mf_su_icmax_q1 MAX mfq_ic_q1 from=0.0 to=2e-08
meas tran mf_su_icmin_q1 MIN mfq_ic_q1 from=0.0 to=2e-08
meas tran mf_ss_icmax_q1 MAX mfq_ic_q1 from=2e-08 to=4e-08
meas tran mf_ss_icmin_q1 MIN mfq_ic_q1 from=2e-08 to=4e-08
let mfq_vce_q2 = v(c_q2)-v(e_q2)
meas tran mf_su_vcemax_q2 MAX mfq_vce_q2 from=0.0 to=2e-08
meas tran mf_su_vcemin_q2 MIN mfq_vce_q2 from=0.0 to=2e-08
meas tran mf_ss_vcemax_q2 MAX mfq_vce_q2 from=2e-08 to=4e-08
meas tran mf_ss_vcemin_q2 MIN mfq_vce_q2 from=2e-08 to=4e-08
let mfq_vbe_q2 = v(b_q2)-v(e_q2)
meas tran mf_su_vbemax_q2 MAX mfq_vbe_q2 from=0.0 to=2e-08
meas tran mf_su_vbemin_q2 MIN mfq_vbe_q2 from=0.0 to=2e-08
meas tran mf_ss_vbemax_q2 MAX mfq_vbe_q2 from=2e-08 to=4e-08
meas tran mf_ss_vbemin_q2 MIN mfq_vbe_q2 from=2e-08 to=4e-08
let mfq_ic_q2 = i(vic_q2)
meas tran mf_su_icmax_q2 MAX mfq_ic_q2 from=0.0 to=2e-08
meas tran mf_su_icmin_q2 MIN mfq_ic_q2 from=0.0 to=2e-08
meas tran mf_ss_icmax_q2 MAX mfq_ic_q2 from=2e-08 to=4e-08
meas tran mf_ss_icmin_q2 MIN mfq_ic_q2 from=2e-08 to=4e-08
let mfq_vce_q3 = v(c_q3)-v(x1)
meas tran mf_su_vcemax_q3 MAX mfq_vce_q3 from=0.0 to=2e-08
meas tran mf_su_vcemin_q3 MIN mfq_vce_q3 from=0.0 to=2e-08
meas tran mf_ss_vcemax_q3 MAX mfq_vce_q3 from=2e-08 to=4e-08
meas tran mf_ss_vcemin_q3 MIN mfq_vce_q3 from=2e-08 to=4e-08
let mfq_vbe_q3 = v(lo_p)-v(x1)
meas tran mf_su_vbemax_q3 MAX mfq_vbe_q3 from=0.0 to=2e-08
meas tran mf_su_vbemin_q3 MIN mfq_vbe_q3 from=0.0 to=2e-08
meas tran mf_ss_vbemax_q3 MAX mfq_vbe_q3 from=2e-08 to=4e-08
meas tran mf_ss_vbemin_q3 MIN mfq_vbe_q3 from=2e-08 to=4e-08
let mfq_ic_q3 = i(vic_q3)
meas tran mf_su_icmax_q3 MAX mfq_ic_q3 from=0.0 to=2e-08
meas tran mf_su_icmin_q3 MIN mfq_ic_q3 from=0.0 to=2e-08
meas tran mf_ss_icmax_q3 MAX mfq_ic_q3 from=2e-08 to=4e-08
meas tran mf_ss_icmin_q3 MIN mfq_ic_q3 from=2e-08 to=4e-08
let mfq_vce_q4 = v(c_q4)-v(x1)
meas tran mf_su_vcemax_q4 MAX mfq_vce_q4 from=0.0 to=2e-08
meas tran mf_su_vcemin_q4 MIN mfq_vce_q4 from=0.0 to=2e-08
meas tran mf_ss_vcemax_q4 MAX mfq_vce_q4 from=2e-08 to=4e-08
meas tran mf_ss_vcemin_q4 MIN mfq_vce_q4 from=2e-08 to=4e-08
let mfq_vbe_q4 = v(lo_n)-v(x1)
meas tran mf_su_vbemax_q4 MAX mfq_vbe_q4 from=0.0 to=2e-08
meas tran mf_su_vbemin_q4 MIN mfq_vbe_q4 from=0.0 to=2e-08
meas tran mf_ss_vbemax_q4 MAX mfq_vbe_q4 from=2e-08 to=4e-08
meas tran mf_ss_vbemin_q4 MIN mfq_vbe_q4 from=2e-08 to=4e-08
let mfq_ic_q4 = i(vic_q4)
meas tran mf_su_icmax_q4 MAX mfq_ic_q4 from=0.0 to=2e-08
meas tran mf_su_icmin_q4 MIN mfq_ic_q4 from=0.0 to=2e-08
meas tran mf_ss_icmax_q4 MAX mfq_ic_q4 from=2e-08 to=4e-08
meas tran mf_ss_icmin_q4 MIN mfq_ic_q4 from=2e-08 to=4e-08
let mfq_vce_q5 = v(c_q5)-v(x2)
meas tran mf_su_vcemax_q5 MAX mfq_vce_q5 from=0.0 to=2e-08
meas tran mf_su_vcemin_q5 MIN mfq_vce_q5 from=0.0 to=2e-08
meas tran mf_ss_vcemax_q5 MAX mfq_vce_q5 from=2e-08 to=4e-08
meas tran mf_ss_vcemin_q5 MIN mfq_vce_q5 from=2e-08 to=4e-08
let mfq_vbe_q5 = v(lo_p)-v(x2)
meas tran mf_su_vbemax_q5 MAX mfq_vbe_q5 from=0.0 to=2e-08
meas tran mf_su_vbemin_q5 MIN mfq_vbe_q5 from=0.0 to=2e-08
meas tran mf_ss_vbemax_q5 MAX mfq_vbe_q5 from=2e-08 to=4e-08
meas tran mf_ss_vbemin_q5 MIN mfq_vbe_q5 from=2e-08 to=4e-08
let mfq_ic_q5 = i(vic_q5)
meas tran mf_su_icmax_q5 MAX mfq_ic_q5 from=0.0 to=2e-08
meas tran mf_su_icmin_q5 MIN mfq_ic_q5 from=0.0 to=2e-08
meas tran mf_ss_icmax_q5 MAX mfq_ic_q5 from=2e-08 to=4e-08
meas tran mf_ss_icmin_q5 MIN mfq_ic_q5 from=2e-08 to=4e-08
let mfq_vce_q6 = v(c_q6)-v(x2)
meas tran mf_su_vcemax_q6 MAX mfq_vce_q6 from=0.0 to=2e-08
meas tran mf_su_vcemin_q6 MIN mfq_vce_q6 from=0.0 to=2e-08
meas tran mf_ss_vcemax_q6 MAX mfq_vce_q6 from=2e-08 to=4e-08
meas tran mf_ss_vcemin_q6 MIN mfq_vce_q6 from=2e-08 to=4e-08
let mfq_vbe_q6 = v(lo_n)-v(x2)
meas tran mf_su_vbemax_q6 MAX mfq_vbe_q6 from=0.0 to=2e-08
meas tran mf_su_vbemin_q6 MIN mfq_vbe_q6 from=0.0 to=2e-08
meas tran mf_ss_vbemax_q6 MAX mfq_vbe_q6 from=2e-08 to=4e-08
meas tran mf_ss_vbemin_q6 MIN mfq_vbe_q6 from=2e-08 to=4e-08
let mfq_ic_q6 = i(vic_q6)
meas tran mf_su_icmax_q6 MAX mfq_ic_q6 from=0.0 to=2e-08
meas tran mf_su_icmin_q6 MIN mfq_ic_q6 from=0.0 to=2e-08
meas tran mf_ss_icmax_q6 MAX mfq_ic_q6 from=2e-08 to=4e-08
meas tran mf_ss_icmin_q6 MIN mfq_ic_q6 from=2e-08 to=4e-08
meas tran mf_su_sinkmin_tail MIN v(tail) from=0.0 to=2e-08
meas tran mf_ss_sinkmin_tail MIN v(tail) from=2e-08 to=4e-08
print mf_su_vcemax_q1
print mf_su_vcemin_q1
print mf_ss_vcemax_q1
print mf_ss_vcemin_q1
print mf_su_vbemax_q1
print mf_su_vbemin_q1
print mf_ss_vbemax_q1
print mf_ss_vbemin_q1
print mf_su_icmax_q1
print mf_su_icmin_q1
print mf_ss_icmax_q1
print mf_ss_icmin_q1
print mf_su_vcemax_q2
print mf_su_vcemin_q2
print mf_ss_vcemax_q2
print mf_ss_vcemin_q2
print mf_su_vbemax_q2
print mf_su_vbemin_q2
print mf_ss_vbemax_q2
print mf_ss_vbemin_q2
print mf_su_icmax_q2
print mf_su_icmin_q2
print mf_ss_icmax_q2
print mf_ss_icmin_q2
print mf_su_vcemax_q3
print mf_su_vcemin_q3
print mf_ss_vcemax_q3
print mf_ss_vcemin_q3
print mf_su_vbemax_q3
print mf_su_vbemin_q3
print mf_ss_vbemax_q3
print mf_ss_vbemin_q3
print mf_su_icmax_q3
print mf_su_icmin_q3
print mf_ss_icmax_q3
print mf_ss_icmin_q3
print mf_su_vcemax_q4
print mf_su_vcemin_q4
print mf_ss_vcemax_q4
print mf_ss_vcemin_q4
print mf_su_vbemax_q4
print mf_su_vbemin_q4
print mf_ss_vbemax_q4
print mf_ss_vbemin_q4
print mf_su_icmax_q4
print mf_su_icmin_q4
print mf_ss_icmax_q4
print mf_ss_icmin_q4
print mf_su_vcemax_q5
print mf_su_vcemin_q5
print mf_ss_vcemax_q5
print mf_ss_vcemin_q5
print mf_su_vbemax_q5
print mf_su_vbemin_q5
print mf_ss_vbemax_q5
print mf_ss_vbemin_q5
print mf_su_icmax_q5
print mf_su_icmin_q5
print mf_ss_icmax_q5
print mf_ss_icmin_q5
print mf_su_vcemax_q6
print mf_su_vcemin_q6
print mf_ss_vcemax_q6
print mf_ss_vcemin_q6
print mf_su_vbemax_q6
print mf_su_vbemin_q6
print mf_ss_vbemax_q6
print mf_ss_vbemin_q6
print mf_su_icmax_q6
print mf_su_icmin_q6
print mf_ss_icmax_q6
print mf_ss_icmin_q6
print mf_su_sinkmin_tail
print mf_ss_sinkmin_tail
linearize
let mf_l = length(time)
let mfw = (time ge 1.99995e-08) * (time lt 3.99995e-08)
let mf_n = mean(mfw) * mf_l
let mfs = mf_l / mf_n
let mf_prail = mean(v(vdd) * (0 - i(vdd)) * mfw) * mfs
let mfph = 2 * pi * 20200000000.0 * (time - 2e-08)
let mf_lodiff_re = 2 * mean((v(lo_p)-v(lo_n)) * mfw * cos(mfph)) * mfs
let mf_lodiff_im = 2 * mean((v(lo_p)-v(lo_n)) * mfw * sin(mfph)) * mfs
let mfph = 2 * pi * 1000000000.0 * (time - 2e-08)
let mf_if_re = 2 * mean((v(if_out)) * mfw * cos(mfph)) * mfs
let mf_if_im = 2 * mean((v(if_out)) * mfw * sin(mfph)) * mfs
let mfph = 2 * pi * 20200000000.0 * (time - 2e-08)
let mf_loif_re = 2 * mean((v(if_out)) * mfw * cos(mfph)) * mfs
let mf_loif_im = 2 * mean((v(if_out)) * mfw * sin(mfph)) * mfs
let mfph = 2 * pi * 20200000000.0 * (time - 2e-08)
let mf_lorf_re = 2 * mean((v(rf_port)) * mfw * cos(mfph)) * mfs
let mf_lorf_im = 2 * mean((v(rf_port)) * mfw * sin(mfph)) * mfs
let mfph = 2 * pi * 950000000.0 * (time - 2e-08)
let mf_flifa_re = 2 * mean((v(if_out)) * mfw * cos(mfph)) * mfs
let mf_flifa_im = 2 * mean((v(if_out)) * mfw * sin(mfph)) * mfs
let mfph = 2 * pi * 1050000000.0 * (time - 2e-08)
let mf_flifb_re = 2 * mean((v(if_out)) * mfw * cos(mfph)) * mfs
let mf_flifb_im = 2 * mean((v(if_out)) * mfw * sin(mfph)) * mfs
let mfph = 2 * pi * 20250000000.0 * (time - 2e-08)
let mf_fllorf_re = 2 * mean((v(rf_port)) * mfw * cos(mfph)) * mfs
let mf_fllorf_im = 2 * mean((v(rf_port)) * mfw * sin(mfph)) * mfs
let mfph = 2 * pi * 20250000000.0 * (time - 2e-08)
let mf_flloif_re = 2 * mean((v(if_out)) * mfw * cos(mfph)) * mfs
let mf_flloif_im = 2 * mean((v(if_out)) * mfw * sin(mfph)) * mfs
print mf_l
print mf_n
print mf_prail
print mf_lodiff_re
print mf_lodiff_im
print mf_if_re
print mf_if_im
print mf_loif_re
print mf_loif_im
print mf_lorf_re
print mf_lorf_im
print mf_flifa_re
print mf_flifa_im
print mf_flifb_re
print mf_flifb_im
print mf_fllorf_re
print mf_fllorf_im
print mf_flloif_re
print mf_flloif_im
destroy all
echo "MFEND ls_f21p20_m3_rf66"
echo "MFRUN ls_f21p20_p0_rf60"
alterparam f1 = 21200000000.0
alterparam f2 = 21200000000.0
alterparam flo = 20200000000.0
alterparam vrf1 = 0.0006324555320336759
alterparam vrf2 = 0.0
alterparam vlo = 0.8944271909999159
reset
op
let mf_dcirail = 0 - i(vdd)
let mf_dc_vce_q1 = v(c_q1)-v(e_q1)
let mf_dc_vbe_q1 = v(b_q1)-v(e_q1)
let mf_dc_ic_q1 = i(vic_q1)
let mf_dc_vce_q2 = v(c_q2)-v(e_q2)
let mf_dc_vbe_q2 = v(b_q2)-v(e_q2)
let mf_dc_ic_q2 = i(vic_q2)
let mf_dc_vce_q3 = v(c_q3)-v(x1)
let mf_dc_vbe_q3 = v(lo_p)-v(x1)
let mf_dc_ic_q3 = i(vic_q3)
let mf_dc_vce_q4 = v(c_q4)-v(x1)
let mf_dc_vbe_q4 = v(lo_n)-v(x1)
let mf_dc_ic_q4 = i(vic_q4)
let mf_dc_vce_q5 = v(c_q5)-v(x2)
let mf_dc_vbe_q5 = v(lo_p)-v(x2)
let mf_dc_ic_q5 = i(vic_q5)
let mf_dc_vce_q6 = v(c_q6)-v(x2)
let mf_dc_vbe_q6 = v(lo_n)-v(x2)
let mf_dc_ic_q6 = i(vic_q6)
let mf_dc_sink_tail = v(tail)
print mf_dcirail
print mf_dc_vce_q1
print mf_dc_vbe_q1
print mf_dc_ic_q1
print mf_dc_vce_q2
print mf_dc_vbe_q2
print mf_dc_ic_q2
print mf_dc_vce_q3
print mf_dc_vbe_q3
print mf_dc_ic_q3
print mf_dc_vce_q4
print mf_dc_vbe_q4
print mf_dc_ic_q4
print mf_dc_vce_q5
print mf_dc_vbe_q5
print mf_dc_ic_q5
print mf_dc_vce_q6
print mf_dc_vbe_q6
print mf_dc_ic_q6
print mf_dc_sink_tail
tran 1e-12 4e-08 0 1e-12
let mfq_vce_q1 = v(c_q1)-v(e_q1)
meas tran mf_su_vcemax_q1 MAX mfq_vce_q1 from=0.0 to=2e-08
meas tran mf_su_vcemin_q1 MIN mfq_vce_q1 from=0.0 to=2e-08
meas tran mf_ss_vcemax_q1 MAX mfq_vce_q1 from=2e-08 to=4e-08
meas tran mf_ss_vcemin_q1 MIN mfq_vce_q1 from=2e-08 to=4e-08
let mfq_vbe_q1 = v(b_q1)-v(e_q1)
meas tran mf_su_vbemax_q1 MAX mfq_vbe_q1 from=0.0 to=2e-08
meas tran mf_su_vbemin_q1 MIN mfq_vbe_q1 from=0.0 to=2e-08
meas tran mf_ss_vbemax_q1 MAX mfq_vbe_q1 from=2e-08 to=4e-08
meas tran mf_ss_vbemin_q1 MIN mfq_vbe_q1 from=2e-08 to=4e-08
let mfq_ic_q1 = i(vic_q1)
meas tran mf_su_icmax_q1 MAX mfq_ic_q1 from=0.0 to=2e-08
meas tran mf_su_icmin_q1 MIN mfq_ic_q1 from=0.0 to=2e-08
meas tran mf_ss_icmax_q1 MAX mfq_ic_q1 from=2e-08 to=4e-08
meas tran mf_ss_icmin_q1 MIN mfq_ic_q1 from=2e-08 to=4e-08
let mfq_vce_q2 = v(c_q2)-v(e_q2)
meas tran mf_su_vcemax_q2 MAX mfq_vce_q2 from=0.0 to=2e-08
meas tran mf_su_vcemin_q2 MIN mfq_vce_q2 from=0.0 to=2e-08
meas tran mf_ss_vcemax_q2 MAX mfq_vce_q2 from=2e-08 to=4e-08
meas tran mf_ss_vcemin_q2 MIN mfq_vce_q2 from=2e-08 to=4e-08
let mfq_vbe_q2 = v(b_q2)-v(e_q2)
meas tran mf_su_vbemax_q2 MAX mfq_vbe_q2 from=0.0 to=2e-08
meas tran mf_su_vbemin_q2 MIN mfq_vbe_q2 from=0.0 to=2e-08
meas tran mf_ss_vbemax_q2 MAX mfq_vbe_q2 from=2e-08 to=4e-08
meas tran mf_ss_vbemin_q2 MIN mfq_vbe_q2 from=2e-08 to=4e-08
let mfq_ic_q2 = i(vic_q2)
meas tran mf_su_icmax_q2 MAX mfq_ic_q2 from=0.0 to=2e-08
meas tran mf_su_icmin_q2 MIN mfq_ic_q2 from=0.0 to=2e-08
meas tran mf_ss_icmax_q2 MAX mfq_ic_q2 from=2e-08 to=4e-08
meas tran mf_ss_icmin_q2 MIN mfq_ic_q2 from=2e-08 to=4e-08
let mfq_vce_q3 = v(c_q3)-v(x1)
meas tran mf_su_vcemax_q3 MAX mfq_vce_q3 from=0.0 to=2e-08
meas tran mf_su_vcemin_q3 MIN mfq_vce_q3 from=0.0 to=2e-08
meas tran mf_ss_vcemax_q3 MAX mfq_vce_q3 from=2e-08 to=4e-08
meas tran mf_ss_vcemin_q3 MIN mfq_vce_q3 from=2e-08 to=4e-08
let mfq_vbe_q3 = v(lo_p)-v(x1)
meas tran mf_su_vbemax_q3 MAX mfq_vbe_q3 from=0.0 to=2e-08
meas tran mf_su_vbemin_q3 MIN mfq_vbe_q3 from=0.0 to=2e-08
meas tran mf_ss_vbemax_q3 MAX mfq_vbe_q3 from=2e-08 to=4e-08
meas tran mf_ss_vbemin_q3 MIN mfq_vbe_q3 from=2e-08 to=4e-08
let mfq_ic_q3 = i(vic_q3)
meas tran mf_su_icmax_q3 MAX mfq_ic_q3 from=0.0 to=2e-08
meas tran mf_su_icmin_q3 MIN mfq_ic_q3 from=0.0 to=2e-08
meas tran mf_ss_icmax_q3 MAX mfq_ic_q3 from=2e-08 to=4e-08
meas tran mf_ss_icmin_q3 MIN mfq_ic_q3 from=2e-08 to=4e-08
let mfq_vce_q4 = v(c_q4)-v(x1)
meas tran mf_su_vcemax_q4 MAX mfq_vce_q4 from=0.0 to=2e-08
meas tran mf_su_vcemin_q4 MIN mfq_vce_q4 from=0.0 to=2e-08
meas tran mf_ss_vcemax_q4 MAX mfq_vce_q4 from=2e-08 to=4e-08
meas tran mf_ss_vcemin_q4 MIN mfq_vce_q4 from=2e-08 to=4e-08
let mfq_vbe_q4 = v(lo_n)-v(x1)
meas tran mf_su_vbemax_q4 MAX mfq_vbe_q4 from=0.0 to=2e-08
meas tran mf_su_vbemin_q4 MIN mfq_vbe_q4 from=0.0 to=2e-08
meas tran mf_ss_vbemax_q4 MAX mfq_vbe_q4 from=2e-08 to=4e-08
meas tran mf_ss_vbemin_q4 MIN mfq_vbe_q4 from=2e-08 to=4e-08
let mfq_ic_q4 = i(vic_q4)
meas tran mf_su_icmax_q4 MAX mfq_ic_q4 from=0.0 to=2e-08
meas tran mf_su_icmin_q4 MIN mfq_ic_q4 from=0.0 to=2e-08
meas tran mf_ss_icmax_q4 MAX mfq_ic_q4 from=2e-08 to=4e-08
meas tran mf_ss_icmin_q4 MIN mfq_ic_q4 from=2e-08 to=4e-08
let mfq_vce_q5 = v(c_q5)-v(x2)
meas tran mf_su_vcemax_q5 MAX mfq_vce_q5 from=0.0 to=2e-08
meas tran mf_su_vcemin_q5 MIN mfq_vce_q5 from=0.0 to=2e-08
meas tran mf_ss_vcemax_q5 MAX mfq_vce_q5 from=2e-08 to=4e-08
meas tran mf_ss_vcemin_q5 MIN mfq_vce_q5 from=2e-08 to=4e-08
let mfq_vbe_q5 = v(lo_p)-v(x2)
meas tran mf_su_vbemax_q5 MAX mfq_vbe_q5 from=0.0 to=2e-08
meas tran mf_su_vbemin_q5 MIN mfq_vbe_q5 from=0.0 to=2e-08
meas tran mf_ss_vbemax_q5 MAX mfq_vbe_q5 from=2e-08 to=4e-08
meas tran mf_ss_vbemin_q5 MIN mfq_vbe_q5 from=2e-08 to=4e-08
let mfq_ic_q5 = i(vic_q5)
meas tran mf_su_icmax_q5 MAX mfq_ic_q5 from=0.0 to=2e-08
meas tran mf_su_icmin_q5 MIN mfq_ic_q5 from=0.0 to=2e-08
meas tran mf_ss_icmax_q5 MAX mfq_ic_q5 from=2e-08 to=4e-08
meas tran mf_ss_icmin_q5 MIN mfq_ic_q5 from=2e-08 to=4e-08
let mfq_vce_q6 = v(c_q6)-v(x2)
meas tran mf_su_vcemax_q6 MAX mfq_vce_q6 from=0.0 to=2e-08
meas tran mf_su_vcemin_q6 MIN mfq_vce_q6 from=0.0 to=2e-08
meas tran mf_ss_vcemax_q6 MAX mfq_vce_q6 from=2e-08 to=4e-08
meas tran mf_ss_vcemin_q6 MIN mfq_vce_q6 from=2e-08 to=4e-08
let mfq_vbe_q6 = v(lo_n)-v(x2)
meas tran mf_su_vbemax_q6 MAX mfq_vbe_q6 from=0.0 to=2e-08
meas tran mf_su_vbemin_q6 MIN mfq_vbe_q6 from=0.0 to=2e-08
meas tran mf_ss_vbemax_q6 MAX mfq_vbe_q6 from=2e-08 to=4e-08
meas tran mf_ss_vbemin_q6 MIN mfq_vbe_q6 from=2e-08 to=4e-08
let mfq_ic_q6 = i(vic_q6)
meas tran mf_su_icmax_q6 MAX mfq_ic_q6 from=0.0 to=2e-08
meas tran mf_su_icmin_q6 MIN mfq_ic_q6 from=0.0 to=2e-08
meas tran mf_ss_icmax_q6 MAX mfq_ic_q6 from=2e-08 to=4e-08
meas tran mf_ss_icmin_q6 MIN mfq_ic_q6 from=2e-08 to=4e-08
meas tran mf_su_sinkmin_tail MIN v(tail) from=0.0 to=2e-08
meas tran mf_ss_sinkmin_tail MIN v(tail) from=2e-08 to=4e-08
print mf_su_vcemax_q1
print mf_su_vcemin_q1
print mf_ss_vcemax_q1
print mf_ss_vcemin_q1
print mf_su_vbemax_q1
print mf_su_vbemin_q1
print mf_ss_vbemax_q1
print mf_ss_vbemin_q1
print mf_su_icmax_q1
print mf_su_icmin_q1
print mf_ss_icmax_q1
print mf_ss_icmin_q1
print mf_su_vcemax_q2
print mf_su_vcemin_q2
print mf_ss_vcemax_q2
print mf_ss_vcemin_q2
print mf_su_vbemax_q2
print mf_su_vbemin_q2
print mf_ss_vbemax_q2
print mf_ss_vbemin_q2
print mf_su_icmax_q2
print mf_su_icmin_q2
print mf_ss_icmax_q2
print mf_ss_icmin_q2
print mf_su_vcemax_q3
print mf_su_vcemin_q3
print mf_ss_vcemax_q3
print mf_ss_vcemin_q3
print mf_su_vbemax_q3
print mf_su_vbemin_q3
print mf_ss_vbemax_q3
print mf_ss_vbemin_q3
print mf_su_icmax_q3
print mf_su_icmin_q3
print mf_ss_icmax_q3
print mf_ss_icmin_q3
print mf_su_vcemax_q4
print mf_su_vcemin_q4
print mf_ss_vcemax_q4
print mf_ss_vcemin_q4
print mf_su_vbemax_q4
print mf_su_vbemin_q4
print mf_ss_vbemax_q4
print mf_ss_vbemin_q4
print mf_su_icmax_q4
print mf_su_icmin_q4
print mf_ss_icmax_q4
print mf_ss_icmin_q4
print mf_su_vcemax_q5
print mf_su_vcemin_q5
print mf_ss_vcemax_q5
print mf_ss_vcemin_q5
print mf_su_vbemax_q5
print mf_su_vbemin_q5
print mf_ss_vbemax_q5
print mf_ss_vbemin_q5
print mf_su_icmax_q5
print mf_su_icmin_q5
print mf_ss_icmax_q5
print mf_ss_icmin_q5
print mf_su_vcemax_q6
print mf_su_vcemin_q6
print mf_ss_vcemax_q6
print mf_ss_vcemin_q6
print mf_su_vbemax_q6
print mf_su_vbemin_q6
print mf_ss_vbemax_q6
print mf_ss_vbemin_q6
print mf_su_icmax_q6
print mf_su_icmin_q6
print mf_ss_icmax_q6
print mf_ss_icmin_q6
print mf_su_sinkmin_tail
print mf_ss_sinkmin_tail
linearize
let mf_l = length(time)
let mfw = (time ge 1.99995e-08) * (time lt 3.99995e-08)
let mf_n = mean(mfw) * mf_l
let mfs = mf_l / mf_n
let mf_prail = mean(v(vdd) * (0 - i(vdd)) * mfw) * mfs
let mfph = 2 * pi * 20200000000.0 * (time - 2e-08)
let mf_lodiff_re = 2 * mean((v(lo_p)-v(lo_n)) * mfw * cos(mfph)) * mfs
let mf_lodiff_im = 2 * mean((v(lo_p)-v(lo_n)) * mfw * sin(mfph)) * mfs
let mfph = 2 * pi * 1000000000.0 * (time - 2e-08)
let mf_if_re = 2 * mean((v(if_out)) * mfw * cos(mfph)) * mfs
let mf_if_im = 2 * mean((v(if_out)) * mfw * sin(mfph)) * mfs
let mfph = 2 * pi * 20200000000.0 * (time - 2e-08)
let mf_loif_re = 2 * mean((v(if_out)) * mfw * cos(mfph)) * mfs
let mf_loif_im = 2 * mean((v(if_out)) * mfw * sin(mfph)) * mfs
let mfph = 2 * pi * 20200000000.0 * (time - 2e-08)
let mf_lorf_re = 2 * mean((v(rf_port)) * mfw * cos(mfph)) * mfs
let mf_lorf_im = 2 * mean((v(rf_port)) * mfw * sin(mfph)) * mfs
let mfph = 2 * pi * 950000000.0 * (time - 2e-08)
let mf_flifa_re = 2 * mean((v(if_out)) * mfw * cos(mfph)) * mfs
let mf_flifa_im = 2 * mean((v(if_out)) * mfw * sin(mfph)) * mfs
let mfph = 2 * pi * 1050000000.0 * (time - 2e-08)
let mf_flifb_re = 2 * mean((v(if_out)) * mfw * cos(mfph)) * mfs
let mf_flifb_im = 2 * mean((v(if_out)) * mfw * sin(mfph)) * mfs
let mfph = 2 * pi * 20250000000.0 * (time - 2e-08)
let mf_fllorf_re = 2 * mean((v(rf_port)) * mfw * cos(mfph)) * mfs
let mf_fllorf_im = 2 * mean((v(rf_port)) * mfw * sin(mfph)) * mfs
let mfph = 2 * pi * 20250000000.0 * (time - 2e-08)
let mf_flloif_re = 2 * mean((v(if_out)) * mfw * cos(mfph)) * mfs
let mf_flloif_im = 2 * mean((v(if_out)) * mfw * sin(mfph)) * mfs
print mf_l
print mf_n
print mf_prail
print mf_lodiff_re
print mf_lodiff_im
print mf_if_re
print mf_if_im
print mf_loif_re
print mf_loif_im
print mf_lorf_re
print mf_lorf_im
print mf_flifa_re
print mf_flifa_im
print mf_flifb_re
print mf_flifb_im
print mf_fllorf_re
print mf_fllorf_im
print mf_flloif_re
print mf_flloif_im
destroy all
echo "MFEND ls_f21p20_p0_rf60"
echo "MFRUN ls_f21p20_p0_rf66"
alterparam f1 = 21200000000.0
alterparam f2 = 21200000000.0
alterparam flo = 20200000000.0
alterparam vrf1 = 0.00031697863849222284
alterparam vrf2 = 0.0
alterparam vlo = 0.8944271909999159
reset
op
let mf_dcirail = 0 - i(vdd)
let mf_dc_vce_q1 = v(c_q1)-v(e_q1)
let mf_dc_vbe_q1 = v(b_q1)-v(e_q1)
let mf_dc_ic_q1 = i(vic_q1)
let mf_dc_vce_q2 = v(c_q2)-v(e_q2)
let mf_dc_vbe_q2 = v(b_q2)-v(e_q2)
let mf_dc_ic_q2 = i(vic_q2)
let mf_dc_vce_q3 = v(c_q3)-v(x1)
let mf_dc_vbe_q3 = v(lo_p)-v(x1)
let mf_dc_ic_q3 = i(vic_q3)
let mf_dc_vce_q4 = v(c_q4)-v(x1)
let mf_dc_vbe_q4 = v(lo_n)-v(x1)
let mf_dc_ic_q4 = i(vic_q4)
let mf_dc_vce_q5 = v(c_q5)-v(x2)
let mf_dc_vbe_q5 = v(lo_p)-v(x2)
let mf_dc_ic_q5 = i(vic_q5)
let mf_dc_vce_q6 = v(c_q6)-v(x2)
let mf_dc_vbe_q6 = v(lo_n)-v(x2)
let mf_dc_ic_q6 = i(vic_q6)
let mf_dc_sink_tail = v(tail)
print mf_dcirail
print mf_dc_vce_q1
print mf_dc_vbe_q1
print mf_dc_ic_q1
print mf_dc_vce_q2
print mf_dc_vbe_q2
print mf_dc_ic_q2
print mf_dc_vce_q3
print mf_dc_vbe_q3
print mf_dc_ic_q3
print mf_dc_vce_q4
print mf_dc_vbe_q4
print mf_dc_ic_q4
print mf_dc_vce_q5
print mf_dc_vbe_q5
print mf_dc_ic_q5
print mf_dc_vce_q6
print mf_dc_vbe_q6
print mf_dc_ic_q6
print mf_dc_sink_tail
tran 1e-12 4e-08 0 1e-12
let mfq_vce_q1 = v(c_q1)-v(e_q1)
meas tran mf_su_vcemax_q1 MAX mfq_vce_q1 from=0.0 to=2e-08
meas tran mf_su_vcemin_q1 MIN mfq_vce_q1 from=0.0 to=2e-08
meas tran mf_ss_vcemax_q1 MAX mfq_vce_q1 from=2e-08 to=4e-08
meas tran mf_ss_vcemin_q1 MIN mfq_vce_q1 from=2e-08 to=4e-08
let mfq_vbe_q1 = v(b_q1)-v(e_q1)
meas tran mf_su_vbemax_q1 MAX mfq_vbe_q1 from=0.0 to=2e-08
meas tran mf_su_vbemin_q1 MIN mfq_vbe_q1 from=0.0 to=2e-08
meas tran mf_ss_vbemax_q1 MAX mfq_vbe_q1 from=2e-08 to=4e-08
meas tran mf_ss_vbemin_q1 MIN mfq_vbe_q1 from=2e-08 to=4e-08
let mfq_ic_q1 = i(vic_q1)
meas tran mf_su_icmax_q1 MAX mfq_ic_q1 from=0.0 to=2e-08
meas tran mf_su_icmin_q1 MIN mfq_ic_q1 from=0.0 to=2e-08
meas tran mf_ss_icmax_q1 MAX mfq_ic_q1 from=2e-08 to=4e-08
meas tran mf_ss_icmin_q1 MIN mfq_ic_q1 from=2e-08 to=4e-08
let mfq_vce_q2 = v(c_q2)-v(e_q2)
meas tran mf_su_vcemax_q2 MAX mfq_vce_q2 from=0.0 to=2e-08
meas tran mf_su_vcemin_q2 MIN mfq_vce_q2 from=0.0 to=2e-08
meas tran mf_ss_vcemax_q2 MAX mfq_vce_q2 from=2e-08 to=4e-08
meas tran mf_ss_vcemin_q2 MIN mfq_vce_q2 from=2e-08 to=4e-08
let mfq_vbe_q2 = v(b_q2)-v(e_q2)
meas tran mf_su_vbemax_q2 MAX mfq_vbe_q2 from=0.0 to=2e-08
meas tran mf_su_vbemin_q2 MIN mfq_vbe_q2 from=0.0 to=2e-08
meas tran mf_ss_vbemax_q2 MAX mfq_vbe_q2 from=2e-08 to=4e-08
meas tran mf_ss_vbemin_q2 MIN mfq_vbe_q2 from=2e-08 to=4e-08
let mfq_ic_q2 = i(vic_q2)
meas tran mf_su_icmax_q2 MAX mfq_ic_q2 from=0.0 to=2e-08
meas tran mf_su_icmin_q2 MIN mfq_ic_q2 from=0.0 to=2e-08
meas tran mf_ss_icmax_q2 MAX mfq_ic_q2 from=2e-08 to=4e-08
meas tran mf_ss_icmin_q2 MIN mfq_ic_q2 from=2e-08 to=4e-08
let mfq_vce_q3 = v(c_q3)-v(x1)
meas tran mf_su_vcemax_q3 MAX mfq_vce_q3 from=0.0 to=2e-08
meas tran mf_su_vcemin_q3 MIN mfq_vce_q3 from=0.0 to=2e-08
meas tran mf_ss_vcemax_q3 MAX mfq_vce_q3 from=2e-08 to=4e-08
meas tran mf_ss_vcemin_q3 MIN mfq_vce_q3 from=2e-08 to=4e-08
let mfq_vbe_q3 = v(lo_p)-v(x1)
meas tran mf_su_vbemax_q3 MAX mfq_vbe_q3 from=0.0 to=2e-08
meas tran mf_su_vbemin_q3 MIN mfq_vbe_q3 from=0.0 to=2e-08
meas tran mf_ss_vbemax_q3 MAX mfq_vbe_q3 from=2e-08 to=4e-08
meas tran mf_ss_vbemin_q3 MIN mfq_vbe_q3 from=2e-08 to=4e-08
let mfq_ic_q3 = i(vic_q3)
meas tran mf_su_icmax_q3 MAX mfq_ic_q3 from=0.0 to=2e-08
meas tran mf_su_icmin_q3 MIN mfq_ic_q3 from=0.0 to=2e-08
meas tran mf_ss_icmax_q3 MAX mfq_ic_q3 from=2e-08 to=4e-08
meas tran mf_ss_icmin_q3 MIN mfq_ic_q3 from=2e-08 to=4e-08
let mfq_vce_q4 = v(c_q4)-v(x1)
meas tran mf_su_vcemax_q4 MAX mfq_vce_q4 from=0.0 to=2e-08
meas tran mf_su_vcemin_q4 MIN mfq_vce_q4 from=0.0 to=2e-08
meas tran mf_ss_vcemax_q4 MAX mfq_vce_q4 from=2e-08 to=4e-08
meas tran mf_ss_vcemin_q4 MIN mfq_vce_q4 from=2e-08 to=4e-08
let mfq_vbe_q4 = v(lo_n)-v(x1)
meas tran mf_su_vbemax_q4 MAX mfq_vbe_q4 from=0.0 to=2e-08
meas tran mf_su_vbemin_q4 MIN mfq_vbe_q4 from=0.0 to=2e-08
meas tran mf_ss_vbemax_q4 MAX mfq_vbe_q4 from=2e-08 to=4e-08
meas tran mf_ss_vbemin_q4 MIN mfq_vbe_q4 from=2e-08 to=4e-08
let mfq_ic_q4 = i(vic_q4)
meas tran mf_su_icmax_q4 MAX mfq_ic_q4 from=0.0 to=2e-08
meas tran mf_su_icmin_q4 MIN mfq_ic_q4 from=0.0 to=2e-08
meas tran mf_ss_icmax_q4 MAX mfq_ic_q4 from=2e-08 to=4e-08
meas tran mf_ss_icmin_q4 MIN mfq_ic_q4 from=2e-08 to=4e-08
let mfq_vce_q5 = v(c_q5)-v(x2)
meas tran mf_su_vcemax_q5 MAX mfq_vce_q5 from=0.0 to=2e-08
meas tran mf_su_vcemin_q5 MIN mfq_vce_q5 from=0.0 to=2e-08
meas tran mf_ss_vcemax_q5 MAX mfq_vce_q5 from=2e-08 to=4e-08
meas tran mf_ss_vcemin_q5 MIN mfq_vce_q5 from=2e-08 to=4e-08
let mfq_vbe_q5 = v(lo_p)-v(x2)
meas tran mf_su_vbemax_q5 MAX mfq_vbe_q5 from=0.0 to=2e-08
meas tran mf_su_vbemin_q5 MIN mfq_vbe_q5 from=0.0 to=2e-08
meas tran mf_ss_vbemax_q5 MAX mfq_vbe_q5 from=2e-08 to=4e-08
meas tran mf_ss_vbemin_q5 MIN mfq_vbe_q5 from=2e-08 to=4e-08
let mfq_ic_q5 = i(vic_q5)
meas tran mf_su_icmax_q5 MAX mfq_ic_q5 from=0.0 to=2e-08
meas tran mf_su_icmin_q5 MIN mfq_ic_q5 from=0.0 to=2e-08
meas tran mf_ss_icmax_q5 MAX mfq_ic_q5 from=2e-08 to=4e-08
meas tran mf_ss_icmin_q5 MIN mfq_ic_q5 from=2e-08 to=4e-08
let mfq_vce_q6 = v(c_q6)-v(x2)
meas tran mf_su_vcemax_q6 MAX mfq_vce_q6 from=0.0 to=2e-08
meas tran mf_su_vcemin_q6 MIN mfq_vce_q6 from=0.0 to=2e-08
meas tran mf_ss_vcemax_q6 MAX mfq_vce_q6 from=2e-08 to=4e-08
meas tran mf_ss_vcemin_q6 MIN mfq_vce_q6 from=2e-08 to=4e-08
let mfq_vbe_q6 = v(lo_n)-v(x2)
meas tran mf_su_vbemax_q6 MAX mfq_vbe_q6 from=0.0 to=2e-08
meas tran mf_su_vbemin_q6 MIN mfq_vbe_q6 from=0.0 to=2e-08
meas tran mf_ss_vbemax_q6 MAX mfq_vbe_q6 from=2e-08 to=4e-08
meas tran mf_ss_vbemin_q6 MIN mfq_vbe_q6 from=2e-08 to=4e-08
let mfq_ic_q6 = i(vic_q6)
meas tran mf_su_icmax_q6 MAX mfq_ic_q6 from=0.0 to=2e-08
meas tran mf_su_icmin_q6 MIN mfq_ic_q6 from=0.0 to=2e-08
meas tran mf_ss_icmax_q6 MAX mfq_ic_q6 from=2e-08 to=4e-08
meas tran mf_ss_icmin_q6 MIN mfq_ic_q6 from=2e-08 to=4e-08
meas tran mf_su_sinkmin_tail MIN v(tail) from=0.0 to=2e-08
meas tran mf_ss_sinkmin_tail MIN v(tail) from=2e-08 to=4e-08
print mf_su_vcemax_q1
print mf_su_vcemin_q1
print mf_ss_vcemax_q1
print mf_ss_vcemin_q1
print mf_su_vbemax_q1
print mf_su_vbemin_q1
print mf_ss_vbemax_q1
print mf_ss_vbemin_q1
print mf_su_icmax_q1
print mf_su_icmin_q1
print mf_ss_icmax_q1
print mf_ss_icmin_q1
print mf_su_vcemax_q2
print mf_su_vcemin_q2
print mf_ss_vcemax_q2
print mf_ss_vcemin_q2
print mf_su_vbemax_q2
print mf_su_vbemin_q2
print mf_ss_vbemax_q2
print mf_ss_vbemin_q2
print mf_su_icmax_q2
print mf_su_icmin_q2
print mf_ss_icmax_q2
print mf_ss_icmin_q2
print mf_su_vcemax_q3
print mf_su_vcemin_q3
print mf_ss_vcemax_q3
print mf_ss_vcemin_q3
print mf_su_vbemax_q3
print mf_su_vbemin_q3
print mf_ss_vbemax_q3
print mf_ss_vbemin_q3
print mf_su_icmax_q3
print mf_su_icmin_q3
print mf_ss_icmax_q3
print mf_ss_icmin_q3
print mf_su_vcemax_q4
print mf_su_vcemin_q4
print mf_ss_vcemax_q4
print mf_ss_vcemin_q4
print mf_su_vbemax_q4
print mf_su_vbemin_q4
print mf_ss_vbemax_q4
print mf_ss_vbemin_q4
print mf_su_icmax_q4
print mf_su_icmin_q4
print mf_ss_icmax_q4
print mf_ss_icmin_q4
print mf_su_vcemax_q5
print mf_su_vcemin_q5
print mf_ss_vcemax_q5
print mf_ss_vcemin_q5
print mf_su_vbemax_q5
print mf_su_vbemin_q5
print mf_ss_vbemax_q5
print mf_ss_vbemin_q5
print mf_su_icmax_q5
print mf_su_icmin_q5
print mf_ss_icmax_q5
print mf_ss_icmin_q5
print mf_su_vcemax_q6
print mf_su_vcemin_q6
print mf_ss_vcemax_q6
print mf_ss_vcemin_q6
print mf_su_vbemax_q6
print mf_su_vbemin_q6
print mf_ss_vbemax_q6
print mf_ss_vbemin_q6
print mf_su_icmax_q6
print mf_su_icmin_q6
print mf_ss_icmax_q6
print mf_ss_icmin_q6
print mf_su_sinkmin_tail
print mf_ss_sinkmin_tail
linearize
let mf_l = length(time)
let mfw = (time ge 1.99995e-08) * (time lt 3.99995e-08)
let mf_n = mean(mfw) * mf_l
let mfs = mf_l / mf_n
let mf_prail = mean(v(vdd) * (0 - i(vdd)) * mfw) * mfs
let mfph = 2 * pi * 20200000000.0 * (time - 2e-08)
let mf_lodiff_re = 2 * mean((v(lo_p)-v(lo_n)) * mfw * cos(mfph)) * mfs
let mf_lodiff_im = 2 * mean((v(lo_p)-v(lo_n)) * mfw * sin(mfph)) * mfs
let mfph = 2 * pi * 1000000000.0 * (time - 2e-08)
let mf_if_re = 2 * mean((v(if_out)) * mfw * cos(mfph)) * mfs
let mf_if_im = 2 * mean((v(if_out)) * mfw * sin(mfph)) * mfs
let mfph = 2 * pi * 20200000000.0 * (time - 2e-08)
let mf_loif_re = 2 * mean((v(if_out)) * mfw * cos(mfph)) * mfs
let mf_loif_im = 2 * mean((v(if_out)) * mfw * sin(mfph)) * mfs
let mfph = 2 * pi * 20200000000.0 * (time - 2e-08)
let mf_lorf_re = 2 * mean((v(rf_port)) * mfw * cos(mfph)) * mfs
let mf_lorf_im = 2 * mean((v(rf_port)) * mfw * sin(mfph)) * mfs
let mfph = 2 * pi * 950000000.0 * (time - 2e-08)
let mf_flifa_re = 2 * mean((v(if_out)) * mfw * cos(mfph)) * mfs
let mf_flifa_im = 2 * mean((v(if_out)) * mfw * sin(mfph)) * mfs
let mfph = 2 * pi * 1050000000.0 * (time - 2e-08)
let mf_flifb_re = 2 * mean((v(if_out)) * mfw * cos(mfph)) * mfs
let mf_flifb_im = 2 * mean((v(if_out)) * mfw * sin(mfph)) * mfs
let mfph = 2 * pi * 20250000000.0 * (time - 2e-08)
let mf_fllorf_re = 2 * mean((v(rf_port)) * mfw * cos(mfph)) * mfs
let mf_fllorf_im = 2 * mean((v(rf_port)) * mfw * sin(mfph)) * mfs
let mfph = 2 * pi * 20250000000.0 * (time - 2e-08)
let mf_flloif_re = 2 * mean((v(if_out)) * mfw * cos(mfph)) * mfs
let mf_flloif_im = 2 * mean((v(if_out)) * mfw * sin(mfph)) * mfs
print mf_l
print mf_n
print mf_prail
print mf_lodiff_re
print mf_lodiff_im
print mf_if_re
print mf_if_im
print mf_loif_re
print mf_loif_im
print mf_lorf_re
print mf_lorf_im
print mf_flifa_re
print mf_flifa_im
print mf_flifb_re
print mf_flifb_im
print mf_fllorf_re
print mf_fllorf_im
print mf_flloif_re
print mf_flloif_im
destroy all
echo "MFEND ls_f21p20_p0_rf66"
echo "MFRUN ls_f21p20_p3_rf60"
alterparam f1 = 21200000000.0
alterparam f2 = 21200000000.0
alterparam flo = 20200000000.0
alterparam vrf1 = 0.0006324555320336759
alterparam vrf2 = 0.0
alterparam vlo = 1.2634119882188484
reset
op
let mf_dcirail = 0 - i(vdd)
let mf_dc_vce_q1 = v(c_q1)-v(e_q1)
let mf_dc_vbe_q1 = v(b_q1)-v(e_q1)
let mf_dc_ic_q1 = i(vic_q1)
let mf_dc_vce_q2 = v(c_q2)-v(e_q2)
let mf_dc_vbe_q2 = v(b_q2)-v(e_q2)
let mf_dc_ic_q2 = i(vic_q2)
let mf_dc_vce_q3 = v(c_q3)-v(x1)
let mf_dc_vbe_q3 = v(lo_p)-v(x1)
let mf_dc_ic_q3 = i(vic_q3)
let mf_dc_vce_q4 = v(c_q4)-v(x1)
let mf_dc_vbe_q4 = v(lo_n)-v(x1)
let mf_dc_ic_q4 = i(vic_q4)
let mf_dc_vce_q5 = v(c_q5)-v(x2)
let mf_dc_vbe_q5 = v(lo_p)-v(x2)
let mf_dc_ic_q5 = i(vic_q5)
let mf_dc_vce_q6 = v(c_q6)-v(x2)
let mf_dc_vbe_q6 = v(lo_n)-v(x2)
let mf_dc_ic_q6 = i(vic_q6)
let mf_dc_sink_tail = v(tail)
print mf_dcirail
print mf_dc_vce_q1
print mf_dc_vbe_q1
print mf_dc_ic_q1
print mf_dc_vce_q2
print mf_dc_vbe_q2
print mf_dc_ic_q2
print mf_dc_vce_q3
print mf_dc_vbe_q3
print mf_dc_ic_q3
print mf_dc_vce_q4
print mf_dc_vbe_q4
print mf_dc_ic_q4
print mf_dc_vce_q5
print mf_dc_vbe_q5
print mf_dc_ic_q5
print mf_dc_vce_q6
print mf_dc_vbe_q6
print mf_dc_ic_q6
print mf_dc_sink_tail
tran 1e-12 4e-08 0 1e-12
let mfq_vce_q1 = v(c_q1)-v(e_q1)
meas tran mf_su_vcemax_q1 MAX mfq_vce_q1 from=0.0 to=2e-08
meas tran mf_su_vcemin_q1 MIN mfq_vce_q1 from=0.0 to=2e-08
meas tran mf_ss_vcemax_q1 MAX mfq_vce_q1 from=2e-08 to=4e-08
meas tran mf_ss_vcemin_q1 MIN mfq_vce_q1 from=2e-08 to=4e-08
let mfq_vbe_q1 = v(b_q1)-v(e_q1)
meas tran mf_su_vbemax_q1 MAX mfq_vbe_q1 from=0.0 to=2e-08
meas tran mf_su_vbemin_q1 MIN mfq_vbe_q1 from=0.0 to=2e-08
meas tran mf_ss_vbemax_q1 MAX mfq_vbe_q1 from=2e-08 to=4e-08
meas tran mf_ss_vbemin_q1 MIN mfq_vbe_q1 from=2e-08 to=4e-08
let mfq_ic_q1 = i(vic_q1)
meas tran mf_su_icmax_q1 MAX mfq_ic_q1 from=0.0 to=2e-08
meas tran mf_su_icmin_q1 MIN mfq_ic_q1 from=0.0 to=2e-08
meas tran mf_ss_icmax_q1 MAX mfq_ic_q1 from=2e-08 to=4e-08
meas tran mf_ss_icmin_q1 MIN mfq_ic_q1 from=2e-08 to=4e-08
let mfq_vce_q2 = v(c_q2)-v(e_q2)
meas tran mf_su_vcemax_q2 MAX mfq_vce_q2 from=0.0 to=2e-08
meas tran mf_su_vcemin_q2 MIN mfq_vce_q2 from=0.0 to=2e-08
meas tran mf_ss_vcemax_q2 MAX mfq_vce_q2 from=2e-08 to=4e-08
meas tran mf_ss_vcemin_q2 MIN mfq_vce_q2 from=2e-08 to=4e-08
let mfq_vbe_q2 = v(b_q2)-v(e_q2)
meas tran mf_su_vbemax_q2 MAX mfq_vbe_q2 from=0.0 to=2e-08
meas tran mf_su_vbemin_q2 MIN mfq_vbe_q2 from=0.0 to=2e-08
meas tran mf_ss_vbemax_q2 MAX mfq_vbe_q2 from=2e-08 to=4e-08
meas tran mf_ss_vbemin_q2 MIN mfq_vbe_q2 from=2e-08 to=4e-08
let mfq_ic_q2 = i(vic_q2)
meas tran mf_su_icmax_q2 MAX mfq_ic_q2 from=0.0 to=2e-08
meas tran mf_su_icmin_q2 MIN mfq_ic_q2 from=0.0 to=2e-08
meas tran mf_ss_icmax_q2 MAX mfq_ic_q2 from=2e-08 to=4e-08
meas tran mf_ss_icmin_q2 MIN mfq_ic_q2 from=2e-08 to=4e-08
let mfq_vce_q3 = v(c_q3)-v(x1)
meas tran mf_su_vcemax_q3 MAX mfq_vce_q3 from=0.0 to=2e-08
meas tran mf_su_vcemin_q3 MIN mfq_vce_q3 from=0.0 to=2e-08
meas tran mf_ss_vcemax_q3 MAX mfq_vce_q3 from=2e-08 to=4e-08
meas tran mf_ss_vcemin_q3 MIN mfq_vce_q3 from=2e-08 to=4e-08
let mfq_vbe_q3 = v(lo_p)-v(x1)
meas tran mf_su_vbemax_q3 MAX mfq_vbe_q3 from=0.0 to=2e-08
meas tran mf_su_vbemin_q3 MIN mfq_vbe_q3 from=0.0 to=2e-08
meas tran mf_ss_vbemax_q3 MAX mfq_vbe_q3 from=2e-08 to=4e-08
meas tran mf_ss_vbemin_q3 MIN mfq_vbe_q3 from=2e-08 to=4e-08
let mfq_ic_q3 = i(vic_q3)
meas tran mf_su_icmax_q3 MAX mfq_ic_q3 from=0.0 to=2e-08
meas tran mf_su_icmin_q3 MIN mfq_ic_q3 from=0.0 to=2e-08
meas tran mf_ss_icmax_q3 MAX mfq_ic_q3 from=2e-08 to=4e-08
meas tran mf_ss_icmin_q3 MIN mfq_ic_q3 from=2e-08 to=4e-08
let mfq_vce_q4 = v(c_q4)-v(x1)
meas tran mf_su_vcemax_q4 MAX mfq_vce_q4 from=0.0 to=2e-08
meas tran mf_su_vcemin_q4 MIN mfq_vce_q4 from=0.0 to=2e-08
meas tran mf_ss_vcemax_q4 MAX mfq_vce_q4 from=2e-08 to=4e-08
meas tran mf_ss_vcemin_q4 MIN mfq_vce_q4 from=2e-08 to=4e-08
let mfq_vbe_q4 = v(lo_n)-v(x1)
meas tran mf_su_vbemax_q4 MAX mfq_vbe_q4 from=0.0 to=2e-08
meas tran mf_su_vbemin_q4 MIN mfq_vbe_q4 from=0.0 to=2e-08
meas tran mf_ss_vbemax_q4 MAX mfq_vbe_q4 from=2e-08 to=4e-08
meas tran mf_ss_vbemin_q4 MIN mfq_vbe_q4 from=2e-08 to=4e-08
let mfq_ic_q4 = i(vic_q4)
meas tran mf_su_icmax_q4 MAX mfq_ic_q4 from=0.0 to=2e-08
meas tran mf_su_icmin_q4 MIN mfq_ic_q4 from=0.0 to=2e-08
meas tran mf_ss_icmax_q4 MAX mfq_ic_q4 from=2e-08 to=4e-08
meas tran mf_ss_icmin_q4 MIN mfq_ic_q4 from=2e-08 to=4e-08
let mfq_vce_q5 = v(c_q5)-v(x2)
meas tran mf_su_vcemax_q5 MAX mfq_vce_q5 from=0.0 to=2e-08
meas tran mf_su_vcemin_q5 MIN mfq_vce_q5 from=0.0 to=2e-08
meas tran mf_ss_vcemax_q5 MAX mfq_vce_q5 from=2e-08 to=4e-08
meas tran mf_ss_vcemin_q5 MIN mfq_vce_q5 from=2e-08 to=4e-08
let mfq_vbe_q5 = v(lo_p)-v(x2)
meas tran mf_su_vbemax_q5 MAX mfq_vbe_q5 from=0.0 to=2e-08
meas tran mf_su_vbemin_q5 MIN mfq_vbe_q5 from=0.0 to=2e-08
meas tran mf_ss_vbemax_q5 MAX mfq_vbe_q5 from=2e-08 to=4e-08
meas tran mf_ss_vbemin_q5 MIN mfq_vbe_q5 from=2e-08 to=4e-08
let mfq_ic_q5 = i(vic_q5)
meas tran mf_su_icmax_q5 MAX mfq_ic_q5 from=0.0 to=2e-08
meas tran mf_su_icmin_q5 MIN mfq_ic_q5 from=0.0 to=2e-08
meas tran mf_ss_icmax_q5 MAX mfq_ic_q5 from=2e-08 to=4e-08
meas tran mf_ss_icmin_q5 MIN mfq_ic_q5 from=2e-08 to=4e-08
let mfq_vce_q6 = v(c_q6)-v(x2)
meas tran mf_su_vcemax_q6 MAX mfq_vce_q6 from=0.0 to=2e-08
meas tran mf_su_vcemin_q6 MIN mfq_vce_q6 from=0.0 to=2e-08
meas tran mf_ss_vcemax_q6 MAX mfq_vce_q6 from=2e-08 to=4e-08
meas tran mf_ss_vcemin_q6 MIN mfq_vce_q6 from=2e-08 to=4e-08
let mfq_vbe_q6 = v(lo_n)-v(x2)
meas tran mf_su_vbemax_q6 MAX mfq_vbe_q6 from=0.0 to=2e-08
meas tran mf_su_vbemin_q6 MIN mfq_vbe_q6 from=0.0 to=2e-08
meas tran mf_ss_vbemax_q6 MAX mfq_vbe_q6 from=2e-08 to=4e-08
meas tran mf_ss_vbemin_q6 MIN mfq_vbe_q6 from=2e-08 to=4e-08
let mfq_ic_q6 = i(vic_q6)
meas tran mf_su_icmax_q6 MAX mfq_ic_q6 from=0.0 to=2e-08
meas tran mf_su_icmin_q6 MIN mfq_ic_q6 from=0.0 to=2e-08
meas tran mf_ss_icmax_q6 MAX mfq_ic_q6 from=2e-08 to=4e-08
meas tran mf_ss_icmin_q6 MIN mfq_ic_q6 from=2e-08 to=4e-08
meas tran mf_su_sinkmin_tail MIN v(tail) from=0.0 to=2e-08
meas tran mf_ss_sinkmin_tail MIN v(tail) from=2e-08 to=4e-08
print mf_su_vcemax_q1
print mf_su_vcemin_q1
print mf_ss_vcemax_q1
print mf_ss_vcemin_q1
print mf_su_vbemax_q1
print mf_su_vbemin_q1
print mf_ss_vbemax_q1
print mf_ss_vbemin_q1
print mf_su_icmax_q1
print mf_su_icmin_q1
print mf_ss_icmax_q1
print mf_ss_icmin_q1
print mf_su_vcemax_q2
print mf_su_vcemin_q2
print mf_ss_vcemax_q2
print mf_ss_vcemin_q2
print mf_su_vbemax_q2
print mf_su_vbemin_q2
print mf_ss_vbemax_q2
print mf_ss_vbemin_q2
print mf_su_icmax_q2
print mf_su_icmin_q2
print mf_ss_icmax_q2
print mf_ss_icmin_q2
print mf_su_vcemax_q3
print mf_su_vcemin_q3
print mf_ss_vcemax_q3
print mf_ss_vcemin_q3
print mf_su_vbemax_q3
print mf_su_vbemin_q3
print mf_ss_vbemax_q3
print mf_ss_vbemin_q3
print mf_su_icmax_q3
print mf_su_icmin_q3
print mf_ss_icmax_q3
print mf_ss_icmin_q3
print mf_su_vcemax_q4
print mf_su_vcemin_q4
print mf_ss_vcemax_q4
print mf_ss_vcemin_q4
print mf_su_vbemax_q4
print mf_su_vbemin_q4
print mf_ss_vbemax_q4
print mf_ss_vbemin_q4
print mf_su_icmax_q4
print mf_su_icmin_q4
print mf_ss_icmax_q4
print mf_ss_icmin_q4
print mf_su_vcemax_q5
print mf_su_vcemin_q5
print mf_ss_vcemax_q5
print mf_ss_vcemin_q5
print mf_su_vbemax_q5
print mf_su_vbemin_q5
print mf_ss_vbemax_q5
print mf_ss_vbemin_q5
print mf_su_icmax_q5
print mf_su_icmin_q5
print mf_ss_icmax_q5
print mf_ss_icmin_q5
print mf_su_vcemax_q6
print mf_su_vcemin_q6
print mf_ss_vcemax_q6
print mf_ss_vcemin_q6
print mf_su_vbemax_q6
print mf_su_vbemin_q6
print mf_ss_vbemax_q6
print mf_ss_vbemin_q6
print mf_su_icmax_q6
print mf_su_icmin_q6
print mf_ss_icmax_q6
print mf_ss_icmin_q6
print mf_su_sinkmin_tail
print mf_ss_sinkmin_tail
linearize
let mf_l = length(time)
let mfw = (time ge 1.99995e-08) * (time lt 3.99995e-08)
let mf_n = mean(mfw) * mf_l
let mfs = mf_l / mf_n
let mf_prail = mean(v(vdd) * (0 - i(vdd)) * mfw) * mfs
let mfph = 2 * pi * 20200000000.0 * (time - 2e-08)
let mf_lodiff_re = 2 * mean((v(lo_p)-v(lo_n)) * mfw * cos(mfph)) * mfs
let mf_lodiff_im = 2 * mean((v(lo_p)-v(lo_n)) * mfw * sin(mfph)) * mfs
let mfph = 2 * pi * 1000000000.0 * (time - 2e-08)
let mf_if_re = 2 * mean((v(if_out)) * mfw * cos(mfph)) * mfs
let mf_if_im = 2 * mean((v(if_out)) * mfw * sin(mfph)) * mfs
let mfph = 2 * pi * 20200000000.0 * (time - 2e-08)
let mf_loif_re = 2 * mean((v(if_out)) * mfw * cos(mfph)) * mfs
let mf_loif_im = 2 * mean((v(if_out)) * mfw * sin(mfph)) * mfs
let mfph = 2 * pi * 20200000000.0 * (time - 2e-08)
let mf_lorf_re = 2 * mean((v(rf_port)) * mfw * cos(mfph)) * mfs
let mf_lorf_im = 2 * mean((v(rf_port)) * mfw * sin(mfph)) * mfs
let mfph = 2 * pi * 950000000.0 * (time - 2e-08)
let mf_flifa_re = 2 * mean((v(if_out)) * mfw * cos(mfph)) * mfs
let mf_flifa_im = 2 * mean((v(if_out)) * mfw * sin(mfph)) * mfs
let mfph = 2 * pi * 1050000000.0 * (time - 2e-08)
let mf_flifb_re = 2 * mean((v(if_out)) * mfw * cos(mfph)) * mfs
let mf_flifb_im = 2 * mean((v(if_out)) * mfw * sin(mfph)) * mfs
let mfph = 2 * pi * 20250000000.0 * (time - 2e-08)
let mf_fllorf_re = 2 * mean((v(rf_port)) * mfw * cos(mfph)) * mfs
let mf_fllorf_im = 2 * mean((v(rf_port)) * mfw * sin(mfph)) * mfs
let mfph = 2 * pi * 20250000000.0 * (time - 2e-08)
let mf_flloif_re = 2 * mean((v(if_out)) * mfw * cos(mfph)) * mfs
let mf_flloif_im = 2 * mean((v(if_out)) * mfw * sin(mfph)) * mfs
print mf_l
print mf_n
print mf_prail
print mf_lodiff_re
print mf_lodiff_im
print mf_if_re
print mf_if_im
print mf_loif_re
print mf_loif_im
print mf_lorf_re
print mf_lorf_im
print mf_flifa_re
print mf_flifa_im
print mf_flifb_re
print mf_flifb_im
print mf_fllorf_re
print mf_fllorf_im
print mf_flloif_re
print mf_flloif_im
destroy all
echo "MFEND ls_f21p20_p3_rf60"
echo "MFRUN ls_f21p20_p3_rf66"
alterparam f1 = 21200000000.0
alterparam f2 = 21200000000.0
alterparam flo = 20200000000.0
alterparam vrf1 = 0.00031697863849222284
alterparam vrf2 = 0.0
alterparam vlo = 1.2634119882188484
reset
op
let mf_dcirail = 0 - i(vdd)
let mf_dc_vce_q1 = v(c_q1)-v(e_q1)
let mf_dc_vbe_q1 = v(b_q1)-v(e_q1)
let mf_dc_ic_q1 = i(vic_q1)
let mf_dc_vce_q2 = v(c_q2)-v(e_q2)
let mf_dc_vbe_q2 = v(b_q2)-v(e_q2)
let mf_dc_ic_q2 = i(vic_q2)
let mf_dc_vce_q3 = v(c_q3)-v(x1)
let mf_dc_vbe_q3 = v(lo_p)-v(x1)
let mf_dc_ic_q3 = i(vic_q3)
let mf_dc_vce_q4 = v(c_q4)-v(x1)
let mf_dc_vbe_q4 = v(lo_n)-v(x1)
let mf_dc_ic_q4 = i(vic_q4)
let mf_dc_vce_q5 = v(c_q5)-v(x2)
let mf_dc_vbe_q5 = v(lo_p)-v(x2)
let mf_dc_ic_q5 = i(vic_q5)
let mf_dc_vce_q6 = v(c_q6)-v(x2)
let mf_dc_vbe_q6 = v(lo_n)-v(x2)
let mf_dc_ic_q6 = i(vic_q6)
let mf_dc_sink_tail = v(tail)
print mf_dcirail
print mf_dc_vce_q1
print mf_dc_vbe_q1
print mf_dc_ic_q1
print mf_dc_vce_q2
print mf_dc_vbe_q2
print mf_dc_ic_q2
print mf_dc_vce_q3
print mf_dc_vbe_q3
print mf_dc_ic_q3
print mf_dc_vce_q4
print mf_dc_vbe_q4
print mf_dc_ic_q4
print mf_dc_vce_q5
print mf_dc_vbe_q5
print mf_dc_ic_q5
print mf_dc_vce_q6
print mf_dc_vbe_q6
print mf_dc_ic_q6
print mf_dc_sink_tail
tran 1e-12 4e-08 0 1e-12
let mfq_vce_q1 = v(c_q1)-v(e_q1)
meas tran mf_su_vcemax_q1 MAX mfq_vce_q1 from=0.0 to=2e-08
meas tran mf_su_vcemin_q1 MIN mfq_vce_q1 from=0.0 to=2e-08
meas tran mf_ss_vcemax_q1 MAX mfq_vce_q1 from=2e-08 to=4e-08
meas tran mf_ss_vcemin_q1 MIN mfq_vce_q1 from=2e-08 to=4e-08
let mfq_vbe_q1 = v(b_q1)-v(e_q1)
meas tran mf_su_vbemax_q1 MAX mfq_vbe_q1 from=0.0 to=2e-08
meas tran mf_su_vbemin_q1 MIN mfq_vbe_q1 from=0.0 to=2e-08
meas tran mf_ss_vbemax_q1 MAX mfq_vbe_q1 from=2e-08 to=4e-08
meas tran mf_ss_vbemin_q1 MIN mfq_vbe_q1 from=2e-08 to=4e-08
let mfq_ic_q1 = i(vic_q1)
meas tran mf_su_icmax_q1 MAX mfq_ic_q1 from=0.0 to=2e-08
meas tran mf_su_icmin_q1 MIN mfq_ic_q1 from=0.0 to=2e-08
meas tran mf_ss_icmax_q1 MAX mfq_ic_q1 from=2e-08 to=4e-08
meas tran mf_ss_icmin_q1 MIN mfq_ic_q1 from=2e-08 to=4e-08
let mfq_vce_q2 = v(c_q2)-v(e_q2)
meas tran mf_su_vcemax_q2 MAX mfq_vce_q2 from=0.0 to=2e-08
meas tran mf_su_vcemin_q2 MIN mfq_vce_q2 from=0.0 to=2e-08
meas tran mf_ss_vcemax_q2 MAX mfq_vce_q2 from=2e-08 to=4e-08
meas tran mf_ss_vcemin_q2 MIN mfq_vce_q2 from=2e-08 to=4e-08
let mfq_vbe_q2 = v(b_q2)-v(e_q2)
meas tran mf_su_vbemax_q2 MAX mfq_vbe_q2 from=0.0 to=2e-08
meas tran mf_su_vbemin_q2 MIN mfq_vbe_q2 from=0.0 to=2e-08
meas tran mf_ss_vbemax_q2 MAX mfq_vbe_q2 from=2e-08 to=4e-08
meas tran mf_ss_vbemin_q2 MIN mfq_vbe_q2 from=2e-08 to=4e-08
let mfq_ic_q2 = i(vic_q2)
meas tran mf_su_icmax_q2 MAX mfq_ic_q2 from=0.0 to=2e-08
meas tran mf_su_icmin_q2 MIN mfq_ic_q2 from=0.0 to=2e-08
meas tran mf_ss_icmax_q2 MAX mfq_ic_q2 from=2e-08 to=4e-08
meas tran mf_ss_icmin_q2 MIN mfq_ic_q2 from=2e-08 to=4e-08
let mfq_vce_q3 = v(c_q3)-v(x1)
meas tran mf_su_vcemax_q3 MAX mfq_vce_q3 from=0.0 to=2e-08
meas tran mf_su_vcemin_q3 MIN mfq_vce_q3 from=0.0 to=2e-08
meas tran mf_ss_vcemax_q3 MAX mfq_vce_q3 from=2e-08 to=4e-08
meas tran mf_ss_vcemin_q3 MIN mfq_vce_q3 from=2e-08 to=4e-08
let mfq_vbe_q3 = v(lo_p)-v(x1)
meas tran mf_su_vbemax_q3 MAX mfq_vbe_q3 from=0.0 to=2e-08
meas tran mf_su_vbemin_q3 MIN mfq_vbe_q3 from=0.0 to=2e-08
meas tran mf_ss_vbemax_q3 MAX mfq_vbe_q3 from=2e-08 to=4e-08
meas tran mf_ss_vbemin_q3 MIN mfq_vbe_q3 from=2e-08 to=4e-08
let mfq_ic_q3 = i(vic_q3)
meas tran mf_su_icmax_q3 MAX mfq_ic_q3 from=0.0 to=2e-08
meas tran mf_su_icmin_q3 MIN mfq_ic_q3 from=0.0 to=2e-08
meas tran mf_ss_icmax_q3 MAX mfq_ic_q3 from=2e-08 to=4e-08
meas tran mf_ss_icmin_q3 MIN mfq_ic_q3 from=2e-08 to=4e-08
let mfq_vce_q4 = v(c_q4)-v(x1)
meas tran mf_su_vcemax_q4 MAX mfq_vce_q4 from=0.0 to=2e-08
meas tran mf_su_vcemin_q4 MIN mfq_vce_q4 from=0.0 to=2e-08
meas tran mf_ss_vcemax_q4 MAX mfq_vce_q4 from=2e-08 to=4e-08
meas tran mf_ss_vcemin_q4 MIN mfq_vce_q4 from=2e-08 to=4e-08
let mfq_vbe_q4 = v(lo_n)-v(x1)
meas tran mf_su_vbemax_q4 MAX mfq_vbe_q4 from=0.0 to=2e-08
meas tran mf_su_vbemin_q4 MIN mfq_vbe_q4 from=0.0 to=2e-08
meas tran mf_ss_vbemax_q4 MAX mfq_vbe_q4 from=2e-08 to=4e-08
meas tran mf_ss_vbemin_q4 MIN mfq_vbe_q4 from=2e-08 to=4e-08
let mfq_ic_q4 = i(vic_q4)
meas tran mf_su_icmax_q4 MAX mfq_ic_q4 from=0.0 to=2e-08
meas tran mf_su_icmin_q4 MIN mfq_ic_q4 from=0.0 to=2e-08
meas tran mf_ss_icmax_q4 MAX mfq_ic_q4 from=2e-08 to=4e-08
meas tran mf_ss_icmin_q4 MIN mfq_ic_q4 from=2e-08 to=4e-08
let mfq_vce_q5 = v(c_q5)-v(x2)
meas tran mf_su_vcemax_q5 MAX mfq_vce_q5 from=0.0 to=2e-08
meas tran mf_su_vcemin_q5 MIN mfq_vce_q5 from=0.0 to=2e-08
meas tran mf_ss_vcemax_q5 MAX mfq_vce_q5 from=2e-08 to=4e-08
meas tran mf_ss_vcemin_q5 MIN mfq_vce_q5 from=2e-08 to=4e-08
let mfq_vbe_q5 = v(lo_p)-v(x2)
meas tran mf_su_vbemax_q5 MAX mfq_vbe_q5 from=0.0 to=2e-08
meas tran mf_su_vbemin_q5 MIN mfq_vbe_q5 from=0.0 to=2e-08
meas tran mf_ss_vbemax_q5 MAX mfq_vbe_q5 from=2e-08 to=4e-08
meas tran mf_ss_vbemin_q5 MIN mfq_vbe_q5 from=2e-08 to=4e-08
let mfq_ic_q5 = i(vic_q5)
meas tran mf_su_icmax_q5 MAX mfq_ic_q5 from=0.0 to=2e-08
meas tran mf_su_icmin_q5 MIN mfq_ic_q5 from=0.0 to=2e-08
meas tran mf_ss_icmax_q5 MAX mfq_ic_q5 from=2e-08 to=4e-08
meas tran mf_ss_icmin_q5 MIN mfq_ic_q5 from=2e-08 to=4e-08
let mfq_vce_q6 = v(c_q6)-v(x2)
meas tran mf_su_vcemax_q6 MAX mfq_vce_q6 from=0.0 to=2e-08
meas tran mf_su_vcemin_q6 MIN mfq_vce_q6 from=0.0 to=2e-08
meas tran mf_ss_vcemax_q6 MAX mfq_vce_q6 from=2e-08 to=4e-08
meas tran mf_ss_vcemin_q6 MIN mfq_vce_q6 from=2e-08 to=4e-08
let mfq_vbe_q6 = v(lo_n)-v(x2)
meas tran mf_su_vbemax_q6 MAX mfq_vbe_q6 from=0.0 to=2e-08
meas tran mf_su_vbemin_q6 MIN mfq_vbe_q6 from=0.0 to=2e-08
meas tran mf_ss_vbemax_q6 MAX mfq_vbe_q6 from=2e-08 to=4e-08
meas tran mf_ss_vbemin_q6 MIN mfq_vbe_q6 from=2e-08 to=4e-08
let mfq_ic_q6 = i(vic_q6)
meas tran mf_su_icmax_q6 MAX mfq_ic_q6 from=0.0 to=2e-08
meas tran mf_su_icmin_q6 MIN mfq_ic_q6 from=0.0 to=2e-08
meas tran mf_ss_icmax_q6 MAX mfq_ic_q6 from=2e-08 to=4e-08
meas tran mf_ss_icmin_q6 MIN mfq_ic_q6 from=2e-08 to=4e-08
meas tran mf_su_sinkmin_tail MIN v(tail) from=0.0 to=2e-08
meas tran mf_ss_sinkmin_tail MIN v(tail) from=2e-08 to=4e-08
print mf_su_vcemax_q1
print mf_su_vcemin_q1
print mf_ss_vcemax_q1
print mf_ss_vcemin_q1
print mf_su_vbemax_q1
print mf_su_vbemin_q1
print mf_ss_vbemax_q1
print mf_ss_vbemin_q1
print mf_su_icmax_q1
print mf_su_icmin_q1
print mf_ss_icmax_q1
print mf_ss_icmin_q1
print mf_su_vcemax_q2
print mf_su_vcemin_q2
print mf_ss_vcemax_q2
print mf_ss_vcemin_q2
print mf_su_vbemax_q2
print mf_su_vbemin_q2
print mf_ss_vbemax_q2
print mf_ss_vbemin_q2
print mf_su_icmax_q2
print mf_su_icmin_q2
print mf_ss_icmax_q2
print mf_ss_icmin_q2
print mf_su_vcemax_q3
print mf_su_vcemin_q3
print mf_ss_vcemax_q3
print mf_ss_vcemin_q3
print mf_su_vbemax_q3
print mf_su_vbemin_q3
print mf_ss_vbemax_q3
print mf_ss_vbemin_q3
print mf_su_icmax_q3
print mf_su_icmin_q3
print mf_ss_icmax_q3
print mf_ss_icmin_q3
print mf_su_vcemax_q4
print mf_su_vcemin_q4
print mf_ss_vcemax_q4
print mf_ss_vcemin_q4
print mf_su_vbemax_q4
print mf_su_vbemin_q4
print mf_ss_vbemax_q4
print mf_ss_vbemin_q4
print mf_su_icmax_q4
print mf_su_icmin_q4
print mf_ss_icmax_q4
print mf_ss_icmin_q4
print mf_su_vcemax_q5
print mf_su_vcemin_q5
print mf_ss_vcemax_q5
print mf_ss_vcemin_q5
print mf_su_vbemax_q5
print mf_su_vbemin_q5
print mf_ss_vbemax_q5
print mf_ss_vbemin_q5
print mf_su_icmax_q5
print mf_su_icmin_q5
print mf_ss_icmax_q5
print mf_ss_icmin_q5
print mf_su_vcemax_q6
print mf_su_vcemin_q6
print mf_ss_vcemax_q6
print mf_ss_vcemin_q6
print mf_su_vbemax_q6
print mf_su_vbemin_q6
print mf_ss_vbemax_q6
print mf_ss_vbemin_q6
print mf_su_icmax_q6
print mf_su_icmin_q6
print mf_ss_icmax_q6
print mf_ss_icmin_q6
print mf_su_sinkmin_tail
print mf_ss_sinkmin_tail
linearize
let mf_l = length(time)
let mfw = (time ge 1.99995e-08) * (time lt 3.99995e-08)
let mf_n = mean(mfw) * mf_l
let mfs = mf_l / mf_n
let mf_prail = mean(v(vdd) * (0 - i(vdd)) * mfw) * mfs
let mfph = 2 * pi * 20200000000.0 * (time - 2e-08)
let mf_lodiff_re = 2 * mean((v(lo_p)-v(lo_n)) * mfw * cos(mfph)) * mfs
let mf_lodiff_im = 2 * mean((v(lo_p)-v(lo_n)) * mfw * sin(mfph)) * mfs
let mfph = 2 * pi * 1000000000.0 * (time - 2e-08)
let mf_if_re = 2 * mean((v(if_out)) * mfw * cos(mfph)) * mfs
let mf_if_im = 2 * mean((v(if_out)) * mfw * sin(mfph)) * mfs
let mfph = 2 * pi * 20200000000.0 * (time - 2e-08)
let mf_loif_re = 2 * mean((v(if_out)) * mfw * cos(mfph)) * mfs
let mf_loif_im = 2 * mean((v(if_out)) * mfw * sin(mfph)) * mfs
let mfph = 2 * pi * 20200000000.0 * (time - 2e-08)
let mf_lorf_re = 2 * mean((v(rf_port)) * mfw * cos(mfph)) * mfs
let mf_lorf_im = 2 * mean((v(rf_port)) * mfw * sin(mfph)) * mfs
let mfph = 2 * pi * 950000000.0 * (time - 2e-08)
let mf_flifa_re = 2 * mean((v(if_out)) * mfw * cos(mfph)) * mfs
let mf_flifa_im = 2 * mean((v(if_out)) * mfw * sin(mfph)) * mfs
let mfph = 2 * pi * 1050000000.0 * (time - 2e-08)
let mf_flifb_re = 2 * mean((v(if_out)) * mfw * cos(mfph)) * mfs
let mf_flifb_im = 2 * mean((v(if_out)) * mfw * sin(mfph)) * mfs
let mfph = 2 * pi * 20250000000.0 * (time - 2e-08)
let mf_fllorf_re = 2 * mean((v(rf_port)) * mfw * cos(mfph)) * mfs
let mf_fllorf_im = 2 * mean((v(rf_port)) * mfw * sin(mfph)) * mfs
let mfph = 2 * pi * 20250000000.0 * (time - 2e-08)
let mf_flloif_re = 2 * mean((v(if_out)) * mfw * cos(mfph)) * mfs
let mf_flloif_im = 2 * mean((v(if_out)) * mfw * sin(mfph)) * mfs
print mf_l
print mf_n
print mf_prail
print mf_lodiff_re
print mf_lodiff_im
print mf_if_re
print mf_if_im
print mf_loif_re
print mf_loif_im
print mf_lorf_re
print mf_lorf_im
print mf_flifa_re
print mf_flifa_im
print mf_flifb_re
print mf_flifb_im
print mf_fllorf_re
print mf_fllorf_im
print mf_flloif_re
print mf_flloif_im
destroy all
echo "MFEND ls_f21p20_p3_rf66"
echo "MFRUN ls_f21p20_p6_rf60"
alterparam f1 = 21200000000.0
alterparam f2 = 21200000000.0
alterparam flo = 20200000000.0
alterparam vrf1 = 0.0006324555320336759
alterparam vrf2 = 0.0
alterparam vlo = 1.7846168676856045
reset
op
let mf_dcirail = 0 - i(vdd)
let mf_dc_vce_q1 = v(c_q1)-v(e_q1)
let mf_dc_vbe_q1 = v(b_q1)-v(e_q1)
let mf_dc_ic_q1 = i(vic_q1)
let mf_dc_vce_q2 = v(c_q2)-v(e_q2)
let mf_dc_vbe_q2 = v(b_q2)-v(e_q2)
let mf_dc_ic_q2 = i(vic_q2)
let mf_dc_vce_q3 = v(c_q3)-v(x1)
let mf_dc_vbe_q3 = v(lo_p)-v(x1)
let mf_dc_ic_q3 = i(vic_q3)
let mf_dc_vce_q4 = v(c_q4)-v(x1)
let mf_dc_vbe_q4 = v(lo_n)-v(x1)
let mf_dc_ic_q4 = i(vic_q4)
let mf_dc_vce_q5 = v(c_q5)-v(x2)
let mf_dc_vbe_q5 = v(lo_p)-v(x2)
let mf_dc_ic_q5 = i(vic_q5)
let mf_dc_vce_q6 = v(c_q6)-v(x2)
let mf_dc_vbe_q6 = v(lo_n)-v(x2)
let mf_dc_ic_q6 = i(vic_q6)
let mf_dc_sink_tail = v(tail)
print mf_dcirail
print mf_dc_vce_q1
print mf_dc_vbe_q1
print mf_dc_ic_q1
print mf_dc_vce_q2
print mf_dc_vbe_q2
print mf_dc_ic_q2
print mf_dc_vce_q3
print mf_dc_vbe_q3
print mf_dc_ic_q3
print mf_dc_vce_q4
print mf_dc_vbe_q4
print mf_dc_ic_q4
print mf_dc_vce_q5
print mf_dc_vbe_q5
print mf_dc_ic_q5
print mf_dc_vce_q6
print mf_dc_vbe_q6
print mf_dc_ic_q6
print mf_dc_sink_tail
tran 1e-12 4e-08 0 1e-12
let mfq_vce_q1 = v(c_q1)-v(e_q1)
meas tran mf_su_vcemax_q1 MAX mfq_vce_q1 from=0.0 to=2e-08
meas tran mf_su_vcemin_q1 MIN mfq_vce_q1 from=0.0 to=2e-08
meas tran mf_ss_vcemax_q1 MAX mfq_vce_q1 from=2e-08 to=4e-08
meas tran mf_ss_vcemin_q1 MIN mfq_vce_q1 from=2e-08 to=4e-08
let mfq_vbe_q1 = v(b_q1)-v(e_q1)
meas tran mf_su_vbemax_q1 MAX mfq_vbe_q1 from=0.0 to=2e-08
meas tran mf_su_vbemin_q1 MIN mfq_vbe_q1 from=0.0 to=2e-08
meas tran mf_ss_vbemax_q1 MAX mfq_vbe_q1 from=2e-08 to=4e-08
meas tran mf_ss_vbemin_q1 MIN mfq_vbe_q1 from=2e-08 to=4e-08
let mfq_ic_q1 = i(vic_q1)
meas tran mf_su_icmax_q1 MAX mfq_ic_q1 from=0.0 to=2e-08
meas tran mf_su_icmin_q1 MIN mfq_ic_q1 from=0.0 to=2e-08
meas tran mf_ss_icmax_q1 MAX mfq_ic_q1 from=2e-08 to=4e-08
meas tran mf_ss_icmin_q1 MIN mfq_ic_q1 from=2e-08 to=4e-08
let mfq_vce_q2 = v(c_q2)-v(e_q2)
meas tran mf_su_vcemax_q2 MAX mfq_vce_q2 from=0.0 to=2e-08
meas tran mf_su_vcemin_q2 MIN mfq_vce_q2 from=0.0 to=2e-08
meas tran mf_ss_vcemax_q2 MAX mfq_vce_q2 from=2e-08 to=4e-08
meas tran mf_ss_vcemin_q2 MIN mfq_vce_q2 from=2e-08 to=4e-08
let mfq_vbe_q2 = v(b_q2)-v(e_q2)
meas tran mf_su_vbemax_q2 MAX mfq_vbe_q2 from=0.0 to=2e-08
meas tran mf_su_vbemin_q2 MIN mfq_vbe_q2 from=0.0 to=2e-08
meas tran mf_ss_vbemax_q2 MAX mfq_vbe_q2 from=2e-08 to=4e-08
meas tran mf_ss_vbemin_q2 MIN mfq_vbe_q2 from=2e-08 to=4e-08
let mfq_ic_q2 = i(vic_q2)
meas tran mf_su_icmax_q2 MAX mfq_ic_q2 from=0.0 to=2e-08
meas tran mf_su_icmin_q2 MIN mfq_ic_q2 from=0.0 to=2e-08
meas tran mf_ss_icmax_q2 MAX mfq_ic_q2 from=2e-08 to=4e-08
meas tran mf_ss_icmin_q2 MIN mfq_ic_q2 from=2e-08 to=4e-08
let mfq_vce_q3 = v(c_q3)-v(x1)
meas tran mf_su_vcemax_q3 MAX mfq_vce_q3 from=0.0 to=2e-08
meas tran mf_su_vcemin_q3 MIN mfq_vce_q3 from=0.0 to=2e-08
meas tran mf_ss_vcemax_q3 MAX mfq_vce_q3 from=2e-08 to=4e-08
meas tran mf_ss_vcemin_q3 MIN mfq_vce_q3 from=2e-08 to=4e-08
let mfq_vbe_q3 = v(lo_p)-v(x1)
meas tran mf_su_vbemax_q3 MAX mfq_vbe_q3 from=0.0 to=2e-08
meas tran mf_su_vbemin_q3 MIN mfq_vbe_q3 from=0.0 to=2e-08
meas tran mf_ss_vbemax_q3 MAX mfq_vbe_q3 from=2e-08 to=4e-08
meas tran mf_ss_vbemin_q3 MIN mfq_vbe_q3 from=2e-08 to=4e-08
let mfq_ic_q3 = i(vic_q3)
meas tran mf_su_icmax_q3 MAX mfq_ic_q3 from=0.0 to=2e-08
meas tran mf_su_icmin_q3 MIN mfq_ic_q3 from=0.0 to=2e-08
meas tran mf_ss_icmax_q3 MAX mfq_ic_q3 from=2e-08 to=4e-08
meas tran mf_ss_icmin_q3 MIN mfq_ic_q3 from=2e-08 to=4e-08
let mfq_vce_q4 = v(c_q4)-v(x1)
meas tran mf_su_vcemax_q4 MAX mfq_vce_q4 from=0.0 to=2e-08
meas tran mf_su_vcemin_q4 MIN mfq_vce_q4 from=0.0 to=2e-08
meas tran mf_ss_vcemax_q4 MAX mfq_vce_q4 from=2e-08 to=4e-08
meas tran mf_ss_vcemin_q4 MIN mfq_vce_q4 from=2e-08 to=4e-08
let mfq_vbe_q4 = v(lo_n)-v(x1)
meas tran mf_su_vbemax_q4 MAX mfq_vbe_q4 from=0.0 to=2e-08
meas tran mf_su_vbemin_q4 MIN mfq_vbe_q4 from=0.0 to=2e-08
meas tran mf_ss_vbemax_q4 MAX mfq_vbe_q4 from=2e-08 to=4e-08
meas tran mf_ss_vbemin_q4 MIN mfq_vbe_q4 from=2e-08 to=4e-08
let mfq_ic_q4 = i(vic_q4)
meas tran mf_su_icmax_q4 MAX mfq_ic_q4 from=0.0 to=2e-08
meas tran mf_su_icmin_q4 MIN mfq_ic_q4 from=0.0 to=2e-08
meas tran mf_ss_icmax_q4 MAX mfq_ic_q4 from=2e-08 to=4e-08
meas tran mf_ss_icmin_q4 MIN mfq_ic_q4 from=2e-08 to=4e-08
let mfq_vce_q5 = v(c_q5)-v(x2)
meas tran mf_su_vcemax_q5 MAX mfq_vce_q5 from=0.0 to=2e-08
meas tran mf_su_vcemin_q5 MIN mfq_vce_q5 from=0.0 to=2e-08
meas tran mf_ss_vcemax_q5 MAX mfq_vce_q5 from=2e-08 to=4e-08
meas tran mf_ss_vcemin_q5 MIN mfq_vce_q5 from=2e-08 to=4e-08
let mfq_vbe_q5 = v(lo_p)-v(x2)
meas tran mf_su_vbemax_q5 MAX mfq_vbe_q5 from=0.0 to=2e-08
meas tran mf_su_vbemin_q5 MIN mfq_vbe_q5 from=0.0 to=2e-08
meas tran mf_ss_vbemax_q5 MAX mfq_vbe_q5 from=2e-08 to=4e-08
meas tran mf_ss_vbemin_q5 MIN mfq_vbe_q5 from=2e-08 to=4e-08
let mfq_ic_q5 = i(vic_q5)
meas tran mf_su_icmax_q5 MAX mfq_ic_q5 from=0.0 to=2e-08
meas tran mf_su_icmin_q5 MIN mfq_ic_q5 from=0.0 to=2e-08
meas tran mf_ss_icmax_q5 MAX mfq_ic_q5 from=2e-08 to=4e-08
meas tran mf_ss_icmin_q5 MIN mfq_ic_q5 from=2e-08 to=4e-08
let mfq_vce_q6 = v(c_q6)-v(x2)
meas tran mf_su_vcemax_q6 MAX mfq_vce_q6 from=0.0 to=2e-08
meas tran mf_su_vcemin_q6 MIN mfq_vce_q6 from=0.0 to=2e-08
meas tran mf_ss_vcemax_q6 MAX mfq_vce_q6 from=2e-08 to=4e-08
meas tran mf_ss_vcemin_q6 MIN mfq_vce_q6 from=2e-08 to=4e-08
let mfq_vbe_q6 = v(lo_n)-v(x2)
meas tran mf_su_vbemax_q6 MAX mfq_vbe_q6 from=0.0 to=2e-08
meas tran mf_su_vbemin_q6 MIN mfq_vbe_q6 from=0.0 to=2e-08
meas tran mf_ss_vbemax_q6 MAX mfq_vbe_q6 from=2e-08 to=4e-08
meas tran mf_ss_vbemin_q6 MIN mfq_vbe_q6 from=2e-08 to=4e-08
let mfq_ic_q6 = i(vic_q6)
meas tran mf_su_icmax_q6 MAX mfq_ic_q6 from=0.0 to=2e-08
meas tran mf_su_icmin_q6 MIN mfq_ic_q6 from=0.0 to=2e-08
meas tran mf_ss_icmax_q6 MAX mfq_ic_q6 from=2e-08 to=4e-08
meas tran mf_ss_icmin_q6 MIN mfq_ic_q6 from=2e-08 to=4e-08
meas tran mf_su_sinkmin_tail MIN v(tail) from=0.0 to=2e-08
meas tran mf_ss_sinkmin_tail MIN v(tail) from=2e-08 to=4e-08
print mf_su_vcemax_q1
print mf_su_vcemin_q1
print mf_ss_vcemax_q1
print mf_ss_vcemin_q1
print mf_su_vbemax_q1
print mf_su_vbemin_q1
print mf_ss_vbemax_q1
print mf_ss_vbemin_q1
print mf_su_icmax_q1
print mf_su_icmin_q1
print mf_ss_icmax_q1
print mf_ss_icmin_q1
print mf_su_vcemax_q2
print mf_su_vcemin_q2
print mf_ss_vcemax_q2
print mf_ss_vcemin_q2
print mf_su_vbemax_q2
print mf_su_vbemin_q2
print mf_ss_vbemax_q2
print mf_ss_vbemin_q2
print mf_su_icmax_q2
print mf_su_icmin_q2
print mf_ss_icmax_q2
print mf_ss_icmin_q2
print mf_su_vcemax_q3
print mf_su_vcemin_q3
print mf_ss_vcemax_q3
print mf_ss_vcemin_q3
print mf_su_vbemax_q3
print mf_su_vbemin_q3
print mf_ss_vbemax_q3
print mf_ss_vbemin_q3
print mf_su_icmax_q3
print mf_su_icmin_q3
print mf_ss_icmax_q3
print mf_ss_icmin_q3
print mf_su_vcemax_q4
print mf_su_vcemin_q4
print mf_ss_vcemax_q4
print mf_ss_vcemin_q4
print mf_su_vbemax_q4
print mf_su_vbemin_q4
print mf_ss_vbemax_q4
print mf_ss_vbemin_q4
print mf_su_icmax_q4
print mf_su_icmin_q4
print mf_ss_icmax_q4
print mf_ss_icmin_q4
print mf_su_vcemax_q5
print mf_su_vcemin_q5
print mf_ss_vcemax_q5
print mf_ss_vcemin_q5
print mf_su_vbemax_q5
print mf_su_vbemin_q5
print mf_ss_vbemax_q5
print mf_ss_vbemin_q5
print mf_su_icmax_q5
print mf_su_icmin_q5
print mf_ss_icmax_q5
print mf_ss_icmin_q5
print mf_su_vcemax_q6
print mf_su_vcemin_q6
print mf_ss_vcemax_q6
print mf_ss_vcemin_q6
print mf_su_vbemax_q6
print mf_su_vbemin_q6
print mf_ss_vbemax_q6
print mf_ss_vbemin_q6
print mf_su_icmax_q6
print mf_su_icmin_q6
print mf_ss_icmax_q6
print mf_ss_icmin_q6
print mf_su_sinkmin_tail
print mf_ss_sinkmin_tail
linearize
let mf_l = length(time)
let mfw = (time ge 1.99995e-08) * (time lt 3.99995e-08)
let mf_n = mean(mfw) * mf_l
let mfs = mf_l / mf_n
let mf_prail = mean(v(vdd) * (0 - i(vdd)) * mfw) * mfs
let mfph = 2 * pi * 20200000000.0 * (time - 2e-08)
let mf_lodiff_re = 2 * mean((v(lo_p)-v(lo_n)) * mfw * cos(mfph)) * mfs
let mf_lodiff_im = 2 * mean((v(lo_p)-v(lo_n)) * mfw * sin(mfph)) * mfs
let mfph = 2 * pi * 1000000000.0 * (time - 2e-08)
let mf_if_re = 2 * mean((v(if_out)) * mfw * cos(mfph)) * mfs
let mf_if_im = 2 * mean((v(if_out)) * mfw * sin(mfph)) * mfs
let mfph = 2 * pi * 20200000000.0 * (time - 2e-08)
let mf_loif_re = 2 * mean((v(if_out)) * mfw * cos(mfph)) * mfs
let mf_loif_im = 2 * mean((v(if_out)) * mfw * sin(mfph)) * mfs
let mfph = 2 * pi * 20200000000.0 * (time - 2e-08)
let mf_lorf_re = 2 * mean((v(rf_port)) * mfw * cos(mfph)) * mfs
let mf_lorf_im = 2 * mean((v(rf_port)) * mfw * sin(mfph)) * mfs
let mfph = 2 * pi * 950000000.0 * (time - 2e-08)
let mf_flifa_re = 2 * mean((v(if_out)) * mfw * cos(mfph)) * mfs
let mf_flifa_im = 2 * mean((v(if_out)) * mfw * sin(mfph)) * mfs
let mfph = 2 * pi * 1050000000.0 * (time - 2e-08)
let mf_flifb_re = 2 * mean((v(if_out)) * mfw * cos(mfph)) * mfs
let mf_flifb_im = 2 * mean((v(if_out)) * mfw * sin(mfph)) * mfs
let mfph = 2 * pi * 20250000000.0 * (time - 2e-08)
let mf_fllorf_re = 2 * mean((v(rf_port)) * mfw * cos(mfph)) * mfs
let mf_fllorf_im = 2 * mean((v(rf_port)) * mfw * sin(mfph)) * mfs
let mfph = 2 * pi * 20250000000.0 * (time - 2e-08)
let mf_flloif_re = 2 * mean((v(if_out)) * mfw * cos(mfph)) * mfs
let mf_flloif_im = 2 * mean((v(if_out)) * mfw * sin(mfph)) * mfs
print mf_l
print mf_n
print mf_prail
print mf_lodiff_re
print mf_lodiff_im
print mf_if_re
print mf_if_im
print mf_loif_re
print mf_loif_im
print mf_lorf_re
print mf_lorf_im
print mf_flifa_re
print mf_flifa_im
print mf_flifb_re
print mf_flifb_im
print mf_fllorf_re
print mf_fllorf_im
print mf_flloif_re
print mf_flloif_im
destroy all
echo "MFEND ls_f21p20_p6_rf60"
echo "MFRUN ls_f21p20_p6_rf66"
alterparam f1 = 21200000000.0
alterparam f2 = 21200000000.0
alterparam flo = 20200000000.0
alterparam vrf1 = 0.00031697863849222284
alterparam vrf2 = 0.0
alterparam vlo = 1.7846168676856045
reset
op
let mf_dcirail = 0 - i(vdd)
let mf_dc_vce_q1 = v(c_q1)-v(e_q1)
let mf_dc_vbe_q1 = v(b_q1)-v(e_q1)
let mf_dc_ic_q1 = i(vic_q1)
let mf_dc_vce_q2 = v(c_q2)-v(e_q2)
let mf_dc_vbe_q2 = v(b_q2)-v(e_q2)
let mf_dc_ic_q2 = i(vic_q2)
let mf_dc_vce_q3 = v(c_q3)-v(x1)
let mf_dc_vbe_q3 = v(lo_p)-v(x1)
let mf_dc_ic_q3 = i(vic_q3)
let mf_dc_vce_q4 = v(c_q4)-v(x1)
let mf_dc_vbe_q4 = v(lo_n)-v(x1)
let mf_dc_ic_q4 = i(vic_q4)
let mf_dc_vce_q5 = v(c_q5)-v(x2)
let mf_dc_vbe_q5 = v(lo_p)-v(x2)
let mf_dc_ic_q5 = i(vic_q5)
let mf_dc_vce_q6 = v(c_q6)-v(x2)
let mf_dc_vbe_q6 = v(lo_n)-v(x2)
let mf_dc_ic_q6 = i(vic_q6)
let mf_dc_sink_tail = v(tail)
print mf_dcirail
print mf_dc_vce_q1
print mf_dc_vbe_q1
print mf_dc_ic_q1
print mf_dc_vce_q2
print mf_dc_vbe_q2
print mf_dc_ic_q2
print mf_dc_vce_q3
print mf_dc_vbe_q3
print mf_dc_ic_q3
print mf_dc_vce_q4
print mf_dc_vbe_q4
print mf_dc_ic_q4
print mf_dc_vce_q5
print mf_dc_vbe_q5
print mf_dc_ic_q5
print mf_dc_vce_q6
print mf_dc_vbe_q6
print mf_dc_ic_q6
print mf_dc_sink_tail
tran 1e-12 4e-08 0 1e-12
let mfq_vce_q1 = v(c_q1)-v(e_q1)
meas tran mf_su_vcemax_q1 MAX mfq_vce_q1 from=0.0 to=2e-08
meas tran mf_su_vcemin_q1 MIN mfq_vce_q1 from=0.0 to=2e-08
meas tran mf_ss_vcemax_q1 MAX mfq_vce_q1 from=2e-08 to=4e-08
meas tran mf_ss_vcemin_q1 MIN mfq_vce_q1 from=2e-08 to=4e-08
let mfq_vbe_q1 = v(b_q1)-v(e_q1)
meas tran mf_su_vbemax_q1 MAX mfq_vbe_q1 from=0.0 to=2e-08
meas tran mf_su_vbemin_q1 MIN mfq_vbe_q1 from=0.0 to=2e-08
meas tran mf_ss_vbemax_q1 MAX mfq_vbe_q1 from=2e-08 to=4e-08
meas tran mf_ss_vbemin_q1 MIN mfq_vbe_q1 from=2e-08 to=4e-08
let mfq_ic_q1 = i(vic_q1)
meas tran mf_su_icmax_q1 MAX mfq_ic_q1 from=0.0 to=2e-08
meas tran mf_su_icmin_q1 MIN mfq_ic_q1 from=0.0 to=2e-08
meas tran mf_ss_icmax_q1 MAX mfq_ic_q1 from=2e-08 to=4e-08
meas tran mf_ss_icmin_q1 MIN mfq_ic_q1 from=2e-08 to=4e-08
let mfq_vce_q2 = v(c_q2)-v(e_q2)
meas tran mf_su_vcemax_q2 MAX mfq_vce_q2 from=0.0 to=2e-08
meas tran mf_su_vcemin_q2 MIN mfq_vce_q2 from=0.0 to=2e-08
meas tran mf_ss_vcemax_q2 MAX mfq_vce_q2 from=2e-08 to=4e-08
meas tran mf_ss_vcemin_q2 MIN mfq_vce_q2 from=2e-08 to=4e-08
let mfq_vbe_q2 = v(b_q2)-v(e_q2)
meas tran mf_su_vbemax_q2 MAX mfq_vbe_q2 from=0.0 to=2e-08
meas tran mf_su_vbemin_q2 MIN mfq_vbe_q2 from=0.0 to=2e-08
meas tran mf_ss_vbemax_q2 MAX mfq_vbe_q2 from=2e-08 to=4e-08
meas tran mf_ss_vbemin_q2 MIN mfq_vbe_q2 from=2e-08 to=4e-08
let mfq_ic_q2 = i(vic_q2)
meas tran mf_su_icmax_q2 MAX mfq_ic_q2 from=0.0 to=2e-08
meas tran mf_su_icmin_q2 MIN mfq_ic_q2 from=0.0 to=2e-08
meas tran mf_ss_icmax_q2 MAX mfq_ic_q2 from=2e-08 to=4e-08
meas tran mf_ss_icmin_q2 MIN mfq_ic_q2 from=2e-08 to=4e-08
let mfq_vce_q3 = v(c_q3)-v(x1)
meas tran mf_su_vcemax_q3 MAX mfq_vce_q3 from=0.0 to=2e-08
meas tran mf_su_vcemin_q3 MIN mfq_vce_q3 from=0.0 to=2e-08
meas tran mf_ss_vcemax_q3 MAX mfq_vce_q3 from=2e-08 to=4e-08
meas tran mf_ss_vcemin_q3 MIN mfq_vce_q3 from=2e-08 to=4e-08
let mfq_vbe_q3 = v(lo_p)-v(x1)
meas tran mf_su_vbemax_q3 MAX mfq_vbe_q3 from=0.0 to=2e-08
meas tran mf_su_vbemin_q3 MIN mfq_vbe_q3 from=0.0 to=2e-08
meas tran mf_ss_vbemax_q3 MAX mfq_vbe_q3 from=2e-08 to=4e-08
meas tran mf_ss_vbemin_q3 MIN mfq_vbe_q3 from=2e-08 to=4e-08
let mfq_ic_q3 = i(vic_q3)
meas tran mf_su_icmax_q3 MAX mfq_ic_q3 from=0.0 to=2e-08
meas tran mf_su_icmin_q3 MIN mfq_ic_q3 from=0.0 to=2e-08
meas tran mf_ss_icmax_q3 MAX mfq_ic_q3 from=2e-08 to=4e-08
meas tran mf_ss_icmin_q3 MIN mfq_ic_q3 from=2e-08 to=4e-08
let mfq_vce_q4 = v(c_q4)-v(x1)
meas tran mf_su_vcemax_q4 MAX mfq_vce_q4 from=0.0 to=2e-08
meas tran mf_su_vcemin_q4 MIN mfq_vce_q4 from=0.0 to=2e-08
meas tran mf_ss_vcemax_q4 MAX mfq_vce_q4 from=2e-08 to=4e-08
meas tran mf_ss_vcemin_q4 MIN mfq_vce_q4 from=2e-08 to=4e-08
let mfq_vbe_q4 = v(lo_n)-v(x1)
meas tran mf_su_vbemax_q4 MAX mfq_vbe_q4 from=0.0 to=2e-08
meas tran mf_su_vbemin_q4 MIN mfq_vbe_q4 from=0.0 to=2e-08
meas tran mf_ss_vbemax_q4 MAX mfq_vbe_q4 from=2e-08 to=4e-08
meas tran mf_ss_vbemin_q4 MIN mfq_vbe_q4 from=2e-08 to=4e-08
let mfq_ic_q4 = i(vic_q4)
meas tran mf_su_icmax_q4 MAX mfq_ic_q4 from=0.0 to=2e-08
meas tran mf_su_icmin_q4 MIN mfq_ic_q4 from=0.0 to=2e-08
meas tran mf_ss_icmax_q4 MAX mfq_ic_q4 from=2e-08 to=4e-08
meas tran mf_ss_icmin_q4 MIN mfq_ic_q4 from=2e-08 to=4e-08
let mfq_vce_q5 = v(c_q5)-v(x2)
meas tran mf_su_vcemax_q5 MAX mfq_vce_q5 from=0.0 to=2e-08
meas tran mf_su_vcemin_q5 MIN mfq_vce_q5 from=0.0 to=2e-08
meas tran mf_ss_vcemax_q5 MAX mfq_vce_q5 from=2e-08 to=4e-08
meas tran mf_ss_vcemin_q5 MIN mfq_vce_q5 from=2e-08 to=4e-08
let mfq_vbe_q5 = v(lo_p)-v(x2)
meas tran mf_su_vbemax_q5 MAX mfq_vbe_q5 from=0.0 to=2e-08
meas tran mf_su_vbemin_q5 MIN mfq_vbe_q5 from=0.0 to=2e-08
meas tran mf_ss_vbemax_q5 MAX mfq_vbe_q5 from=2e-08 to=4e-08
meas tran mf_ss_vbemin_q5 MIN mfq_vbe_q5 from=2e-08 to=4e-08
let mfq_ic_q5 = i(vic_q5)
meas tran mf_su_icmax_q5 MAX mfq_ic_q5 from=0.0 to=2e-08
meas tran mf_su_icmin_q5 MIN mfq_ic_q5 from=0.0 to=2e-08
meas tran mf_ss_icmax_q5 MAX mfq_ic_q5 from=2e-08 to=4e-08
meas tran mf_ss_icmin_q5 MIN mfq_ic_q5 from=2e-08 to=4e-08
let mfq_vce_q6 = v(c_q6)-v(x2)
meas tran mf_su_vcemax_q6 MAX mfq_vce_q6 from=0.0 to=2e-08
meas tran mf_su_vcemin_q6 MIN mfq_vce_q6 from=0.0 to=2e-08
meas tran mf_ss_vcemax_q6 MAX mfq_vce_q6 from=2e-08 to=4e-08
meas tran mf_ss_vcemin_q6 MIN mfq_vce_q6 from=2e-08 to=4e-08
let mfq_vbe_q6 = v(lo_n)-v(x2)
meas tran mf_su_vbemax_q6 MAX mfq_vbe_q6 from=0.0 to=2e-08
meas tran mf_su_vbemin_q6 MIN mfq_vbe_q6 from=0.0 to=2e-08
meas tran mf_ss_vbemax_q6 MAX mfq_vbe_q6 from=2e-08 to=4e-08
meas tran mf_ss_vbemin_q6 MIN mfq_vbe_q6 from=2e-08 to=4e-08
let mfq_ic_q6 = i(vic_q6)
meas tran mf_su_icmax_q6 MAX mfq_ic_q6 from=0.0 to=2e-08
meas tran mf_su_icmin_q6 MIN mfq_ic_q6 from=0.0 to=2e-08
meas tran mf_ss_icmax_q6 MAX mfq_ic_q6 from=2e-08 to=4e-08
meas tran mf_ss_icmin_q6 MIN mfq_ic_q6 from=2e-08 to=4e-08
meas tran mf_su_sinkmin_tail MIN v(tail) from=0.0 to=2e-08
meas tran mf_ss_sinkmin_tail MIN v(tail) from=2e-08 to=4e-08
print mf_su_vcemax_q1
print mf_su_vcemin_q1
print mf_ss_vcemax_q1
print mf_ss_vcemin_q1
print mf_su_vbemax_q1
print mf_su_vbemin_q1
print mf_ss_vbemax_q1
print mf_ss_vbemin_q1
print mf_su_icmax_q1
print mf_su_icmin_q1
print mf_ss_icmax_q1
print mf_ss_icmin_q1
print mf_su_vcemax_q2
print mf_su_vcemin_q2
print mf_ss_vcemax_q2
print mf_ss_vcemin_q2
print mf_su_vbemax_q2
print mf_su_vbemin_q2
print mf_ss_vbemax_q2
print mf_ss_vbemin_q2
print mf_su_icmax_q2
print mf_su_icmin_q2
print mf_ss_icmax_q2
print mf_ss_icmin_q2
print mf_su_vcemax_q3
print mf_su_vcemin_q3
print mf_ss_vcemax_q3
print mf_ss_vcemin_q3
print mf_su_vbemax_q3
print mf_su_vbemin_q3
print mf_ss_vbemax_q3
print mf_ss_vbemin_q3
print mf_su_icmax_q3
print mf_su_icmin_q3
print mf_ss_icmax_q3
print mf_ss_icmin_q3
print mf_su_vcemax_q4
print mf_su_vcemin_q4
print mf_ss_vcemax_q4
print mf_ss_vcemin_q4
print mf_su_vbemax_q4
print mf_su_vbemin_q4
print mf_ss_vbemax_q4
print mf_ss_vbemin_q4
print mf_su_icmax_q4
print mf_su_icmin_q4
print mf_ss_icmax_q4
print mf_ss_icmin_q4
print mf_su_vcemax_q5
print mf_su_vcemin_q5
print mf_ss_vcemax_q5
print mf_ss_vcemin_q5
print mf_su_vbemax_q5
print mf_su_vbemin_q5
print mf_ss_vbemax_q5
print mf_ss_vbemin_q5
print mf_su_icmax_q5
print mf_su_icmin_q5
print mf_ss_icmax_q5
print mf_ss_icmin_q5
print mf_su_vcemax_q6
print mf_su_vcemin_q6
print mf_ss_vcemax_q6
print mf_ss_vcemin_q6
print mf_su_vbemax_q6
print mf_su_vbemin_q6
print mf_ss_vbemax_q6
print mf_ss_vbemin_q6
print mf_su_icmax_q6
print mf_su_icmin_q6
print mf_ss_icmax_q6
print mf_ss_icmin_q6
print mf_su_sinkmin_tail
print mf_ss_sinkmin_tail
linearize
let mf_l = length(time)
let mfw = (time ge 1.99995e-08) * (time lt 3.99995e-08)
let mf_n = mean(mfw) * mf_l
let mfs = mf_l / mf_n
let mf_prail = mean(v(vdd) * (0 - i(vdd)) * mfw) * mfs
let mfph = 2 * pi * 20200000000.0 * (time - 2e-08)
let mf_lodiff_re = 2 * mean((v(lo_p)-v(lo_n)) * mfw * cos(mfph)) * mfs
let mf_lodiff_im = 2 * mean((v(lo_p)-v(lo_n)) * mfw * sin(mfph)) * mfs
let mfph = 2 * pi * 1000000000.0 * (time - 2e-08)
let mf_if_re = 2 * mean((v(if_out)) * mfw * cos(mfph)) * mfs
let mf_if_im = 2 * mean((v(if_out)) * mfw * sin(mfph)) * mfs
let mfph = 2 * pi * 20200000000.0 * (time - 2e-08)
let mf_loif_re = 2 * mean((v(if_out)) * mfw * cos(mfph)) * mfs
let mf_loif_im = 2 * mean((v(if_out)) * mfw * sin(mfph)) * mfs
let mfph = 2 * pi * 20200000000.0 * (time - 2e-08)
let mf_lorf_re = 2 * mean((v(rf_port)) * mfw * cos(mfph)) * mfs
let mf_lorf_im = 2 * mean((v(rf_port)) * mfw * sin(mfph)) * mfs
let mfph = 2 * pi * 950000000.0 * (time - 2e-08)
let mf_flifa_re = 2 * mean((v(if_out)) * mfw * cos(mfph)) * mfs
let mf_flifa_im = 2 * mean((v(if_out)) * mfw * sin(mfph)) * mfs
let mfph = 2 * pi * 1050000000.0 * (time - 2e-08)
let mf_flifb_re = 2 * mean((v(if_out)) * mfw * cos(mfph)) * mfs
let mf_flifb_im = 2 * mean((v(if_out)) * mfw * sin(mfph)) * mfs
let mfph = 2 * pi * 20250000000.0 * (time - 2e-08)
let mf_fllorf_re = 2 * mean((v(rf_port)) * mfw * cos(mfph)) * mfs
let mf_fllorf_im = 2 * mean((v(rf_port)) * mfw * sin(mfph)) * mfs
let mfph = 2 * pi * 20250000000.0 * (time - 2e-08)
let mf_flloif_re = 2 * mean((v(if_out)) * mfw * cos(mfph)) * mfs
let mf_flloif_im = 2 * mean((v(if_out)) * mfw * sin(mfph)) * mfs
print mf_l
print mf_n
print mf_prail
print mf_lodiff_re
print mf_lodiff_im
print mf_if_re
print mf_if_im
print mf_loif_re
print mf_loif_im
print mf_lorf_re
print mf_lorf_im
print mf_flifa_re
print mf_flifa_im
print mf_flifb_re
print mf_flifb_im
print mf_fllorf_re
print mf_fllorf_im
print mf_flloif_re
print mf_flloif_im
destroy all
echo "MFEND ls_f21p20_p6_rf66"
echo "MF_DECK_END"
.endc
