* Mixer-topology feasibility bench (issue #35): COMMON PORT DEFINITIONS.
*
* DEVICE-LEVEL TOPOLOGY STUDY, NOT A DESIGN. This file is prepended by
* ../mixfeas.py (compose_fragment) to EVERY candidate fragment in this
* directory, so all candidates see bit-identical port, power and supply
* conventions. Only the candidate fragment differs. Harness fragment rules
* apply (sim/harness/testbench.py): no .lib/.temp/.include/.control/.end.
*
* Parameters set by the driver (generated .param lines, then alterparam in
* the control block), never by a candidate:
*   vdd_val  supply rail for this PVT point (sim/harness)
*   f1, f2   RF tone frequencies [Hz] (single-tone runs: vrf2 = 0)
*   flo      LO frequency [Hz] (low-side: RF - 1 GHz, see tb.json "study")
*   vrf1/2   open-circuit PEAK voltage of each RF tone [V]
*   vlo      open-circuit PEAK DIFFERENTIAL LO voltage [V]
*   rf_dc    DC level of the RF source leg (an ideal bias tee; 0 if the
*            candidate biases its RF input itself)
*   lo_dc    DC level of BOTH LO source legs (ideal bias tee)
*
* ---- Ports -------------------------------------------------------------------
* RF:  single-ended 50 ohm Thevenin port. Reference plane = node rf_port.
*      Available power per tone  P_av = vrf^2 / (8 * z0).
*      With the RF source at 0 (RF off) Rrf is the RF port's 50 ohm
*      termination; LO-to-RF leakage = |V(rf_port) at flo|^2 / (2 * z0),
*      i.e. power DELIVERED into that termination.
* LO:  differential 100 ohm reference port: two 50 ohm legs driven in
*      antiphase (+vlo/2, -vlo/2 peak). Reference plane = nodes lo_p/lo_n.
*      Thevenin differential open-circuit peak = vlo, R_diff = 2 * z0, so
*      the TOTAL available LO power is P_av = vlo^2 / (8 * R_diff)
*      (issue #35 formula), quoted as one number, not per leg. The loaded
*      differential voltage is V(lo_p) - V(lo_n) at flo.
* IF:  physical 50 ohm termination Rif at node if_out. Every candidate
*      transforms its output to if_out with an ideal transformer stated in
*      its own fragment header; IF power = |V(if_out) at f_if|^2 / (2 * z0),
*      power DELIVERED into Rif. LO-to-IF leakage is the same quantity at flo
*      with the RF source off.
* Rail: Vdd, node vdd. Mixer-only DC rail power = vdd_val * (-I(Vdd)),
*      averaged over the retained window (and at the DC operating point).
*      Ideal bias sources (rf_dc, lo_dc, candidate bias sources) are NOT
*      rail power; they are ideal bias elements, stated as such.
*
* No inductor of any kind appears here or in any candidate. The two ideal
* transformer subcircuits below are lossless, frequency-independent,
* DC-coupled controlled-source models (E/F sources); they are ideal baluns,
* not a passive model of anything on this PDK.

.param z0=50

* ---- supply ---------------------------------------------------------------
Vdd vdd 0 DC {vdd_val}

* ---- RF port: two series tones behind one 50 ohm source resistance ------
Vrf1 rfa 0 DC {rf_dc} SIN({rf_dc} {vrf1} {f1})
Vrf2 rfs rfa DC 0 SIN(0 {vrf2} {f2})
Rrf rfs rf_port {z0}

* ---- LO port: two antiphase 50 ohm legs (ideal bias tee = lo_dc) ---------
Vlop lops 0 DC {lo_dc} SIN({lo_dc} {vlo/2} {flo})
Vlon lons 0 DC {lo_dc} SIN({lo_dc} {-vlo/2} {flo})
Rlop lops lo_p {z0}
Rlon lons lo_n {z0}

* ---- IF termination -----------------------------------------------------------
Rif if_out 0 {z0}

* ---- ideal transformers -------------------------------------------------------
* mf_balun: single-ended winding se (to ground) <-> centre-tapped
* differential winding pos/neg around ct.
*   V(pos) - V(neg) = n * V(se)       (each half n/2, antiphase about ct)
*   I into se        = n * I_diff      (power conserving)
* so Z_diff = n^2 * Z_se. Bidirectional: either side may be the source.
.subckt mf_balun se pos neg ct n=1
Ep pi ct se 0 {n/2}
Vsp pi pos 0
En ni ct se 0 {-n/2}
Vsn ni neg 0
Fp se 0 Vsp {n/2}
Fn se 0 Vsn {-n/2}
.ends mf_balun

* mf_xfmr: single-ended to single-ended ideal transformer (both windings to
* ground), V(sec) = n * V(pri), I into pri = n * I out of sec, so
* Z_pri = Z_sec / n^2.
.subckt mf_xfmr pri sec n=1
Es si 0 pri 0 {n}
Vss si sec 0
Fs pri 0 Vss {n}
.ends mf_xfmr
