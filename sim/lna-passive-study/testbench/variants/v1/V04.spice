* SUBSTITUTED-PRIMITIVE VARIANT V04 of design/netlist/lna_stage1.spice (issue #340, sim/lna-passive-study): V01 with the SMALLEST on-chip cmim Cblk_in that still closes the input match, re-matched (Lin/Cshunt re-derived at the DRAFT band centre by the design's own L-section method): DR-0011 option (b). The value, side and re-match values are frozen by testbench/prematch.json BEFORE the collection; if no grid value closes, V04 is dropped and the record says so.
* GENERATED by sim/lna-passive-study/run.py; NOT a production schematic; do not edit.
* Sizings from layout/lna_stage1/passive_sizing.json (PDK models, corrections included).
* The inductors (Lin, Lfeed, Le1) remain IDEAL lossless ngspice L: no PDK inductor
* model exists (#110 / DR-0005). This deck selects nothing and claims no spec row.
* lna_stage1 subcircuit, exported by xschem from design/lna_stage1.sch via 'klt netlist --block'
* tools: XSCHEM V3.4.7; klt 0.9.2.dev1022+g2a9c52b27ce7; sources sha256 (lna_stage1.sch then lna_stage1.sym concatenated): c6c82d72a0e711158ae6fc75a4d4f7e6293eba6b75819432d08b29b52eda64c2
* DERIVED FILE: regenerate with design/export_netlist.sh, never edit by hand.
* Matching elements (Cshunt, Lin, Lfeed, Cm) and the emitter-degeneration inductor Le1 are IDEAL lossless L/C: no PDK inductor model exists.
** sch_path: design/lna_stage1.sch
.subckt lna_stage1 in out vdd gnd
*.ipin in
*.opin out
*.iopin vdd
*.iopin gnd
* Rref -> rppd (R_typ 8000.94 ohm vs design 8k)
Xref vdd nr gnd rppd w=0.5u l=15.48u m=1
Xqr nr br er gnd npn13G2 Nx=1
* Rbr -> rppd (R_typ 60904.8 ohm vs design 60.9k)
Xbr nr br gnd rppd w=0.5u l=119.66u m=1
* Rer -> rsil (R_typ 24 ohm vs design 24)
Xer er gnd gnd rsil w=0.75u l=1.32u m=1
* Rbias -> rppd (R_typ 10001.7 ohm vs design 10k)
Xbias nr b1 gnd rppd w=0.5u l=19.42u m=1
Lfeed vdd oc 0.962n m=1
* Rd -> rppd (R_typ 465 ohm vs design 465)
Xd vdd oc gnd rppd w=0.5u l=0.64u m=1
Xq2 oc b2 c1 gnd npn13G2 Nx=8
Xq1 c1 b1 e1 gnd npn13G2 Nx=8
Le1 e1 e1d 67p m=1
* Re1 -> rsil (R_typ 3.01315 ohm vs design 3)
Xe1 e1d gnd gnd rsil w=5u l=0.87u m=1
* R1b -> rppd (R_typ 1500.94 ohm vs design 1.5k)
X1b vdd b2 gnd rppd w=0.5u l=2.68u m=1
* R2b -> rppd (R_typ 7000.55 ohm vs design 7k)
X2b b2 gnd gnd rppd w=0.5u l=13.51u m=1
* Cb2 -> cap_cmim x2 (C_typ 1.00029e-11 F vs design 10p)
Xb2 b2 gnd cap_cmim w=57.69u l=57.69u m=2
* Cshunt re-matched for the on-chip Cblk_in (170f -> 31.89f, DR-0011 option b bounded iteration)
Cshunt in gnd 31.89f m=1
* Lin re-matched for the on-chip Cblk_in (1.41n -> 1.317n, DR-0011 option b bounded iteration)
Lin in in2 1.317n m=1
* Cblk_in -> cap_cmim x1 (C_typ 1.00026e-12 F vs design 1n)
Xblk_in in2 b1 cap_cmim w=25.77u l=25.77u m=1
* Cm -> cap_cmim x1 (C_typ 5.7904e-14 F vs design 57.8f)
Xm oc out cap_cmim w=6.16u l=6.16u m=1
.ends
