* mixer-cm-interface-probe (issue #89) -- ONE nominal point:
* hbt_typ / 27 C / VDD = 2.50 V. Template: run_probe.py substitutes the model
* library path, the placeholder path, the control fragment and the generated run
* blocks (the four brace tokens below), then runs the result ONCE with `ngspice -b`.
* Single local probe process; no grid, no sweep, no loop outside the ngspice
* control language's own sequential runs.
*
* What this measures: which interfaces a conversion-matrix NF solver would need
* are reachable on the PINNED simulator/model (LO-period trajectory, wanted and
* image sideband transfer, per-mechanism noise intensity, noise covariance).
* It does not measure the mixer's noise. No number printed here is a noise figure.
*
* DUT: the placeholder mixer fragment included VERBATIM (one npn13G2, Nx=4;
* RF two-tone + LO summed at the base; output node `coll`). Its own RF tones are
* zeroed (alterparam vrf=0). LO drive is a PROBE SETTING (vlo as in the
* placeholder), not a qualified design selection.
*
* Transfer probe: two extra perturbation sources (Vpu: wanted sideband
* fLO+fIF, Vpl: image sideband fLO-fIF; fIF = 1 GHz) drive the base through
* 50 ohm + 1 pF like every other port. Each run's IF-projection of v(coll)
* minus the LO-only baseline run's projection is the perturbation response.
* The same source parameters also drive the disjoint ideal-mixer control, so
* control and DUT see identical stimuli in identical runs.
*
* Projections are .meas INTEG (trapezoid) of v*cos / v*sin over the last 40 ns of a 120 ns run (80n to 120n)
* (40 IF periods and 738 LO periods: every analysed tone is an integer
* multiple of 25 MHz = 1/40 ns, so the projections are orthogonal).

.lib "{model_lib}" hbt_typ
.temp 27
.param vdd_val=2.5
.include "{placeholder}"

.param apu=0 apl=0 phu=20 phl=70

* ---- perturbation sources into the DUT base ----
Vpu pus 0 DC 0 SIN(0 {apu} 19.45e9 0 0 {phu})
Rpu pus pup 50
Cpu pup base 1p
Vpl pls 0 DC 0 SIN(0 {apl} 17.45e9 0 0 {phl})
Rpl pls plp 50
Cpl plp base 1p

* ---- known-answer ideal-mixer control (disjoint circuit) ----
.include "{control}"

.options savecurrents=0
.control
set noaskquit
set filetype=ascii
echo "MARK ngspice_banner_follows"
version -s
let wif = 2*pi*1e9
let wxf = 2*pi*1.025e9
let wlo = 2*pi*18.45e9
let w2lo = 4*pi*18.45e9

{runs}

* ---------- N: .noise about the LO-off DC operating point, two DC biases ----------
alterparam apu=0
alterparam apl=0
alterparam vrf=0
alterparam vlo=0
alterparam vbb_mx=0.90
reset
alter @vrf[acmag] = 1
noise v(coll) vrf dec 50 250e6 500e9 1
echo "MARK N_section_begin=bias_a"
print all
echo "MARK N_section_end=bias_a"
alterparam vbb_mx=0.85
reset
alter @vrf[acmag] = 1
noise v(coll) vrf dec 50 250e6 500e9 1
echo "MARK N_section_begin=bias_b"
print all
echo "MARK N_section_end=bias_b"

* ---------- E: periodic steady state / periodic noise availability ----------
echo "MARK E_pss_attempt_begin"
pss 18.45e9 1n coll 1024 10 50 5e-3
echo "MARK E_pss_attempt_end"
echo "MARK E_pnoise_attempt_begin"
pnoise
pac
echo "MARK E_pnoise_attempt_end"
echo "MARK done"
quit
.endc
.end
