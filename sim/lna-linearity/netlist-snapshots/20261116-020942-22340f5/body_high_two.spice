* lna-linearity high_two -- GENERATED by sim/lna-linearity/run.py, do not edit
.param z0=50
.param va1=0 va2=0

* lna_stage1 subcircuit, exported by xschem from design/lna_stage1.sch via 'klt netlist --block'
* tools: XSCHEM V3.4.7; klt 0.9.2.dev1022+g2a9c52b27ce7; sources sha256 (lna_stage1.sch then lna_stage1.sym concatenated): c6c82d72a0e711158ae6fc75a4d4f7e6293eba6b75819432d08b29b52eda64c2
* DERIVED FILE: regenerate with design/export_netlist.sh, never edit by hand.
* Matching elements (Cshunt, Lin, Lfeed, Cm) and the emitter-degeneration inductor Le1 are IDEAL lossless L/C: no PDK inductor model exists.
** sch_path: design/lna_stage1.sch
.subckt lna_stage1 in out vdd gnd
*.ipin in
*.opin out
*.iopin vdd
*.iopin gnd
Rref vdd nr 8k m=1
Xqr nr br er gnd npn13G2 Nx=1
Rbr nr br 60.9k m=1
Rer er gnd 24 m=1
Rbias nr b1 10k m=1
Lfeed vdd oc 0.962n m=1
Rd vdd oc 465 m=1
Xq2 oc b2 c1 gnd npn13G2 Nx=8
Xq1 c1 b1 e1 gnd npn13G2 Nx=8
Le1 e1 e1d 67p m=1
Re1 e1d gnd 3 m=1
R1b vdd b2 1.5k m=1
R2b b2 gnd 7k m=1
Cb2 b2 gnd 10p m=1
Cshunt in gnd 170f m=1
Lin in in2 1.41n m=1
Cblk_in in2 b1 1n m=1
Cm oc out 57.8f m=1
.ends

.param vdd_val=2.5
Vdd vdd 0 DC {vdd_val}
Xdut p1 p2 vdd 0 lna_stage1
.options reltol=1e-07 trtol=1.0
.param fq1=1e10 fq2=1e10
Bs n2 0 V = (time<5e-09 ? 0.5*(1-cos(pi*time/5e-09)) : 1)*({va1}*sin(2*pi*{fq1}*time) + {va2}*sin(2*pi*{fq2}*time))
Rs n2 p1 {z0}
RL p2 0 {z0}

.control
set numdgt=12
set noaskquit
  * run b_two00: two-tone, available power -56 dBm per tone
  alterparam fq1 = 20900000000.0
  alterparam fq2 = 21000000000.0
  alterparam va1 = 0.00100237446725455
  alterparam va2 = 0.00100237446725455
  reset
  save all @q.xdut.xq1.qnpn13g2[ic] @q.xdut.xq2.qnpn13g2[ic]
  tran 1e-12 6e-08 0 1e-12
  linearize v(p2) v(xdut.c1) v(xdut.e1) v(xdut.oc) v(xdut.b1) v(xdut.b2) @q.xdut.xq1.qnpn13g2[ic] @q.xdut.xq2.qnpn13g2[ic]
  let tt = time[40000,59999]
  let xo = v(p2)[40000,59999]
  let m_b_two00_n = length(xo)
  let m_b_two00_t0 = tt[0]
  let m_b_two00_t1 = tt[19999]
  let m_b_two00_f1_c = 2*mean(xo*cos(2*pi*20900000000.0*tt))
  let m_b_two00_f1_s = 2*mean(xo*sin(2*pi*20900000000.0*tt))
  let m_b_two00_f2_c = 2*mean(xo*cos(2*pi*21000000000.0*tt))
  let m_b_two00_f2_s = 2*mean(xo*sin(2*pi*21000000000.0*tt))
  let m_b_two00_im3l_c = 2*mean(xo*cos(2*pi*20800000000.0*tt))
  let m_b_two00_im3l_s = 2*mean(xo*sin(2*pi*20800000000.0*tt))
  let m_b_two00_im3h_c = 2*mean(xo*cos(2*pi*21100000000.0*tt))
  let m_b_two00_im3h_s = 2*mean(xo*sin(2*pi*21100000000.0*tt))
  let m_b_two00_fl_lo_c = 2*mean(xo*cos(2*pi*20750000000.0*tt))
  let m_b_two00_fl_lo_s = 2*mean(xo*sin(2*pi*20750000000.0*tt))
  let m_b_two00_fl_hi_c = 2*mean(xo*cos(2*pi*21150000000.0*tt))
  let m_b_two00_fl_hi_s = 2*mean(xo*sin(2*pi*21150000000.0*tt))
  let m_b_two00_vce_q1_max = maximum(v(xdut.c1)[40000,59999] - v(xdut.e1)[40000,59999])
  let m_b_two00_vce_q1_min = minimum(v(xdut.c1)[40000,59999] - v(xdut.e1)[40000,59999])
  let m_b_two00_vce_q2_max = maximum(v(xdut.oc)[40000,59999] - v(xdut.c1)[40000,59999])
  let m_b_two00_vce_q2_min = minimum(v(xdut.oc)[40000,59999] - v(xdut.c1)[40000,59999])
  let m_b_two00_vbe_q1_max = maximum(v(xdut.b1)[40000,59999] - v(xdut.e1)[40000,59999])
  let m_b_two00_vbe_q1_min = minimum(v(xdut.b1)[40000,59999] - v(xdut.e1)[40000,59999])
  let m_b_two00_vbe_q2_max = maximum(v(xdut.b2)[40000,59999] - v(xdut.c1)[40000,59999])
  let m_b_two00_vbe_q2_min = minimum(v(xdut.b2)[40000,59999] - v(xdut.c1)[40000,59999])
  let w_b_two00_ic_q1 = @q.xdut.xq1.qnpn13g2[ic][40000,59999]
  let m_b_two00_ic_q1_max = maximum(w_b_two00_ic_q1)
  let m_b_two00_ic_q1_min = minimum(w_b_two00_ic_q1)
  let w_b_two00_ic_q2 = @q.xdut.xq2.qnpn13g2[ic][40000,59999]
  let m_b_two00_ic_q2_max = maximum(w_b_two00_ic_q2)
  let m_b_two00_ic_q2_min = minimum(w_b_two00_ic_q2)
  print m_b_two00_n m_b_two00_t0 m_b_two00_t1 m_b_two00_f1_c m_b_two00_f1_s m_b_two00_f2_c
  print m_b_two00_f2_s m_b_two00_im3l_c m_b_two00_im3l_s m_b_two00_im3h_c m_b_two00_im3h_s m_b_two00_fl_lo_c
  print m_b_two00_fl_lo_s m_b_two00_fl_hi_c m_b_two00_fl_hi_s m_b_two00_vce_q1_max m_b_two00_vce_q1_min m_b_two00_vce_q2_max
  print m_b_two00_vce_q2_min m_b_two00_vbe_q1_max m_b_two00_vbe_q1_min m_b_two00_vbe_q2_max m_b_two00_vbe_q2_min m_b_two00_ic_q1_max
  print m_b_two00_ic_q1_min m_b_two00_ic_q2_max m_b_two00_ic_q2_min
  * run b_two01: two-tone, available power -55 dBm per tone
  alterparam fq1 = 20900000000.0
  alterparam fq2 = 21000000000.0
  alterparam va1 = 0.0011246826503807
  alterparam va2 = 0.0011246826503807
  reset
  save all @q.xdut.xq1.qnpn13g2[ic] @q.xdut.xq2.qnpn13g2[ic]
  tran 1e-12 6e-08 0 1e-12
  linearize v(p2) v(xdut.c1) v(xdut.e1) v(xdut.oc) v(xdut.b1) v(xdut.b2) @q.xdut.xq1.qnpn13g2[ic] @q.xdut.xq2.qnpn13g2[ic]
  let tt = time[40000,59999]
  let xo = v(p2)[40000,59999]
  let m_b_two01_n = length(xo)
  let m_b_two01_t0 = tt[0]
  let m_b_two01_t1 = tt[19999]
  let m_b_two01_f1_c = 2*mean(xo*cos(2*pi*20900000000.0*tt))
  let m_b_two01_f1_s = 2*mean(xo*sin(2*pi*20900000000.0*tt))
  let m_b_two01_f2_c = 2*mean(xo*cos(2*pi*21000000000.0*tt))
  let m_b_two01_f2_s = 2*mean(xo*sin(2*pi*21000000000.0*tt))
  let m_b_two01_im3l_c = 2*mean(xo*cos(2*pi*20800000000.0*tt))
  let m_b_two01_im3l_s = 2*mean(xo*sin(2*pi*20800000000.0*tt))
  let m_b_two01_im3h_c = 2*mean(xo*cos(2*pi*21100000000.0*tt))
  let m_b_two01_im3h_s = 2*mean(xo*sin(2*pi*21100000000.0*tt))
  let m_b_two01_fl_lo_c = 2*mean(xo*cos(2*pi*20750000000.0*tt))
  let m_b_two01_fl_lo_s = 2*mean(xo*sin(2*pi*20750000000.0*tt))
  let m_b_two01_fl_hi_c = 2*mean(xo*cos(2*pi*21150000000.0*tt))
  let m_b_two01_fl_hi_s = 2*mean(xo*sin(2*pi*21150000000.0*tt))
  let m_b_two01_vce_q1_max = maximum(v(xdut.c1)[40000,59999] - v(xdut.e1)[40000,59999])
  let m_b_two01_vce_q1_min = minimum(v(xdut.c1)[40000,59999] - v(xdut.e1)[40000,59999])
  let m_b_two01_vce_q2_max = maximum(v(xdut.oc)[40000,59999] - v(xdut.c1)[40000,59999])
  let m_b_two01_vce_q2_min = minimum(v(xdut.oc)[40000,59999] - v(xdut.c1)[40000,59999])
  let m_b_two01_vbe_q1_max = maximum(v(xdut.b1)[40000,59999] - v(xdut.e1)[40000,59999])
  let m_b_two01_vbe_q1_min = minimum(v(xdut.b1)[40000,59999] - v(xdut.e1)[40000,59999])
  let m_b_two01_vbe_q2_max = maximum(v(xdut.b2)[40000,59999] - v(xdut.c1)[40000,59999])
  let m_b_two01_vbe_q2_min = minimum(v(xdut.b2)[40000,59999] - v(xdut.c1)[40000,59999])
  let w_b_two01_ic_q1 = @q.xdut.xq1.qnpn13g2[ic][40000,59999]
  let m_b_two01_ic_q1_max = maximum(w_b_two01_ic_q1)
  let m_b_two01_ic_q1_min = minimum(w_b_two01_ic_q1)
  let w_b_two01_ic_q2 = @q.xdut.xq2.qnpn13g2[ic][40000,59999]
  let m_b_two01_ic_q2_max = maximum(w_b_two01_ic_q2)
  let m_b_two01_ic_q2_min = minimum(w_b_two01_ic_q2)
  print m_b_two01_n m_b_two01_t0 m_b_two01_t1 m_b_two01_f1_c m_b_two01_f1_s m_b_two01_f2_c
  print m_b_two01_f2_s m_b_two01_im3l_c m_b_two01_im3l_s m_b_two01_im3h_c m_b_two01_im3h_s m_b_two01_fl_lo_c
  print m_b_two01_fl_lo_s m_b_two01_fl_hi_c m_b_two01_fl_hi_s m_b_two01_vce_q1_max m_b_two01_vce_q1_min m_b_two01_vce_q2_max
  print m_b_two01_vce_q2_min m_b_two01_vbe_q1_max m_b_two01_vbe_q1_min m_b_two01_vbe_q2_max m_b_two01_vbe_q2_min m_b_two01_ic_q1_max
  print m_b_two01_ic_q1_min m_b_two01_ic_q2_max m_b_two01_ic_q2_min
  * run b_two02: two-tone, available power -54 dBm per tone
  alterparam fq1 = 20900000000.0
  alterparam fq2 = 21000000000.0
  alterparam va1 = 0.00126191468896039
  alterparam va2 = 0.00126191468896039
  reset
  save all @q.xdut.xq1.qnpn13g2[ic] @q.xdut.xq2.qnpn13g2[ic]
  tran 1e-12 6e-08 0 1e-12
  linearize v(p2) v(xdut.c1) v(xdut.e1) v(xdut.oc) v(xdut.b1) v(xdut.b2) @q.xdut.xq1.qnpn13g2[ic] @q.xdut.xq2.qnpn13g2[ic]
  let tt = time[40000,59999]
  let xo = v(p2)[40000,59999]
  let m_b_two02_n = length(xo)
  let m_b_two02_t0 = tt[0]
  let m_b_two02_t1 = tt[19999]
  let m_b_two02_f1_c = 2*mean(xo*cos(2*pi*20900000000.0*tt))
  let m_b_two02_f1_s = 2*mean(xo*sin(2*pi*20900000000.0*tt))
  let m_b_two02_f2_c = 2*mean(xo*cos(2*pi*21000000000.0*tt))
  let m_b_two02_f2_s = 2*mean(xo*sin(2*pi*21000000000.0*tt))
  let m_b_two02_im3l_c = 2*mean(xo*cos(2*pi*20800000000.0*tt))
  let m_b_two02_im3l_s = 2*mean(xo*sin(2*pi*20800000000.0*tt))
  let m_b_two02_im3h_c = 2*mean(xo*cos(2*pi*21100000000.0*tt))
  let m_b_two02_im3h_s = 2*mean(xo*sin(2*pi*21100000000.0*tt))
  let m_b_two02_fl_lo_c = 2*mean(xo*cos(2*pi*20750000000.0*tt))
  let m_b_two02_fl_lo_s = 2*mean(xo*sin(2*pi*20750000000.0*tt))
  let m_b_two02_fl_hi_c = 2*mean(xo*cos(2*pi*21150000000.0*tt))
  let m_b_two02_fl_hi_s = 2*mean(xo*sin(2*pi*21150000000.0*tt))
  let m_b_two02_vce_q1_max = maximum(v(xdut.c1)[40000,59999] - v(xdut.e1)[40000,59999])
  let m_b_two02_vce_q1_min = minimum(v(xdut.c1)[40000,59999] - v(xdut.e1)[40000,59999])
  let m_b_two02_vce_q2_max = maximum(v(xdut.oc)[40000,59999] - v(xdut.c1)[40000,59999])
  let m_b_two02_vce_q2_min = minimum(v(xdut.oc)[40000,59999] - v(xdut.c1)[40000,59999])
  let m_b_two02_vbe_q1_max = maximum(v(xdut.b1)[40000,59999] - v(xdut.e1)[40000,59999])
  let m_b_two02_vbe_q1_min = minimum(v(xdut.b1)[40000,59999] - v(xdut.e1)[40000,59999])
  let m_b_two02_vbe_q2_max = maximum(v(xdut.b2)[40000,59999] - v(xdut.c1)[40000,59999])
  let m_b_two02_vbe_q2_min = minimum(v(xdut.b2)[40000,59999] - v(xdut.c1)[40000,59999])
  let w_b_two02_ic_q1 = @q.xdut.xq1.qnpn13g2[ic][40000,59999]
  let m_b_two02_ic_q1_max = maximum(w_b_two02_ic_q1)
  let m_b_two02_ic_q1_min = minimum(w_b_two02_ic_q1)
  let w_b_two02_ic_q2 = @q.xdut.xq2.qnpn13g2[ic][40000,59999]
  let m_b_two02_ic_q2_max = maximum(w_b_two02_ic_q2)
  let m_b_two02_ic_q2_min = minimum(w_b_two02_ic_q2)
  print m_b_two02_n m_b_two02_t0 m_b_two02_t1 m_b_two02_f1_c m_b_two02_f1_s m_b_two02_f2_c
  print m_b_two02_f2_s m_b_two02_im3l_c m_b_two02_im3l_s m_b_two02_im3h_c m_b_two02_im3h_s m_b_two02_fl_lo_c
  print m_b_two02_fl_lo_s m_b_two02_fl_hi_c m_b_two02_fl_hi_s m_b_two02_vce_q1_max m_b_two02_vce_q1_min m_b_two02_vce_q2_max
  print m_b_two02_vce_q2_min m_b_two02_vbe_q1_max m_b_two02_vbe_q1_min m_b_two02_vbe_q2_max m_b_two02_vbe_q2_min m_b_two02_ic_q1_max
  print m_b_two02_ic_q1_min m_b_two02_ic_q2_max m_b_two02_ic_q2_min
  * run b_two03: two-tone, available power -53 dBm per tone
  alterparam fq1 = 20900000000.0
  alterparam fq2 = 21000000000.0
  alterparam va1 = 0.00141589156876828
  alterparam va2 = 0.00141589156876828
  reset
  save all @q.xdut.xq1.qnpn13g2[ic] @q.xdut.xq2.qnpn13g2[ic]
  tran 1e-12 6e-08 0 1e-12
  linearize v(p2) v(xdut.c1) v(xdut.e1) v(xdut.oc) v(xdut.b1) v(xdut.b2) @q.xdut.xq1.qnpn13g2[ic] @q.xdut.xq2.qnpn13g2[ic]
  let tt = time[40000,59999]
  let xo = v(p2)[40000,59999]
  let m_b_two03_n = length(xo)
  let m_b_two03_t0 = tt[0]
  let m_b_two03_t1 = tt[19999]
  let m_b_two03_f1_c = 2*mean(xo*cos(2*pi*20900000000.0*tt))
  let m_b_two03_f1_s = 2*mean(xo*sin(2*pi*20900000000.0*tt))
  let m_b_two03_f2_c = 2*mean(xo*cos(2*pi*21000000000.0*tt))
  let m_b_two03_f2_s = 2*mean(xo*sin(2*pi*21000000000.0*tt))
  let m_b_two03_im3l_c = 2*mean(xo*cos(2*pi*20800000000.0*tt))
  let m_b_two03_im3l_s = 2*mean(xo*sin(2*pi*20800000000.0*tt))
  let m_b_two03_im3h_c = 2*mean(xo*cos(2*pi*21100000000.0*tt))
  let m_b_two03_im3h_s = 2*mean(xo*sin(2*pi*21100000000.0*tt))
  let m_b_two03_fl_lo_c = 2*mean(xo*cos(2*pi*20750000000.0*tt))
  let m_b_two03_fl_lo_s = 2*mean(xo*sin(2*pi*20750000000.0*tt))
  let m_b_two03_fl_hi_c = 2*mean(xo*cos(2*pi*21150000000.0*tt))
  let m_b_two03_fl_hi_s = 2*mean(xo*sin(2*pi*21150000000.0*tt))
  let m_b_two03_vce_q1_max = maximum(v(xdut.c1)[40000,59999] - v(xdut.e1)[40000,59999])
  let m_b_two03_vce_q1_min = minimum(v(xdut.c1)[40000,59999] - v(xdut.e1)[40000,59999])
  let m_b_two03_vce_q2_max = maximum(v(xdut.oc)[40000,59999] - v(xdut.c1)[40000,59999])
  let m_b_two03_vce_q2_min = minimum(v(xdut.oc)[40000,59999] - v(xdut.c1)[40000,59999])
  let m_b_two03_vbe_q1_max = maximum(v(xdut.b1)[40000,59999] - v(xdut.e1)[40000,59999])
  let m_b_two03_vbe_q1_min = minimum(v(xdut.b1)[40000,59999] - v(xdut.e1)[40000,59999])
  let m_b_two03_vbe_q2_max = maximum(v(xdut.b2)[40000,59999] - v(xdut.c1)[40000,59999])
  let m_b_two03_vbe_q2_min = minimum(v(xdut.b2)[40000,59999] - v(xdut.c1)[40000,59999])
  let w_b_two03_ic_q1 = @q.xdut.xq1.qnpn13g2[ic][40000,59999]
  let m_b_two03_ic_q1_max = maximum(w_b_two03_ic_q1)
  let m_b_two03_ic_q1_min = minimum(w_b_two03_ic_q1)
  let w_b_two03_ic_q2 = @q.xdut.xq2.qnpn13g2[ic][40000,59999]
  let m_b_two03_ic_q2_max = maximum(w_b_two03_ic_q2)
  let m_b_two03_ic_q2_min = minimum(w_b_two03_ic_q2)
  print m_b_two03_n m_b_two03_t0 m_b_two03_t1 m_b_two03_f1_c m_b_two03_f1_s m_b_two03_f2_c
  print m_b_two03_f2_s m_b_two03_im3l_c m_b_two03_im3l_s m_b_two03_im3h_c m_b_two03_im3h_s m_b_two03_fl_lo_c
  print m_b_two03_fl_lo_s m_b_two03_fl_hi_c m_b_two03_fl_hi_s m_b_two03_vce_q1_max m_b_two03_vce_q1_min m_b_two03_vce_q2_max
  print m_b_two03_vce_q2_min m_b_two03_vbe_q1_max m_b_two03_vbe_q1_min m_b_two03_vbe_q2_max m_b_two03_vbe_q2_min m_b_two03_ic_q1_max
  print m_b_two03_ic_q1_min m_b_two03_ic_q2_max m_b_two03_ic_q2_min
  * run b_two04: two-tone, available power -52 dBm per tone
  alterparam fq1 = 20900000000.0
  alterparam fq2 = 21000000000.0
  alterparam va1 = 0.00158865646944856
  alterparam va2 = 0.00158865646944856
  reset
  save all @q.xdut.xq1.qnpn13g2[ic] @q.xdut.xq2.qnpn13g2[ic]
  tran 1e-12 6e-08 0 1e-12
  linearize v(p2) v(xdut.c1) v(xdut.e1) v(xdut.oc) v(xdut.b1) v(xdut.b2) @q.xdut.xq1.qnpn13g2[ic] @q.xdut.xq2.qnpn13g2[ic]
  let tt = time[40000,59999]
  let xo = v(p2)[40000,59999]
  let m_b_two04_n = length(xo)
  let m_b_two04_t0 = tt[0]
  let m_b_two04_t1 = tt[19999]
  let m_b_two04_f1_c = 2*mean(xo*cos(2*pi*20900000000.0*tt))
  let m_b_two04_f1_s = 2*mean(xo*sin(2*pi*20900000000.0*tt))
  let m_b_two04_f2_c = 2*mean(xo*cos(2*pi*21000000000.0*tt))
  let m_b_two04_f2_s = 2*mean(xo*sin(2*pi*21000000000.0*tt))
  let m_b_two04_im3l_c = 2*mean(xo*cos(2*pi*20800000000.0*tt))
  let m_b_two04_im3l_s = 2*mean(xo*sin(2*pi*20800000000.0*tt))
  let m_b_two04_im3h_c = 2*mean(xo*cos(2*pi*21100000000.0*tt))
  let m_b_two04_im3h_s = 2*mean(xo*sin(2*pi*21100000000.0*tt))
  let m_b_two04_fl_lo_c = 2*mean(xo*cos(2*pi*20750000000.0*tt))
  let m_b_two04_fl_lo_s = 2*mean(xo*sin(2*pi*20750000000.0*tt))
  let m_b_two04_fl_hi_c = 2*mean(xo*cos(2*pi*21150000000.0*tt))
  let m_b_two04_fl_hi_s = 2*mean(xo*sin(2*pi*21150000000.0*tt))
  let m_b_two04_vce_q1_max = maximum(v(xdut.c1)[40000,59999] - v(xdut.e1)[40000,59999])
  let m_b_two04_vce_q1_min = minimum(v(xdut.c1)[40000,59999] - v(xdut.e1)[40000,59999])
  let m_b_two04_vce_q2_max = maximum(v(xdut.oc)[40000,59999] - v(xdut.c1)[40000,59999])
  let m_b_two04_vce_q2_min = minimum(v(xdut.oc)[40000,59999] - v(xdut.c1)[40000,59999])
  let m_b_two04_vbe_q1_max = maximum(v(xdut.b1)[40000,59999] - v(xdut.e1)[40000,59999])
  let m_b_two04_vbe_q1_min = minimum(v(xdut.b1)[40000,59999] - v(xdut.e1)[40000,59999])
  let m_b_two04_vbe_q2_max = maximum(v(xdut.b2)[40000,59999] - v(xdut.c1)[40000,59999])
  let m_b_two04_vbe_q2_min = minimum(v(xdut.b2)[40000,59999] - v(xdut.c1)[40000,59999])
  let w_b_two04_ic_q1 = @q.xdut.xq1.qnpn13g2[ic][40000,59999]
  let m_b_two04_ic_q1_max = maximum(w_b_two04_ic_q1)
  let m_b_two04_ic_q1_min = minimum(w_b_two04_ic_q1)
  let w_b_two04_ic_q2 = @q.xdut.xq2.qnpn13g2[ic][40000,59999]
  let m_b_two04_ic_q2_max = maximum(w_b_two04_ic_q2)
  let m_b_two04_ic_q2_min = minimum(w_b_two04_ic_q2)
  print m_b_two04_n m_b_two04_t0 m_b_two04_t1 m_b_two04_f1_c m_b_two04_f1_s m_b_two04_f2_c
  print m_b_two04_f2_s m_b_two04_im3l_c m_b_two04_im3l_s m_b_two04_im3h_c m_b_two04_im3h_s m_b_two04_fl_lo_c
  print m_b_two04_fl_lo_s m_b_two04_fl_hi_c m_b_two04_fl_hi_s m_b_two04_vce_q1_max m_b_two04_vce_q1_min m_b_two04_vce_q2_max
  print m_b_two04_vce_q2_min m_b_two04_vbe_q1_max m_b_two04_vbe_q1_min m_b_two04_vbe_q2_max m_b_two04_vbe_q2_min m_b_two04_ic_q1_max
  print m_b_two04_ic_q1_min m_b_two04_ic_q2_max m_b_two04_ic_q2_min
  * run b_two05: two-tone, available power -51 dBm per tone
  alterparam fq1 = 20900000000.0
  alterparam fq2 = 21000000000.0
  alterparam va1 = 0.00178250187626749
  alterparam va2 = 0.00178250187626749
  reset
  save all @q.xdut.xq1.qnpn13g2[ic] @q.xdut.xq2.qnpn13g2[ic]
  tran 1e-12 6e-08 0 1e-12
  linearize v(p2) v(xdut.c1) v(xdut.e1) v(xdut.oc) v(xdut.b1) v(xdut.b2) @q.xdut.xq1.qnpn13g2[ic] @q.xdut.xq2.qnpn13g2[ic]
  let tt = time[40000,59999]
  let xo = v(p2)[40000,59999]
  let m_b_two05_n = length(xo)
  let m_b_two05_t0 = tt[0]
  let m_b_two05_t1 = tt[19999]
  let m_b_two05_f1_c = 2*mean(xo*cos(2*pi*20900000000.0*tt))
  let m_b_two05_f1_s = 2*mean(xo*sin(2*pi*20900000000.0*tt))
  let m_b_two05_f2_c = 2*mean(xo*cos(2*pi*21000000000.0*tt))
  let m_b_two05_f2_s = 2*mean(xo*sin(2*pi*21000000000.0*tt))
  let m_b_two05_im3l_c = 2*mean(xo*cos(2*pi*20800000000.0*tt))
  let m_b_two05_im3l_s = 2*mean(xo*sin(2*pi*20800000000.0*tt))
  let m_b_two05_im3h_c = 2*mean(xo*cos(2*pi*21100000000.0*tt))
  let m_b_two05_im3h_s = 2*mean(xo*sin(2*pi*21100000000.0*tt))
  let m_b_two05_fl_lo_c = 2*mean(xo*cos(2*pi*20750000000.0*tt))
  let m_b_two05_fl_lo_s = 2*mean(xo*sin(2*pi*20750000000.0*tt))
  let m_b_two05_fl_hi_c = 2*mean(xo*cos(2*pi*21150000000.0*tt))
  let m_b_two05_fl_hi_s = 2*mean(xo*sin(2*pi*21150000000.0*tt))
  let m_b_two05_vce_q1_max = maximum(v(xdut.c1)[40000,59999] - v(xdut.e1)[40000,59999])
  let m_b_two05_vce_q1_min = minimum(v(xdut.c1)[40000,59999] - v(xdut.e1)[40000,59999])
  let m_b_two05_vce_q2_max = maximum(v(xdut.oc)[40000,59999] - v(xdut.c1)[40000,59999])
  let m_b_two05_vce_q2_min = minimum(v(xdut.oc)[40000,59999] - v(xdut.c1)[40000,59999])
  let m_b_two05_vbe_q1_max = maximum(v(xdut.b1)[40000,59999] - v(xdut.e1)[40000,59999])
  let m_b_two05_vbe_q1_min = minimum(v(xdut.b1)[40000,59999] - v(xdut.e1)[40000,59999])
  let m_b_two05_vbe_q2_max = maximum(v(xdut.b2)[40000,59999] - v(xdut.c1)[40000,59999])
  let m_b_two05_vbe_q2_min = minimum(v(xdut.b2)[40000,59999] - v(xdut.c1)[40000,59999])
  let w_b_two05_ic_q1 = @q.xdut.xq1.qnpn13g2[ic][40000,59999]
  let m_b_two05_ic_q1_max = maximum(w_b_two05_ic_q1)
  let m_b_two05_ic_q1_min = minimum(w_b_two05_ic_q1)
  let w_b_two05_ic_q2 = @q.xdut.xq2.qnpn13g2[ic][40000,59999]
  let m_b_two05_ic_q2_max = maximum(w_b_two05_ic_q2)
  let m_b_two05_ic_q2_min = minimum(w_b_two05_ic_q2)
  print m_b_two05_n m_b_two05_t0 m_b_two05_t1 m_b_two05_f1_c m_b_two05_f1_s m_b_two05_f2_c
  print m_b_two05_f2_s m_b_two05_im3l_c m_b_two05_im3l_s m_b_two05_im3h_c m_b_two05_im3h_s m_b_two05_fl_lo_c
  print m_b_two05_fl_lo_s m_b_two05_fl_hi_c m_b_two05_fl_hi_s m_b_two05_vce_q1_max m_b_two05_vce_q1_min m_b_two05_vce_q2_max
  print m_b_two05_vce_q2_min m_b_two05_vbe_q1_max m_b_two05_vbe_q1_min m_b_two05_vbe_q2_max m_b_two05_vbe_q2_min m_b_two05_ic_q1_max
  print m_b_two05_ic_q1_min m_b_two05_ic_q2_max m_b_two05_ic_q2_min
  * run b_two06: two-tone, available power -50 dBm per tone
  alterparam fq1 = 20900000000.0
  alterparam fq2 = 21000000000.0
  alterparam va1 = 0.002
  alterparam va2 = 0.002
  reset
  save all @q.xdut.xq1.qnpn13g2[ic] @q.xdut.xq2.qnpn13g2[ic]
  tran 1e-12 6e-08 0 1e-12
  linearize v(p2) v(xdut.c1) v(xdut.e1) v(xdut.oc) v(xdut.b1) v(xdut.b2) @q.xdut.xq1.qnpn13g2[ic] @q.xdut.xq2.qnpn13g2[ic]
  let tt = time[40000,59999]
  let xo = v(p2)[40000,59999]
  let m_b_two06_n = length(xo)
  let m_b_two06_t0 = tt[0]
  let m_b_two06_t1 = tt[19999]
  let m_b_two06_f1_c = 2*mean(xo*cos(2*pi*20900000000.0*tt))
  let m_b_two06_f1_s = 2*mean(xo*sin(2*pi*20900000000.0*tt))
  let m_b_two06_f2_c = 2*mean(xo*cos(2*pi*21000000000.0*tt))
  let m_b_two06_f2_s = 2*mean(xo*sin(2*pi*21000000000.0*tt))
  let m_b_two06_im3l_c = 2*mean(xo*cos(2*pi*20800000000.0*tt))
  let m_b_two06_im3l_s = 2*mean(xo*sin(2*pi*20800000000.0*tt))
  let m_b_two06_im3h_c = 2*mean(xo*cos(2*pi*21100000000.0*tt))
  let m_b_two06_im3h_s = 2*mean(xo*sin(2*pi*21100000000.0*tt))
  let m_b_two06_fl_lo_c = 2*mean(xo*cos(2*pi*20750000000.0*tt))
  let m_b_two06_fl_lo_s = 2*mean(xo*sin(2*pi*20750000000.0*tt))
  let m_b_two06_fl_hi_c = 2*mean(xo*cos(2*pi*21150000000.0*tt))
  let m_b_two06_fl_hi_s = 2*mean(xo*sin(2*pi*21150000000.0*tt))
  let m_b_two06_vce_q1_max = maximum(v(xdut.c1)[40000,59999] - v(xdut.e1)[40000,59999])
  let m_b_two06_vce_q1_min = minimum(v(xdut.c1)[40000,59999] - v(xdut.e1)[40000,59999])
  let m_b_two06_vce_q2_max = maximum(v(xdut.oc)[40000,59999] - v(xdut.c1)[40000,59999])
  let m_b_two06_vce_q2_min = minimum(v(xdut.oc)[40000,59999] - v(xdut.c1)[40000,59999])
  let m_b_two06_vbe_q1_max = maximum(v(xdut.b1)[40000,59999] - v(xdut.e1)[40000,59999])
  let m_b_two06_vbe_q1_min = minimum(v(xdut.b1)[40000,59999] - v(xdut.e1)[40000,59999])
  let m_b_two06_vbe_q2_max = maximum(v(xdut.b2)[40000,59999] - v(xdut.c1)[40000,59999])
  let m_b_two06_vbe_q2_min = minimum(v(xdut.b2)[40000,59999] - v(xdut.c1)[40000,59999])
  let w_b_two06_ic_q1 = @q.xdut.xq1.qnpn13g2[ic][40000,59999]
  let m_b_two06_ic_q1_max = maximum(w_b_two06_ic_q1)
  let m_b_two06_ic_q1_min = minimum(w_b_two06_ic_q1)
  let w_b_two06_ic_q2 = @q.xdut.xq2.qnpn13g2[ic][40000,59999]
  let m_b_two06_ic_q2_max = maximum(w_b_two06_ic_q2)
  let m_b_two06_ic_q2_min = minimum(w_b_two06_ic_q2)
  print m_b_two06_n m_b_two06_t0 m_b_two06_t1 m_b_two06_f1_c m_b_two06_f1_s m_b_two06_f2_c
  print m_b_two06_f2_s m_b_two06_im3l_c m_b_two06_im3l_s m_b_two06_im3h_c m_b_two06_im3h_s m_b_two06_fl_lo_c
  print m_b_two06_fl_lo_s m_b_two06_fl_hi_c m_b_two06_fl_hi_s m_b_two06_vce_q1_max m_b_two06_vce_q1_min m_b_two06_vce_q2_max
  print m_b_two06_vce_q2_min m_b_two06_vbe_q1_max m_b_two06_vbe_q1_min m_b_two06_vbe_q2_max m_b_two06_vbe_q2_min m_b_two06_ic_q1_max
  print m_b_two06_ic_q1_min m_b_two06_ic_q2_max m_b_two06_ic_q2_min
  * run b_two07: two-tone, available power -49 dBm per tone
  alterparam fq1 = 20900000000.0
  alterparam fq2 = 21000000000.0
  alterparam va1 = 0.00224403690860393
  alterparam va2 = 0.00224403690860393
  reset
  save all @q.xdut.xq1.qnpn13g2[ic] @q.xdut.xq2.qnpn13g2[ic]
  tran 1e-12 6e-08 0 1e-12
  linearize v(p2) v(xdut.c1) v(xdut.e1) v(xdut.oc) v(xdut.b1) v(xdut.b2) @q.xdut.xq1.qnpn13g2[ic] @q.xdut.xq2.qnpn13g2[ic]
  let tt = time[40000,59999]
  let xo = v(p2)[40000,59999]
  let m_b_two07_n = length(xo)
  let m_b_two07_t0 = tt[0]
  let m_b_two07_t1 = tt[19999]
  let m_b_two07_f1_c = 2*mean(xo*cos(2*pi*20900000000.0*tt))
  let m_b_two07_f1_s = 2*mean(xo*sin(2*pi*20900000000.0*tt))
  let m_b_two07_f2_c = 2*mean(xo*cos(2*pi*21000000000.0*tt))
  let m_b_two07_f2_s = 2*mean(xo*sin(2*pi*21000000000.0*tt))
  let m_b_two07_im3l_c = 2*mean(xo*cos(2*pi*20800000000.0*tt))
  let m_b_two07_im3l_s = 2*mean(xo*sin(2*pi*20800000000.0*tt))
  let m_b_two07_im3h_c = 2*mean(xo*cos(2*pi*21100000000.0*tt))
  let m_b_two07_im3h_s = 2*mean(xo*sin(2*pi*21100000000.0*tt))
  let m_b_two07_fl_lo_c = 2*mean(xo*cos(2*pi*20750000000.0*tt))
  let m_b_two07_fl_lo_s = 2*mean(xo*sin(2*pi*20750000000.0*tt))
  let m_b_two07_fl_hi_c = 2*mean(xo*cos(2*pi*21150000000.0*tt))
  let m_b_two07_fl_hi_s = 2*mean(xo*sin(2*pi*21150000000.0*tt))
  let m_b_two07_vce_q1_max = maximum(v(xdut.c1)[40000,59999] - v(xdut.e1)[40000,59999])
  let m_b_two07_vce_q1_min = minimum(v(xdut.c1)[40000,59999] - v(xdut.e1)[40000,59999])
  let m_b_two07_vce_q2_max = maximum(v(xdut.oc)[40000,59999] - v(xdut.c1)[40000,59999])
  let m_b_two07_vce_q2_min = minimum(v(xdut.oc)[40000,59999] - v(xdut.c1)[40000,59999])
  let m_b_two07_vbe_q1_max = maximum(v(xdut.b1)[40000,59999] - v(xdut.e1)[40000,59999])
  let m_b_two07_vbe_q1_min = minimum(v(xdut.b1)[40000,59999] - v(xdut.e1)[40000,59999])
  let m_b_two07_vbe_q2_max = maximum(v(xdut.b2)[40000,59999] - v(xdut.c1)[40000,59999])
  let m_b_two07_vbe_q2_min = minimum(v(xdut.b2)[40000,59999] - v(xdut.c1)[40000,59999])
  let w_b_two07_ic_q1 = @q.xdut.xq1.qnpn13g2[ic][40000,59999]
  let m_b_two07_ic_q1_max = maximum(w_b_two07_ic_q1)
  let m_b_two07_ic_q1_min = minimum(w_b_two07_ic_q1)
  let w_b_two07_ic_q2 = @q.xdut.xq2.qnpn13g2[ic][40000,59999]
  let m_b_two07_ic_q2_max = maximum(w_b_two07_ic_q2)
  let m_b_two07_ic_q2_min = minimum(w_b_two07_ic_q2)
  print m_b_two07_n m_b_two07_t0 m_b_two07_t1 m_b_two07_f1_c m_b_two07_f1_s m_b_two07_f2_c
  print m_b_two07_f2_s m_b_two07_im3l_c m_b_two07_im3l_s m_b_two07_im3h_c m_b_two07_im3h_s m_b_two07_fl_lo_c
  print m_b_two07_fl_lo_s m_b_two07_fl_hi_c m_b_two07_fl_hi_s m_b_two07_vce_q1_max m_b_two07_vce_q1_min m_b_two07_vce_q2_max
  print m_b_two07_vce_q2_min m_b_two07_vbe_q1_max m_b_two07_vbe_q1_min m_b_two07_vbe_q2_max m_b_two07_vbe_q2_min m_b_two07_ic_q1_max
  print m_b_two07_ic_q1_min m_b_two07_ic_q2_max m_b_two07_ic_q2_min
  * run b_two08: two-tone, available power -48 dBm per tone
  alterparam fq1 = 20900000000.0
  alterparam fq2 = 21000000000.0
  alterparam va1 = 0.00251785082358833
  alterparam va2 = 0.00251785082358833
  reset
  save all @q.xdut.xq1.qnpn13g2[ic] @q.xdut.xq2.qnpn13g2[ic]
  tran 1e-12 6e-08 0 1e-12
  linearize v(p2) v(xdut.c1) v(xdut.e1) v(xdut.oc) v(xdut.b1) v(xdut.b2) @q.xdut.xq1.qnpn13g2[ic] @q.xdut.xq2.qnpn13g2[ic]
  let tt = time[40000,59999]
  let xo = v(p2)[40000,59999]
  let m_b_two08_n = length(xo)
  let m_b_two08_t0 = tt[0]
  let m_b_two08_t1 = tt[19999]
  let m_b_two08_f1_c = 2*mean(xo*cos(2*pi*20900000000.0*tt))
  let m_b_two08_f1_s = 2*mean(xo*sin(2*pi*20900000000.0*tt))
  let m_b_two08_f2_c = 2*mean(xo*cos(2*pi*21000000000.0*tt))
  let m_b_two08_f2_s = 2*mean(xo*sin(2*pi*21000000000.0*tt))
  let m_b_two08_im3l_c = 2*mean(xo*cos(2*pi*20800000000.0*tt))
  let m_b_two08_im3l_s = 2*mean(xo*sin(2*pi*20800000000.0*tt))
  let m_b_two08_im3h_c = 2*mean(xo*cos(2*pi*21100000000.0*tt))
  let m_b_two08_im3h_s = 2*mean(xo*sin(2*pi*21100000000.0*tt))
  let m_b_two08_fl_lo_c = 2*mean(xo*cos(2*pi*20750000000.0*tt))
  let m_b_two08_fl_lo_s = 2*mean(xo*sin(2*pi*20750000000.0*tt))
  let m_b_two08_fl_hi_c = 2*mean(xo*cos(2*pi*21150000000.0*tt))
  let m_b_two08_fl_hi_s = 2*mean(xo*sin(2*pi*21150000000.0*tt))
  let m_b_two08_vce_q1_max = maximum(v(xdut.c1)[40000,59999] - v(xdut.e1)[40000,59999])
  let m_b_two08_vce_q1_min = minimum(v(xdut.c1)[40000,59999] - v(xdut.e1)[40000,59999])
  let m_b_two08_vce_q2_max = maximum(v(xdut.oc)[40000,59999] - v(xdut.c1)[40000,59999])
  let m_b_two08_vce_q2_min = minimum(v(xdut.oc)[40000,59999] - v(xdut.c1)[40000,59999])
  let m_b_two08_vbe_q1_max = maximum(v(xdut.b1)[40000,59999] - v(xdut.e1)[40000,59999])
  let m_b_two08_vbe_q1_min = minimum(v(xdut.b1)[40000,59999] - v(xdut.e1)[40000,59999])
  let m_b_two08_vbe_q2_max = maximum(v(xdut.b2)[40000,59999] - v(xdut.c1)[40000,59999])
  let m_b_two08_vbe_q2_min = minimum(v(xdut.b2)[40000,59999] - v(xdut.c1)[40000,59999])
  let w_b_two08_ic_q1 = @q.xdut.xq1.qnpn13g2[ic][40000,59999]
  let m_b_two08_ic_q1_max = maximum(w_b_two08_ic_q1)
  let m_b_two08_ic_q1_min = minimum(w_b_two08_ic_q1)
  let w_b_two08_ic_q2 = @q.xdut.xq2.qnpn13g2[ic][40000,59999]
  let m_b_two08_ic_q2_max = maximum(w_b_two08_ic_q2)
  let m_b_two08_ic_q2_min = minimum(w_b_two08_ic_q2)
  print m_b_two08_n m_b_two08_t0 m_b_two08_t1 m_b_two08_f1_c m_b_two08_f1_s m_b_two08_f2_c
  print m_b_two08_f2_s m_b_two08_im3l_c m_b_two08_im3l_s m_b_two08_im3h_c m_b_two08_im3h_s m_b_two08_fl_lo_c
  print m_b_two08_fl_lo_s m_b_two08_fl_hi_c m_b_two08_fl_hi_s m_b_two08_vce_q1_max m_b_two08_vce_q1_min m_b_two08_vce_q2_max
  print m_b_two08_vce_q2_min m_b_two08_vbe_q1_max m_b_two08_vbe_q1_min m_b_two08_vbe_q2_max m_b_two08_vbe_q2_min m_b_two08_ic_q1_max
  print m_b_two08_ic_q1_min m_b_two08_ic_q2_max m_b_two08_ic_q2_min
  * run b_two09: two-tone, available power -47 dBm per tone
  alterparam fq1 = 20900000000.0
  alterparam fq2 = 21000000000.0
  alterparam va1 = 0.00282507508924551
  alterparam va2 = 0.00282507508924551
  reset
  save all @q.xdut.xq1.qnpn13g2[ic] @q.xdut.xq2.qnpn13g2[ic]
  tran 1e-12 6e-08 0 1e-12
  linearize v(p2) v(xdut.c1) v(xdut.e1) v(xdut.oc) v(xdut.b1) v(xdut.b2) @q.xdut.xq1.qnpn13g2[ic] @q.xdut.xq2.qnpn13g2[ic]
  let tt = time[40000,59999]
  let xo = v(p2)[40000,59999]
  let m_b_two09_n = length(xo)
  let m_b_two09_t0 = tt[0]
  let m_b_two09_t1 = tt[19999]
  let m_b_two09_f1_c = 2*mean(xo*cos(2*pi*20900000000.0*tt))
  let m_b_two09_f1_s = 2*mean(xo*sin(2*pi*20900000000.0*tt))
  let m_b_two09_f2_c = 2*mean(xo*cos(2*pi*21000000000.0*tt))
  let m_b_two09_f2_s = 2*mean(xo*sin(2*pi*21000000000.0*tt))
  let m_b_two09_im3l_c = 2*mean(xo*cos(2*pi*20800000000.0*tt))
  let m_b_two09_im3l_s = 2*mean(xo*sin(2*pi*20800000000.0*tt))
  let m_b_two09_im3h_c = 2*mean(xo*cos(2*pi*21100000000.0*tt))
  let m_b_two09_im3h_s = 2*mean(xo*sin(2*pi*21100000000.0*tt))
  let m_b_two09_fl_lo_c = 2*mean(xo*cos(2*pi*20750000000.0*tt))
  let m_b_two09_fl_lo_s = 2*mean(xo*sin(2*pi*20750000000.0*tt))
  let m_b_two09_fl_hi_c = 2*mean(xo*cos(2*pi*21150000000.0*tt))
  let m_b_two09_fl_hi_s = 2*mean(xo*sin(2*pi*21150000000.0*tt))
  let m_b_two09_vce_q1_max = maximum(v(xdut.c1)[40000,59999] - v(xdut.e1)[40000,59999])
  let m_b_two09_vce_q1_min = minimum(v(xdut.c1)[40000,59999] - v(xdut.e1)[40000,59999])
  let m_b_two09_vce_q2_max = maximum(v(xdut.oc)[40000,59999] - v(xdut.c1)[40000,59999])
  let m_b_two09_vce_q2_min = minimum(v(xdut.oc)[40000,59999] - v(xdut.c1)[40000,59999])
  let m_b_two09_vbe_q1_max = maximum(v(xdut.b1)[40000,59999] - v(xdut.e1)[40000,59999])
  let m_b_two09_vbe_q1_min = minimum(v(xdut.b1)[40000,59999] - v(xdut.e1)[40000,59999])
  let m_b_two09_vbe_q2_max = maximum(v(xdut.b2)[40000,59999] - v(xdut.c1)[40000,59999])
  let m_b_two09_vbe_q2_min = minimum(v(xdut.b2)[40000,59999] - v(xdut.c1)[40000,59999])
  let w_b_two09_ic_q1 = @q.xdut.xq1.qnpn13g2[ic][40000,59999]
  let m_b_two09_ic_q1_max = maximum(w_b_two09_ic_q1)
  let m_b_two09_ic_q1_min = minimum(w_b_two09_ic_q1)
  let w_b_two09_ic_q2 = @q.xdut.xq2.qnpn13g2[ic][40000,59999]
  let m_b_two09_ic_q2_max = maximum(w_b_two09_ic_q2)
  let m_b_two09_ic_q2_min = minimum(w_b_two09_ic_q2)
  print m_b_two09_n m_b_two09_t0 m_b_two09_t1 m_b_two09_f1_c m_b_two09_f1_s m_b_two09_f2_c
  print m_b_two09_f2_s m_b_two09_im3l_c m_b_two09_im3l_s m_b_two09_im3h_c m_b_two09_im3h_s m_b_two09_fl_lo_c
  print m_b_two09_fl_lo_s m_b_two09_fl_hi_c m_b_two09_fl_hi_s m_b_two09_vce_q1_max m_b_two09_vce_q1_min m_b_two09_vce_q2_max
  print m_b_two09_vce_q2_min m_b_two09_vbe_q1_max m_b_two09_vbe_q1_min m_b_two09_vbe_q2_max m_b_two09_vbe_q2_min m_b_two09_ic_q1_max
  print m_b_two09_ic_q1_min m_b_two09_ic_q2_max m_b_two09_ic_q2_min
  * run b_two10: two-tone, available power -46 dBm per tone
  alterparam fq1 = 20900000000.0
  alterparam fq2 = 21000000000.0
  alterparam va1 = 0.00316978638492223
  alterparam va2 = 0.00316978638492223
  reset
  save all @q.xdut.xq1.qnpn13g2[ic] @q.xdut.xq2.qnpn13g2[ic]
  tran 1e-12 6e-08 0 1e-12
  linearize v(p2) v(xdut.c1) v(xdut.e1) v(xdut.oc) v(xdut.b1) v(xdut.b2) @q.xdut.xq1.qnpn13g2[ic] @q.xdut.xq2.qnpn13g2[ic]
  let tt = time[40000,59999]
  let xo = v(p2)[40000,59999]
  let m_b_two10_n = length(xo)
  let m_b_two10_t0 = tt[0]
  let m_b_two10_t1 = tt[19999]
  let m_b_two10_f1_c = 2*mean(xo*cos(2*pi*20900000000.0*tt))
  let m_b_two10_f1_s = 2*mean(xo*sin(2*pi*20900000000.0*tt))
  let m_b_two10_f2_c = 2*mean(xo*cos(2*pi*21000000000.0*tt))
  let m_b_two10_f2_s = 2*mean(xo*sin(2*pi*21000000000.0*tt))
  let m_b_two10_im3l_c = 2*mean(xo*cos(2*pi*20800000000.0*tt))
  let m_b_two10_im3l_s = 2*mean(xo*sin(2*pi*20800000000.0*tt))
  let m_b_two10_im3h_c = 2*mean(xo*cos(2*pi*21100000000.0*tt))
  let m_b_two10_im3h_s = 2*mean(xo*sin(2*pi*21100000000.0*tt))
  let m_b_two10_fl_lo_c = 2*mean(xo*cos(2*pi*20750000000.0*tt))
  let m_b_two10_fl_lo_s = 2*mean(xo*sin(2*pi*20750000000.0*tt))
  let m_b_two10_fl_hi_c = 2*mean(xo*cos(2*pi*21150000000.0*tt))
  let m_b_two10_fl_hi_s = 2*mean(xo*sin(2*pi*21150000000.0*tt))
  let m_b_two10_vce_q1_max = maximum(v(xdut.c1)[40000,59999] - v(xdut.e1)[40000,59999])
  let m_b_two10_vce_q1_min = minimum(v(xdut.c1)[40000,59999] - v(xdut.e1)[40000,59999])
  let m_b_two10_vce_q2_max = maximum(v(xdut.oc)[40000,59999] - v(xdut.c1)[40000,59999])
  let m_b_two10_vce_q2_min = minimum(v(xdut.oc)[40000,59999] - v(xdut.c1)[40000,59999])
  let m_b_two10_vbe_q1_max = maximum(v(xdut.b1)[40000,59999] - v(xdut.e1)[40000,59999])
  let m_b_two10_vbe_q1_min = minimum(v(xdut.b1)[40000,59999] - v(xdut.e1)[40000,59999])
  let m_b_two10_vbe_q2_max = maximum(v(xdut.b2)[40000,59999] - v(xdut.c1)[40000,59999])
  let m_b_two10_vbe_q2_min = minimum(v(xdut.b2)[40000,59999] - v(xdut.c1)[40000,59999])
  let w_b_two10_ic_q1 = @q.xdut.xq1.qnpn13g2[ic][40000,59999]
  let m_b_two10_ic_q1_max = maximum(w_b_two10_ic_q1)
  let m_b_two10_ic_q1_min = minimum(w_b_two10_ic_q1)
  let w_b_two10_ic_q2 = @q.xdut.xq2.qnpn13g2[ic][40000,59999]
  let m_b_two10_ic_q2_max = maximum(w_b_two10_ic_q2)
  let m_b_two10_ic_q2_min = minimum(w_b_two10_ic_q2)
  print m_b_two10_n m_b_two10_t0 m_b_two10_t1 m_b_two10_f1_c m_b_two10_f1_s m_b_two10_f2_c
  print m_b_two10_f2_s m_b_two10_im3l_c m_b_two10_im3l_s m_b_two10_im3h_c m_b_two10_im3h_s m_b_two10_fl_lo_c
  print m_b_two10_fl_lo_s m_b_two10_fl_hi_c m_b_two10_fl_hi_s m_b_two10_vce_q1_max m_b_two10_vce_q1_min m_b_two10_vce_q2_max
  print m_b_two10_vce_q2_min m_b_two10_vbe_q1_max m_b_two10_vbe_q1_min m_b_two10_vbe_q2_max m_b_two10_vbe_q2_min m_b_two10_ic_q1_max
  print m_b_two10_ic_q1_min m_b_two10_ic_q2_max m_b_two10_ic_q2_min
  * run b_two11: two-tone, available power -45 dBm per tone
  alterparam fq1 = 20900000000.0
  alterparam fq2 = 21000000000.0
  alterparam va1 = 0.00355655882007785
  alterparam va2 = 0.00355655882007785
  reset
  save all @q.xdut.xq1.qnpn13g2[ic] @q.xdut.xq2.qnpn13g2[ic]
  tran 1e-12 6e-08 0 1e-12
  linearize v(p2) v(xdut.c1) v(xdut.e1) v(xdut.oc) v(xdut.b1) v(xdut.b2) @q.xdut.xq1.qnpn13g2[ic] @q.xdut.xq2.qnpn13g2[ic]
  let tt = time[40000,59999]
  let xo = v(p2)[40000,59999]
  let m_b_two11_n = length(xo)
  let m_b_two11_t0 = tt[0]
  let m_b_two11_t1 = tt[19999]
  let m_b_two11_f1_c = 2*mean(xo*cos(2*pi*20900000000.0*tt))
  let m_b_two11_f1_s = 2*mean(xo*sin(2*pi*20900000000.0*tt))
  let m_b_two11_f2_c = 2*mean(xo*cos(2*pi*21000000000.0*tt))
  let m_b_two11_f2_s = 2*mean(xo*sin(2*pi*21000000000.0*tt))
  let m_b_two11_im3l_c = 2*mean(xo*cos(2*pi*20800000000.0*tt))
  let m_b_two11_im3l_s = 2*mean(xo*sin(2*pi*20800000000.0*tt))
  let m_b_two11_im3h_c = 2*mean(xo*cos(2*pi*21100000000.0*tt))
  let m_b_two11_im3h_s = 2*mean(xo*sin(2*pi*21100000000.0*tt))
  let m_b_two11_fl_lo_c = 2*mean(xo*cos(2*pi*20750000000.0*tt))
  let m_b_two11_fl_lo_s = 2*mean(xo*sin(2*pi*20750000000.0*tt))
  let m_b_two11_fl_hi_c = 2*mean(xo*cos(2*pi*21150000000.0*tt))
  let m_b_two11_fl_hi_s = 2*mean(xo*sin(2*pi*21150000000.0*tt))
  let m_b_two11_vce_q1_max = maximum(v(xdut.c1)[40000,59999] - v(xdut.e1)[40000,59999])
  let m_b_two11_vce_q1_min = minimum(v(xdut.c1)[40000,59999] - v(xdut.e1)[40000,59999])
  let m_b_two11_vce_q2_max = maximum(v(xdut.oc)[40000,59999] - v(xdut.c1)[40000,59999])
  let m_b_two11_vce_q2_min = minimum(v(xdut.oc)[40000,59999] - v(xdut.c1)[40000,59999])
  let m_b_two11_vbe_q1_max = maximum(v(xdut.b1)[40000,59999] - v(xdut.e1)[40000,59999])
  let m_b_two11_vbe_q1_min = minimum(v(xdut.b1)[40000,59999] - v(xdut.e1)[40000,59999])
  let m_b_two11_vbe_q2_max = maximum(v(xdut.b2)[40000,59999] - v(xdut.c1)[40000,59999])
  let m_b_two11_vbe_q2_min = minimum(v(xdut.b2)[40000,59999] - v(xdut.c1)[40000,59999])
  let w_b_two11_ic_q1 = @q.xdut.xq1.qnpn13g2[ic][40000,59999]
  let m_b_two11_ic_q1_max = maximum(w_b_two11_ic_q1)
  let m_b_two11_ic_q1_min = minimum(w_b_two11_ic_q1)
  let w_b_two11_ic_q2 = @q.xdut.xq2.qnpn13g2[ic][40000,59999]
  let m_b_two11_ic_q2_max = maximum(w_b_two11_ic_q2)
  let m_b_two11_ic_q2_min = minimum(w_b_two11_ic_q2)
  print m_b_two11_n m_b_two11_t0 m_b_two11_t1 m_b_two11_f1_c m_b_two11_f1_s m_b_two11_f2_c
  print m_b_two11_f2_s m_b_two11_im3l_c m_b_two11_im3l_s m_b_two11_im3h_c m_b_two11_im3h_s m_b_two11_fl_lo_c
  print m_b_two11_fl_lo_s m_b_two11_fl_hi_c m_b_two11_fl_hi_s m_b_two11_vce_q1_max m_b_two11_vce_q1_min m_b_two11_vce_q2_max
  print m_b_two11_vce_q2_min m_b_two11_vbe_q1_max m_b_two11_vbe_q1_min m_b_two11_vbe_q2_max m_b_two11_vbe_q2_min m_b_two11_ic_q1_max
  print m_b_two11_ic_q1_min m_b_two11_ic_q2_max m_b_two11_ic_q2_min
  * run b_two12: two-tone, available power -44 dBm per tone
  alterparam fq1 = 20900000000.0
  alterparam fq2 = 21000000000.0
  alterparam va1 = 0.00399052462993776
  alterparam va2 = 0.00399052462993776
  reset
  save all @q.xdut.xq1.qnpn13g2[ic] @q.xdut.xq2.qnpn13g2[ic]
  tran 1e-12 6e-08 0 1e-12
  linearize v(p2) v(xdut.c1) v(xdut.e1) v(xdut.oc) v(xdut.b1) v(xdut.b2) @q.xdut.xq1.qnpn13g2[ic] @q.xdut.xq2.qnpn13g2[ic]
  let tt = time[40000,59999]
  let xo = v(p2)[40000,59999]
  let m_b_two12_n = length(xo)
  let m_b_two12_t0 = tt[0]
  let m_b_two12_t1 = tt[19999]
  let m_b_two12_f1_c = 2*mean(xo*cos(2*pi*20900000000.0*tt))
  let m_b_two12_f1_s = 2*mean(xo*sin(2*pi*20900000000.0*tt))
  let m_b_two12_f2_c = 2*mean(xo*cos(2*pi*21000000000.0*tt))
  let m_b_two12_f2_s = 2*mean(xo*sin(2*pi*21000000000.0*tt))
  let m_b_two12_im3l_c = 2*mean(xo*cos(2*pi*20800000000.0*tt))
  let m_b_two12_im3l_s = 2*mean(xo*sin(2*pi*20800000000.0*tt))
  let m_b_two12_im3h_c = 2*mean(xo*cos(2*pi*21100000000.0*tt))
  let m_b_two12_im3h_s = 2*mean(xo*sin(2*pi*21100000000.0*tt))
  let m_b_two12_fl_lo_c = 2*mean(xo*cos(2*pi*20750000000.0*tt))
  let m_b_two12_fl_lo_s = 2*mean(xo*sin(2*pi*20750000000.0*tt))
  let m_b_two12_fl_hi_c = 2*mean(xo*cos(2*pi*21150000000.0*tt))
  let m_b_two12_fl_hi_s = 2*mean(xo*sin(2*pi*21150000000.0*tt))
  let m_b_two12_vce_q1_max = maximum(v(xdut.c1)[40000,59999] - v(xdut.e1)[40000,59999])
  let m_b_two12_vce_q1_min = minimum(v(xdut.c1)[40000,59999] - v(xdut.e1)[40000,59999])
  let m_b_two12_vce_q2_max = maximum(v(xdut.oc)[40000,59999] - v(xdut.c1)[40000,59999])
  let m_b_two12_vce_q2_min = minimum(v(xdut.oc)[40000,59999] - v(xdut.c1)[40000,59999])
  let m_b_two12_vbe_q1_max = maximum(v(xdut.b1)[40000,59999] - v(xdut.e1)[40000,59999])
  let m_b_two12_vbe_q1_min = minimum(v(xdut.b1)[40000,59999] - v(xdut.e1)[40000,59999])
  let m_b_two12_vbe_q2_max = maximum(v(xdut.b2)[40000,59999] - v(xdut.c1)[40000,59999])
  let m_b_two12_vbe_q2_min = minimum(v(xdut.b2)[40000,59999] - v(xdut.c1)[40000,59999])
  let w_b_two12_ic_q1 = @q.xdut.xq1.qnpn13g2[ic][40000,59999]
  let m_b_two12_ic_q1_max = maximum(w_b_two12_ic_q1)
  let m_b_two12_ic_q1_min = minimum(w_b_two12_ic_q1)
  let w_b_two12_ic_q2 = @q.xdut.xq2.qnpn13g2[ic][40000,59999]
  let m_b_two12_ic_q2_max = maximum(w_b_two12_ic_q2)
  let m_b_two12_ic_q2_min = minimum(w_b_two12_ic_q2)
  print m_b_two12_n m_b_two12_t0 m_b_two12_t1 m_b_two12_f1_c m_b_two12_f1_s m_b_two12_f2_c
  print m_b_two12_f2_s m_b_two12_im3l_c m_b_two12_im3l_s m_b_two12_im3h_c m_b_two12_im3h_s m_b_two12_fl_lo_c
  print m_b_two12_fl_lo_s m_b_two12_fl_hi_c m_b_two12_fl_hi_s m_b_two12_vce_q1_max m_b_two12_vce_q1_min m_b_two12_vce_q2_max
  print m_b_two12_vce_q2_min m_b_two12_vbe_q1_max m_b_two12_vbe_q1_min m_b_two12_vbe_q2_max m_b_two12_vbe_q2_min m_b_two12_ic_q1_max
  print m_b_two12_ic_q1_min m_b_two12_ic_q2_max m_b_two12_ic_q2_min
  * run b_two13: two-tone, available power -43 dBm per tone
  alterparam fq1 = 20900000000.0
  alterparam fq2 = 21000000000.0
  alterparam va1 = 0.00447744227713668
  alterparam va2 = 0.00447744227713668
  reset
  save all @q.xdut.xq1.qnpn13g2[ic] @q.xdut.xq2.qnpn13g2[ic]
  tran 1e-12 6e-08 0 1e-12
  linearize v(p2) v(xdut.c1) v(xdut.e1) v(xdut.oc) v(xdut.b1) v(xdut.b2) @q.xdut.xq1.qnpn13g2[ic] @q.xdut.xq2.qnpn13g2[ic]
  let tt = time[40000,59999]
  let xo = v(p2)[40000,59999]
  let m_b_two13_n = length(xo)
  let m_b_two13_t0 = tt[0]
  let m_b_two13_t1 = tt[19999]
  let m_b_two13_f1_c = 2*mean(xo*cos(2*pi*20900000000.0*tt))
  let m_b_two13_f1_s = 2*mean(xo*sin(2*pi*20900000000.0*tt))
  let m_b_two13_f2_c = 2*mean(xo*cos(2*pi*21000000000.0*tt))
  let m_b_two13_f2_s = 2*mean(xo*sin(2*pi*21000000000.0*tt))
  let m_b_two13_im3l_c = 2*mean(xo*cos(2*pi*20800000000.0*tt))
  let m_b_two13_im3l_s = 2*mean(xo*sin(2*pi*20800000000.0*tt))
  let m_b_two13_im3h_c = 2*mean(xo*cos(2*pi*21100000000.0*tt))
  let m_b_two13_im3h_s = 2*mean(xo*sin(2*pi*21100000000.0*tt))
  let m_b_two13_fl_lo_c = 2*mean(xo*cos(2*pi*20750000000.0*tt))
  let m_b_two13_fl_lo_s = 2*mean(xo*sin(2*pi*20750000000.0*tt))
  let m_b_two13_fl_hi_c = 2*mean(xo*cos(2*pi*21150000000.0*tt))
  let m_b_two13_fl_hi_s = 2*mean(xo*sin(2*pi*21150000000.0*tt))
  let m_b_two13_vce_q1_max = maximum(v(xdut.c1)[40000,59999] - v(xdut.e1)[40000,59999])
  let m_b_two13_vce_q1_min = minimum(v(xdut.c1)[40000,59999] - v(xdut.e1)[40000,59999])
  let m_b_two13_vce_q2_max = maximum(v(xdut.oc)[40000,59999] - v(xdut.c1)[40000,59999])
  let m_b_two13_vce_q2_min = minimum(v(xdut.oc)[40000,59999] - v(xdut.c1)[40000,59999])
  let m_b_two13_vbe_q1_max = maximum(v(xdut.b1)[40000,59999] - v(xdut.e1)[40000,59999])
  let m_b_two13_vbe_q1_min = minimum(v(xdut.b1)[40000,59999] - v(xdut.e1)[40000,59999])
  let m_b_two13_vbe_q2_max = maximum(v(xdut.b2)[40000,59999] - v(xdut.c1)[40000,59999])
  let m_b_two13_vbe_q2_min = minimum(v(xdut.b2)[40000,59999] - v(xdut.c1)[40000,59999])
  let w_b_two13_ic_q1 = @q.xdut.xq1.qnpn13g2[ic][40000,59999]
  let m_b_two13_ic_q1_max = maximum(w_b_two13_ic_q1)
  let m_b_two13_ic_q1_min = minimum(w_b_two13_ic_q1)
  let w_b_two13_ic_q2 = @q.xdut.xq2.qnpn13g2[ic][40000,59999]
  let m_b_two13_ic_q2_max = maximum(w_b_two13_ic_q2)
  let m_b_two13_ic_q2_min = minimum(w_b_two13_ic_q2)
  print m_b_two13_n m_b_two13_t0 m_b_two13_t1 m_b_two13_f1_c m_b_two13_f1_s m_b_two13_f2_c
  print m_b_two13_f2_s m_b_two13_im3l_c m_b_two13_im3l_s m_b_two13_im3h_c m_b_two13_im3h_s m_b_two13_fl_lo_c
  print m_b_two13_fl_lo_s m_b_two13_fl_hi_c m_b_two13_fl_hi_s m_b_two13_vce_q1_max m_b_two13_vce_q1_min m_b_two13_vce_q2_max
  print m_b_two13_vce_q2_min m_b_two13_vbe_q1_max m_b_two13_vbe_q1_min m_b_two13_vbe_q2_max m_b_two13_vbe_q2_min m_b_two13_ic_q1_max
  print m_b_two13_ic_q1_min m_b_two13_ic_q2_max m_b_two13_ic_q2_min
  * run b_two14: two-tone, available power -42 dBm per tone
  alterparam fq1 = 20900000000.0
  alterparam fq2 = 21000000000.0
  alterparam va1 = 0.00502377286301916
  alterparam va2 = 0.00502377286301916
  reset
  save all @q.xdut.xq1.qnpn13g2[ic] @q.xdut.xq2.qnpn13g2[ic]
  tran 1e-12 6e-08 0 1e-12
  linearize v(p2) v(xdut.c1) v(xdut.e1) v(xdut.oc) v(xdut.b1) v(xdut.b2) @q.xdut.xq1.qnpn13g2[ic] @q.xdut.xq2.qnpn13g2[ic]
  let tt = time[40000,59999]
  let xo = v(p2)[40000,59999]
  let m_b_two14_n = length(xo)
  let m_b_two14_t0 = tt[0]
  let m_b_two14_t1 = tt[19999]
  let m_b_two14_f1_c = 2*mean(xo*cos(2*pi*20900000000.0*tt))
  let m_b_two14_f1_s = 2*mean(xo*sin(2*pi*20900000000.0*tt))
  let m_b_two14_f2_c = 2*mean(xo*cos(2*pi*21000000000.0*tt))
  let m_b_two14_f2_s = 2*mean(xo*sin(2*pi*21000000000.0*tt))
  let m_b_two14_im3l_c = 2*mean(xo*cos(2*pi*20800000000.0*tt))
  let m_b_two14_im3l_s = 2*mean(xo*sin(2*pi*20800000000.0*tt))
  let m_b_two14_im3h_c = 2*mean(xo*cos(2*pi*21100000000.0*tt))
  let m_b_two14_im3h_s = 2*mean(xo*sin(2*pi*21100000000.0*tt))
  let m_b_two14_fl_lo_c = 2*mean(xo*cos(2*pi*20750000000.0*tt))
  let m_b_two14_fl_lo_s = 2*mean(xo*sin(2*pi*20750000000.0*tt))
  let m_b_two14_fl_hi_c = 2*mean(xo*cos(2*pi*21150000000.0*tt))
  let m_b_two14_fl_hi_s = 2*mean(xo*sin(2*pi*21150000000.0*tt))
  let m_b_two14_vce_q1_max = maximum(v(xdut.c1)[40000,59999] - v(xdut.e1)[40000,59999])
  let m_b_two14_vce_q1_min = minimum(v(xdut.c1)[40000,59999] - v(xdut.e1)[40000,59999])
  let m_b_two14_vce_q2_max = maximum(v(xdut.oc)[40000,59999] - v(xdut.c1)[40000,59999])
  let m_b_two14_vce_q2_min = minimum(v(xdut.oc)[40000,59999] - v(xdut.c1)[40000,59999])
  let m_b_two14_vbe_q1_max = maximum(v(xdut.b1)[40000,59999] - v(xdut.e1)[40000,59999])
  let m_b_two14_vbe_q1_min = minimum(v(xdut.b1)[40000,59999] - v(xdut.e1)[40000,59999])
  let m_b_two14_vbe_q2_max = maximum(v(xdut.b2)[40000,59999] - v(xdut.c1)[40000,59999])
  let m_b_two14_vbe_q2_min = minimum(v(xdut.b2)[40000,59999] - v(xdut.c1)[40000,59999])
  let w_b_two14_ic_q1 = @q.xdut.xq1.qnpn13g2[ic][40000,59999]
  let m_b_two14_ic_q1_max = maximum(w_b_two14_ic_q1)
  let m_b_two14_ic_q1_min = minimum(w_b_two14_ic_q1)
  let w_b_two14_ic_q2 = @q.xdut.xq2.qnpn13g2[ic][40000,59999]
  let m_b_two14_ic_q2_max = maximum(w_b_two14_ic_q2)
  let m_b_two14_ic_q2_min = minimum(w_b_two14_ic_q2)
  print m_b_two14_n m_b_two14_t0 m_b_two14_t1 m_b_two14_f1_c m_b_two14_f1_s m_b_two14_f2_c
  print m_b_two14_f2_s m_b_two14_im3l_c m_b_two14_im3l_s m_b_two14_im3h_c m_b_two14_im3h_s m_b_two14_fl_lo_c
  print m_b_two14_fl_lo_s m_b_two14_fl_hi_c m_b_two14_fl_hi_s m_b_two14_vce_q1_max m_b_two14_vce_q1_min m_b_two14_vce_q2_max
  print m_b_two14_vce_q2_min m_b_two14_vbe_q1_max m_b_two14_vbe_q1_min m_b_two14_vbe_q2_max m_b_two14_vbe_q2_min m_b_two14_ic_q1_max
  print m_b_two14_ic_q1_min m_b_two14_ic_q2_max m_b_two14_ic_q2_min
  * run b_two15: two-tone, available power -41 dBm per tone
  alterparam fq1 = 20900000000.0
  alterparam fq2 = 21000000000.0
  alterparam va1 = 0.00563676586252891
  alterparam va2 = 0.00563676586252891
  reset
  save all @q.xdut.xq1.qnpn13g2[ic] @q.xdut.xq2.qnpn13g2[ic]
  tran 1e-12 6e-08 0 1e-12
  linearize v(p2) v(xdut.c1) v(xdut.e1) v(xdut.oc) v(xdut.b1) v(xdut.b2) @q.xdut.xq1.qnpn13g2[ic] @q.xdut.xq2.qnpn13g2[ic]
  let tt = time[40000,59999]
  let xo = v(p2)[40000,59999]
  let m_b_two15_n = length(xo)
  let m_b_two15_t0 = tt[0]
  let m_b_two15_t1 = tt[19999]
  let m_b_two15_f1_c = 2*mean(xo*cos(2*pi*20900000000.0*tt))
  let m_b_two15_f1_s = 2*mean(xo*sin(2*pi*20900000000.0*tt))
  let m_b_two15_f2_c = 2*mean(xo*cos(2*pi*21000000000.0*tt))
  let m_b_two15_f2_s = 2*mean(xo*sin(2*pi*21000000000.0*tt))
  let m_b_two15_im3l_c = 2*mean(xo*cos(2*pi*20800000000.0*tt))
  let m_b_two15_im3l_s = 2*mean(xo*sin(2*pi*20800000000.0*tt))
  let m_b_two15_im3h_c = 2*mean(xo*cos(2*pi*21100000000.0*tt))
  let m_b_two15_im3h_s = 2*mean(xo*sin(2*pi*21100000000.0*tt))
  let m_b_two15_fl_lo_c = 2*mean(xo*cos(2*pi*20750000000.0*tt))
  let m_b_two15_fl_lo_s = 2*mean(xo*sin(2*pi*20750000000.0*tt))
  let m_b_two15_fl_hi_c = 2*mean(xo*cos(2*pi*21150000000.0*tt))
  let m_b_two15_fl_hi_s = 2*mean(xo*sin(2*pi*21150000000.0*tt))
  let m_b_two15_vce_q1_max = maximum(v(xdut.c1)[40000,59999] - v(xdut.e1)[40000,59999])
  let m_b_two15_vce_q1_min = minimum(v(xdut.c1)[40000,59999] - v(xdut.e1)[40000,59999])
  let m_b_two15_vce_q2_max = maximum(v(xdut.oc)[40000,59999] - v(xdut.c1)[40000,59999])
  let m_b_two15_vce_q2_min = minimum(v(xdut.oc)[40000,59999] - v(xdut.c1)[40000,59999])
  let m_b_two15_vbe_q1_max = maximum(v(xdut.b1)[40000,59999] - v(xdut.e1)[40000,59999])
  let m_b_two15_vbe_q1_min = minimum(v(xdut.b1)[40000,59999] - v(xdut.e1)[40000,59999])
  let m_b_two15_vbe_q2_max = maximum(v(xdut.b2)[40000,59999] - v(xdut.c1)[40000,59999])
  let m_b_two15_vbe_q2_min = minimum(v(xdut.b2)[40000,59999] - v(xdut.c1)[40000,59999])
  let w_b_two15_ic_q1 = @q.xdut.xq1.qnpn13g2[ic][40000,59999]
  let m_b_two15_ic_q1_max = maximum(w_b_two15_ic_q1)
  let m_b_two15_ic_q1_min = minimum(w_b_two15_ic_q1)
  let w_b_two15_ic_q2 = @q.xdut.xq2.qnpn13g2[ic][40000,59999]
  let m_b_two15_ic_q2_max = maximum(w_b_two15_ic_q2)
  let m_b_two15_ic_q2_min = minimum(w_b_two15_ic_q2)
  print m_b_two15_n m_b_two15_t0 m_b_two15_t1 m_b_two15_f1_c m_b_two15_f1_s m_b_two15_f2_c
  print m_b_two15_f2_s m_b_two15_im3l_c m_b_two15_im3l_s m_b_two15_im3h_c m_b_two15_im3h_s m_b_two15_fl_lo_c
  print m_b_two15_fl_lo_s m_b_two15_fl_hi_c m_b_two15_fl_hi_s m_b_two15_vce_q1_max m_b_two15_vce_q1_min m_b_two15_vce_q2_max
  print m_b_two15_vce_q2_min m_b_two15_vbe_q1_max m_b_two15_vbe_q1_min m_b_two15_vbe_q2_max m_b_two15_vbe_q2_min m_b_two15_ic_q1_max
  print m_b_two15_ic_q1_min m_b_two15_ic_q2_max m_b_two15_ic_q2_min
  * run b_two16: two-tone, available power -40 dBm per tone
  alterparam fq1 = 20900000000.0
  alterparam fq2 = 21000000000.0
  alterparam va1 = 0.00632455532033676
  alterparam va2 = 0.00632455532033676
  reset
  save all @q.xdut.xq1.qnpn13g2[ic] @q.xdut.xq2.qnpn13g2[ic]
  tran 1e-12 6e-08 0 1e-12
  linearize v(p2) v(xdut.c1) v(xdut.e1) v(xdut.oc) v(xdut.b1) v(xdut.b2) @q.xdut.xq1.qnpn13g2[ic] @q.xdut.xq2.qnpn13g2[ic]
  let tt = time[40000,59999]
  let xo = v(p2)[40000,59999]
  let m_b_two16_n = length(xo)
  let m_b_two16_t0 = tt[0]
  let m_b_two16_t1 = tt[19999]
  let m_b_two16_f1_c = 2*mean(xo*cos(2*pi*20900000000.0*tt))
  let m_b_two16_f1_s = 2*mean(xo*sin(2*pi*20900000000.0*tt))
  let m_b_two16_f2_c = 2*mean(xo*cos(2*pi*21000000000.0*tt))
  let m_b_two16_f2_s = 2*mean(xo*sin(2*pi*21000000000.0*tt))
  let m_b_two16_im3l_c = 2*mean(xo*cos(2*pi*20800000000.0*tt))
  let m_b_two16_im3l_s = 2*mean(xo*sin(2*pi*20800000000.0*tt))
  let m_b_two16_im3h_c = 2*mean(xo*cos(2*pi*21100000000.0*tt))
  let m_b_two16_im3h_s = 2*mean(xo*sin(2*pi*21100000000.0*tt))
  let m_b_two16_fl_lo_c = 2*mean(xo*cos(2*pi*20750000000.0*tt))
  let m_b_two16_fl_lo_s = 2*mean(xo*sin(2*pi*20750000000.0*tt))
  let m_b_two16_fl_hi_c = 2*mean(xo*cos(2*pi*21150000000.0*tt))
  let m_b_two16_fl_hi_s = 2*mean(xo*sin(2*pi*21150000000.0*tt))
  let m_b_two16_vce_q1_max = maximum(v(xdut.c1)[40000,59999] - v(xdut.e1)[40000,59999])
  let m_b_two16_vce_q1_min = minimum(v(xdut.c1)[40000,59999] - v(xdut.e1)[40000,59999])
  let m_b_two16_vce_q2_max = maximum(v(xdut.oc)[40000,59999] - v(xdut.c1)[40000,59999])
  let m_b_two16_vce_q2_min = minimum(v(xdut.oc)[40000,59999] - v(xdut.c1)[40000,59999])
  let m_b_two16_vbe_q1_max = maximum(v(xdut.b1)[40000,59999] - v(xdut.e1)[40000,59999])
  let m_b_two16_vbe_q1_min = minimum(v(xdut.b1)[40000,59999] - v(xdut.e1)[40000,59999])
  let m_b_two16_vbe_q2_max = maximum(v(xdut.b2)[40000,59999] - v(xdut.c1)[40000,59999])
  let m_b_two16_vbe_q2_min = minimum(v(xdut.b2)[40000,59999] - v(xdut.c1)[40000,59999])
  let w_b_two16_ic_q1 = @q.xdut.xq1.qnpn13g2[ic][40000,59999]
  let m_b_two16_ic_q1_max = maximum(w_b_two16_ic_q1)
  let m_b_two16_ic_q1_min = minimum(w_b_two16_ic_q1)
  let w_b_two16_ic_q2 = @q.xdut.xq2.qnpn13g2[ic][40000,59999]
  let m_b_two16_ic_q2_max = maximum(w_b_two16_ic_q2)
  let m_b_two16_ic_q2_min = minimum(w_b_two16_ic_q2)
  print m_b_two16_n m_b_two16_t0 m_b_two16_t1 m_b_two16_f1_c m_b_two16_f1_s m_b_two16_f2_c
  print m_b_two16_f2_s m_b_two16_im3l_c m_b_two16_im3l_s m_b_two16_im3h_c m_b_two16_im3h_s m_b_two16_fl_lo_c
  print m_b_two16_fl_lo_s m_b_two16_fl_hi_c m_b_two16_fl_hi_s m_b_two16_vce_q1_max m_b_two16_vce_q1_min m_b_two16_vce_q2_max
  print m_b_two16_vce_q2_min m_b_two16_vbe_q1_max m_b_two16_vbe_q1_min m_b_two16_vbe_q2_max m_b_two16_vbe_q2_min m_b_two16_ic_q1_max
  print m_b_two16_ic_q1_min m_b_two16_ic_q2_max m_b_two16_ic_q2_min
  * run b_two17: two-tone, available power -39 dBm per tone
  alterparam fq1 = 20900000000.0
  alterparam fq2 = 21000000000.0
  alterparam va1 = 0.00709626778467151
  alterparam va2 = 0.00709626778467151
  reset
  save all @q.xdut.xq1.qnpn13g2[ic] @q.xdut.xq2.qnpn13g2[ic]
  tran 1e-12 6e-08 0 1e-12
  linearize v(p2) v(xdut.c1) v(xdut.e1) v(xdut.oc) v(xdut.b1) v(xdut.b2) @q.xdut.xq1.qnpn13g2[ic] @q.xdut.xq2.qnpn13g2[ic]
  let tt = time[40000,59999]
  let xo = v(p2)[40000,59999]
  let m_b_two17_n = length(xo)
  let m_b_two17_t0 = tt[0]
  let m_b_two17_t1 = tt[19999]
  let m_b_two17_f1_c = 2*mean(xo*cos(2*pi*20900000000.0*tt))
  let m_b_two17_f1_s = 2*mean(xo*sin(2*pi*20900000000.0*tt))
  let m_b_two17_f2_c = 2*mean(xo*cos(2*pi*21000000000.0*tt))
  let m_b_two17_f2_s = 2*mean(xo*sin(2*pi*21000000000.0*tt))
  let m_b_two17_im3l_c = 2*mean(xo*cos(2*pi*20800000000.0*tt))
  let m_b_two17_im3l_s = 2*mean(xo*sin(2*pi*20800000000.0*tt))
  let m_b_two17_im3h_c = 2*mean(xo*cos(2*pi*21100000000.0*tt))
  let m_b_two17_im3h_s = 2*mean(xo*sin(2*pi*21100000000.0*tt))
  let m_b_two17_fl_lo_c = 2*mean(xo*cos(2*pi*20750000000.0*tt))
  let m_b_two17_fl_lo_s = 2*mean(xo*sin(2*pi*20750000000.0*tt))
  let m_b_two17_fl_hi_c = 2*mean(xo*cos(2*pi*21150000000.0*tt))
  let m_b_two17_fl_hi_s = 2*mean(xo*sin(2*pi*21150000000.0*tt))
  let m_b_two17_vce_q1_max = maximum(v(xdut.c1)[40000,59999] - v(xdut.e1)[40000,59999])
  let m_b_two17_vce_q1_min = minimum(v(xdut.c1)[40000,59999] - v(xdut.e1)[40000,59999])
  let m_b_two17_vce_q2_max = maximum(v(xdut.oc)[40000,59999] - v(xdut.c1)[40000,59999])
  let m_b_two17_vce_q2_min = minimum(v(xdut.oc)[40000,59999] - v(xdut.c1)[40000,59999])
  let m_b_two17_vbe_q1_max = maximum(v(xdut.b1)[40000,59999] - v(xdut.e1)[40000,59999])
  let m_b_two17_vbe_q1_min = minimum(v(xdut.b1)[40000,59999] - v(xdut.e1)[40000,59999])
  let m_b_two17_vbe_q2_max = maximum(v(xdut.b2)[40000,59999] - v(xdut.c1)[40000,59999])
  let m_b_two17_vbe_q2_min = minimum(v(xdut.b2)[40000,59999] - v(xdut.c1)[40000,59999])
  let w_b_two17_ic_q1 = @q.xdut.xq1.qnpn13g2[ic][40000,59999]
  let m_b_two17_ic_q1_max = maximum(w_b_two17_ic_q1)
  let m_b_two17_ic_q1_min = minimum(w_b_two17_ic_q1)
  let w_b_two17_ic_q2 = @q.xdut.xq2.qnpn13g2[ic][40000,59999]
  let m_b_two17_ic_q2_max = maximum(w_b_two17_ic_q2)
  let m_b_two17_ic_q2_min = minimum(w_b_two17_ic_q2)
  print m_b_two17_n m_b_two17_t0 m_b_two17_t1 m_b_two17_f1_c m_b_two17_f1_s m_b_two17_f2_c
  print m_b_two17_f2_s m_b_two17_im3l_c m_b_two17_im3l_s m_b_two17_im3h_c m_b_two17_im3h_s m_b_two17_fl_lo_c
  print m_b_two17_fl_lo_s m_b_two17_fl_hi_c m_b_two17_fl_hi_s m_b_two17_vce_q1_max m_b_two17_vce_q1_min m_b_two17_vce_q2_max
  print m_b_two17_vce_q2_min m_b_two17_vbe_q1_max m_b_two17_vbe_q1_min m_b_two17_vbe_q2_max m_b_two17_vbe_q2_min m_b_two17_ic_q1_max
  print m_b_two17_ic_q1_min m_b_two17_ic_q2_max m_b_two17_ic_q2_min
  * run b_two18: two-tone, available power -38 dBm per tone
  alterparam fq1 = 20900000000.0
  alterparam fq2 = 21000000000.0
  alterparam va1 = 0.00796214341106995
  alterparam va2 = 0.00796214341106995
  reset
  save all @q.xdut.xq1.qnpn13g2[ic] @q.xdut.xq2.qnpn13g2[ic]
  tran 1e-12 6e-08 0 1e-12
  linearize v(p2) v(xdut.c1) v(xdut.e1) v(xdut.oc) v(xdut.b1) v(xdut.b2) @q.xdut.xq1.qnpn13g2[ic] @q.xdut.xq2.qnpn13g2[ic]
  let tt = time[40000,59999]
  let xo = v(p2)[40000,59999]
  let m_b_two18_n = length(xo)
  let m_b_two18_t0 = tt[0]
  let m_b_two18_t1 = tt[19999]
  let m_b_two18_f1_c = 2*mean(xo*cos(2*pi*20900000000.0*tt))
  let m_b_two18_f1_s = 2*mean(xo*sin(2*pi*20900000000.0*tt))
  let m_b_two18_f2_c = 2*mean(xo*cos(2*pi*21000000000.0*tt))
  let m_b_two18_f2_s = 2*mean(xo*sin(2*pi*21000000000.0*tt))
  let m_b_two18_im3l_c = 2*mean(xo*cos(2*pi*20800000000.0*tt))
  let m_b_two18_im3l_s = 2*mean(xo*sin(2*pi*20800000000.0*tt))
  let m_b_two18_im3h_c = 2*mean(xo*cos(2*pi*21100000000.0*tt))
  let m_b_two18_im3h_s = 2*mean(xo*sin(2*pi*21100000000.0*tt))
  let m_b_two18_fl_lo_c = 2*mean(xo*cos(2*pi*20750000000.0*tt))
  let m_b_two18_fl_lo_s = 2*mean(xo*sin(2*pi*20750000000.0*tt))
  let m_b_two18_fl_hi_c = 2*mean(xo*cos(2*pi*21150000000.0*tt))
  let m_b_two18_fl_hi_s = 2*mean(xo*sin(2*pi*21150000000.0*tt))
  let m_b_two18_vce_q1_max = maximum(v(xdut.c1)[40000,59999] - v(xdut.e1)[40000,59999])
  let m_b_two18_vce_q1_min = minimum(v(xdut.c1)[40000,59999] - v(xdut.e1)[40000,59999])
  let m_b_two18_vce_q2_max = maximum(v(xdut.oc)[40000,59999] - v(xdut.c1)[40000,59999])
  let m_b_two18_vce_q2_min = minimum(v(xdut.oc)[40000,59999] - v(xdut.c1)[40000,59999])
  let m_b_two18_vbe_q1_max = maximum(v(xdut.b1)[40000,59999] - v(xdut.e1)[40000,59999])
  let m_b_two18_vbe_q1_min = minimum(v(xdut.b1)[40000,59999] - v(xdut.e1)[40000,59999])
  let m_b_two18_vbe_q2_max = maximum(v(xdut.b2)[40000,59999] - v(xdut.c1)[40000,59999])
  let m_b_two18_vbe_q2_min = minimum(v(xdut.b2)[40000,59999] - v(xdut.c1)[40000,59999])
  let w_b_two18_ic_q1 = @q.xdut.xq1.qnpn13g2[ic][40000,59999]
  let m_b_two18_ic_q1_max = maximum(w_b_two18_ic_q1)
  let m_b_two18_ic_q1_min = minimum(w_b_two18_ic_q1)
  let w_b_two18_ic_q2 = @q.xdut.xq2.qnpn13g2[ic][40000,59999]
  let m_b_two18_ic_q2_max = maximum(w_b_two18_ic_q2)
  let m_b_two18_ic_q2_min = minimum(w_b_two18_ic_q2)
  print m_b_two18_n m_b_two18_t0 m_b_two18_t1 m_b_two18_f1_c m_b_two18_f1_s m_b_two18_f2_c
  print m_b_two18_f2_s m_b_two18_im3l_c m_b_two18_im3l_s m_b_two18_im3h_c m_b_two18_im3h_s m_b_two18_fl_lo_c
  print m_b_two18_fl_lo_s m_b_two18_fl_hi_c m_b_two18_fl_hi_s m_b_two18_vce_q1_max m_b_two18_vce_q1_min m_b_two18_vce_q2_max
  print m_b_two18_vce_q2_min m_b_two18_vbe_q1_max m_b_two18_vbe_q1_min m_b_two18_vbe_q2_max m_b_two18_vbe_q2_min m_b_two18_ic_q1_max
  print m_b_two18_ic_q1_min m_b_two18_ic_q2_max m_b_two18_ic_q2_min
  * run b_two19: two-tone, available power -37 dBm per tone
  alterparam fq1 = 20900000000.0
  alterparam fq2 = 21000000000.0
  alterparam va1 = 0.00893367184301926
  alterparam va2 = 0.00893367184301926
  reset
  save all @q.xdut.xq1.qnpn13g2[ic] @q.xdut.xq2.qnpn13g2[ic]
  tran 1e-12 6e-08 0 1e-12
  linearize v(p2) v(xdut.c1) v(xdut.e1) v(xdut.oc) v(xdut.b1) v(xdut.b2) @q.xdut.xq1.qnpn13g2[ic] @q.xdut.xq2.qnpn13g2[ic]
  let tt = time[40000,59999]
  let xo = v(p2)[40000,59999]
  let m_b_two19_n = length(xo)
  let m_b_two19_t0 = tt[0]
  let m_b_two19_t1 = tt[19999]
  let m_b_two19_f1_c = 2*mean(xo*cos(2*pi*20900000000.0*tt))
  let m_b_two19_f1_s = 2*mean(xo*sin(2*pi*20900000000.0*tt))
  let m_b_two19_f2_c = 2*mean(xo*cos(2*pi*21000000000.0*tt))
  let m_b_two19_f2_s = 2*mean(xo*sin(2*pi*21000000000.0*tt))
  let m_b_two19_im3l_c = 2*mean(xo*cos(2*pi*20800000000.0*tt))
  let m_b_two19_im3l_s = 2*mean(xo*sin(2*pi*20800000000.0*tt))
  let m_b_two19_im3h_c = 2*mean(xo*cos(2*pi*21100000000.0*tt))
  let m_b_two19_im3h_s = 2*mean(xo*sin(2*pi*21100000000.0*tt))
  let m_b_two19_fl_lo_c = 2*mean(xo*cos(2*pi*20750000000.0*tt))
  let m_b_two19_fl_lo_s = 2*mean(xo*sin(2*pi*20750000000.0*tt))
  let m_b_two19_fl_hi_c = 2*mean(xo*cos(2*pi*21150000000.0*tt))
  let m_b_two19_fl_hi_s = 2*mean(xo*sin(2*pi*21150000000.0*tt))
  let m_b_two19_vce_q1_max = maximum(v(xdut.c1)[40000,59999] - v(xdut.e1)[40000,59999])
  let m_b_two19_vce_q1_min = minimum(v(xdut.c1)[40000,59999] - v(xdut.e1)[40000,59999])
  let m_b_two19_vce_q2_max = maximum(v(xdut.oc)[40000,59999] - v(xdut.c1)[40000,59999])
  let m_b_two19_vce_q2_min = minimum(v(xdut.oc)[40000,59999] - v(xdut.c1)[40000,59999])
  let m_b_two19_vbe_q1_max = maximum(v(xdut.b1)[40000,59999] - v(xdut.e1)[40000,59999])
  let m_b_two19_vbe_q1_min = minimum(v(xdut.b1)[40000,59999] - v(xdut.e1)[40000,59999])
  let m_b_two19_vbe_q2_max = maximum(v(xdut.b2)[40000,59999] - v(xdut.c1)[40000,59999])
  let m_b_two19_vbe_q2_min = minimum(v(xdut.b2)[40000,59999] - v(xdut.c1)[40000,59999])
  let w_b_two19_ic_q1 = @q.xdut.xq1.qnpn13g2[ic][40000,59999]
  let m_b_two19_ic_q1_max = maximum(w_b_two19_ic_q1)
  let m_b_two19_ic_q1_min = minimum(w_b_two19_ic_q1)
  let w_b_two19_ic_q2 = @q.xdut.xq2.qnpn13g2[ic][40000,59999]
  let m_b_two19_ic_q2_max = maximum(w_b_two19_ic_q2)
  let m_b_two19_ic_q2_min = minimum(w_b_two19_ic_q2)
  print m_b_two19_n m_b_two19_t0 m_b_two19_t1 m_b_two19_f1_c m_b_two19_f1_s m_b_two19_f2_c
  print m_b_two19_f2_s m_b_two19_im3l_c m_b_two19_im3l_s m_b_two19_im3h_c m_b_two19_im3h_s m_b_two19_fl_lo_c
  print m_b_two19_fl_lo_s m_b_two19_fl_hi_c m_b_two19_fl_hi_s m_b_two19_vce_q1_max m_b_two19_vce_q1_min m_b_two19_vce_q2_max
  print m_b_two19_vce_q2_min m_b_two19_vbe_q1_max m_b_two19_vbe_q1_min m_b_two19_vbe_q2_max m_b_two19_vbe_q2_min m_b_two19_ic_q1_max
  print m_b_two19_ic_q1_min m_b_two19_ic_q2_max m_b_two19_ic_q2_min
  * run b_two20: two-tone, available power -36 dBm per tone
  alterparam fq1 = 20900000000.0
  alterparam fq2 = 21000000000.0
  alterparam va1 = 0.0100237446725454
  alterparam va2 = 0.0100237446725454
  reset
  save all @q.xdut.xq1.qnpn13g2[ic] @q.xdut.xq2.qnpn13g2[ic]
  tran 1e-12 6e-08 0 1e-12
  linearize v(p2) v(xdut.c1) v(xdut.e1) v(xdut.oc) v(xdut.b1) v(xdut.b2) @q.xdut.xq1.qnpn13g2[ic] @q.xdut.xq2.qnpn13g2[ic]
  let tt = time[40000,59999]
  let xo = v(p2)[40000,59999]
  let m_b_two20_n = length(xo)
  let m_b_two20_t0 = tt[0]
  let m_b_two20_t1 = tt[19999]
  let m_b_two20_f1_c = 2*mean(xo*cos(2*pi*20900000000.0*tt))
  let m_b_two20_f1_s = 2*mean(xo*sin(2*pi*20900000000.0*tt))
  let m_b_two20_f2_c = 2*mean(xo*cos(2*pi*21000000000.0*tt))
  let m_b_two20_f2_s = 2*mean(xo*sin(2*pi*21000000000.0*tt))
  let m_b_two20_im3l_c = 2*mean(xo*cos(2*pi*20800000000.0*tt))
  let m_b_two20_im3l_s = 2*mean(xo*sin(2*pi*20800000000.0*tt))
  let m_b_two20_im3h_c = 2*mean(xo*cos(2*pi*21100000000.0*tt))
  let m_b_two20_im3h_s = 2*mean(xo*sin(2*pi*21100000000.0*tt))
  let m_b_two20_fl_lo_c = 2*mean(xo*cos(2*pi*20750000000.0*tt))
  let m_b_two20_fl_lo_s = 2*mean(xo*sin(2*pi*20750000000.0*tt))
  let m_b_two20_fl_hi_c = 2*mean(xo*cos(2*pi*21150000000.0*tt))
  let m_b_two20_fl_hi_s = 2*mean(xo*sin(2*pi*21150000000.0*tt))
  let m_b_two20_vce_q1_max = maximum(v(xdut.c1)[40000,59999] - v(xdut.e1)[40000,59999])
  let m_b_two20_vce_q1_min = minimum(v(xdut.c1)[40000,59999] - v(xdut.e1)[40000,59999])
  let m_b_two20_vce_q2_max = maximum(v(xdut.oc)[40000,59999] - v(xdut.c1)[40000,59999])
  let m_b_two20_vce_q2_min = minimum(v(xdut.oc)[40000,59999] - v(xdut.c1)[40000,59999])
  let m_b_two20_vbe_q1_max = maximum(v(xdut.b1)[40000,59999] - v(xdut.e1)[40000,59999])
  let m_b_two20_vbe_q1_min = minimum(v(xdut.b1)[40000,59999] - v(xdut.e1)[40000,59999])
  let m_b_two20_vbe_q2_max = maximum(v(xdut.b2)[40000,59999] - v(xdut.c1)[40000,59999])
  let m_b_two20_vbe_q2_min = minimum(v(xdut.b2)[40000,59999] - v(xdut.c1)[40000,59999])
  let w_b_two20_ic_q1 = @q.xdut.xq1.qnpn13g2[ic][40000,59999]
  let m_b_two20_ic_q1_max = maximum(w_b_two20_ic_q1)
  let m_b_two20_ic_q1_min = minimum(w_b_two20_ic_q1)
  let w_b_two20_ic_q2 = @q.xdut.xq2.qnpn13g2[ic][40000,59999]
  let m_b_two20_ic_q2_max = maximum(w_b_two20_ic_q2)
  let m_b_two20_ic_q2_min = minimum(w_b_two20_ic_q2)
  print m_b_two20_n m_b_two20_t0 m_b_two20_t1 m_b_two20_f1_c m_b_two20_f1_s m_b_two20_f2_c
  print m_b_two20_f2_s m_b_two20_im3l_c m_b_two20_im3l_s m_b_two20_im3h_c m_b_two20_im3h_s m_b_two20_fl_lo_c
  print m_b_two20_fl_lo_s m_b_two20_fl_hi_c m_b_two20_fl_hi_s m_b_two20_vce_q1_max m_b_two20_vce_q1_min m_b_two20_vce_q2_max
  print m_b_two20_vce_q2_min m_b_two20_vbe_q1_max m_b_two20_vbe_q1_min m_b_two20_vbe_q2_max m_b_two20_vbe_q2_min m_b_two20_ic_q1_max
  print m_b_two20_ic_q1_min m_b_two20_ic_q2_max m_b_two20_ic_q2_min
  * run h_two00: two-tone, available power -56 dBm per tone
  alterparam fq1 = 20900000000.0
  alterparam fq2 = 21000000000.0
  alterparam va1 = 0.00100237446725455
  alterparam va2 = 0.00100237446725455
  reset
  save all @q.xdut.xq1.qnpn13g2[ic] @q.xdut.xq2.qnpn13g2[ic]
  tran 5e-13 6e-08 0 5e-13
  linearize v(p2) v(xdut.c1) v(xdut.e1) v(xdut.oc) v(xdut.b1) v(xdut.b2) @q.xdut.xq1.qnpn13g2[ic] @q.xdut.xq2.qnpn13g2[ic]
  let tt = time[80000,119999]
  let xo = v(p2)[80000,119999]
  let m_h_two00_n = length(xo)
  let m_h_two00_t0 = tt[0]
  let m_h_two00_t1 = tt[39999]
  let m_h_two00_f1_c = 2*mean(xo*cos(2*pi*20900000000.0*tt))
  let m_h_two00_f1_s = 2*mean(xo*sin(2*pi*20900000000.0*tt))
  let m_h_two00_f2_c = 2*mean(xo*cos(2*pi*21000000000.0*tt))
  let m_h_two00_f2_s = 2*mean(xo*sin(2*pi*21000000000.0*tt))
  let m_h_two00_im3l_c = 2*mean(xo*cos(2*pi*20800000000.0*tt))
  let m_h_two00_im3l_s = 2*mean(xo*sin(2*pi*20800000000.0*tt))
  let m_h_two00_im3h_c = 2*mean(xo*cos(2*pi*21100000000.0*tt))
  let m_h_two00_im3h_s = 2*mean(xo*sin(2*pi*21100000000.0*tt))
  let m_h_two00_fl_lo_c = 2*mean(xo*cos(2*pi*20750000000.0*tt))
  let m_h_two00_fl_lo_s = 2*mean(xo*sin(2*pi*20750000000.0*tt))
  let m_h_two00_fl_hi_c = 2*mean(xo*cos(2*pi*21150000000.0*tt))
  let m_h_two00_fl_hi_s = 2*mean(xo*sin(2*pi*21150000000.0*tt))
  let m_h_two00_vce_q1_max = maximum(v(xdut.c1)[80000,119999] - v(xdut.e1)[80000,119999])
  let m_h_two00_vce_q1_min = minimum(v(xdut.c1)[80000,119999] - v(xdut.e1)[80000,119999])
  let m_h_two00_vce_q2_max = maximum(v(xdut.oc)[80000,119999] - v(xdut.c1)[80000,119999])
  let m_h_two00_vce_q2_min = minimum(v(xdut.oc)[80000,119999] - v(xdut.c1)[80000,119999])
  let m_h_two00_vbe_q1_max = maximum(v(xdut.b1)[80000,119999] - v(xdut.e1)[80000,119999])
  let m_h_two00_vbe_q1_min = minimum(v(xdut.b1)[80000,119999] - v(xdut.e1)[80000,119999])
  let m_h_two00_vbe_q2_max = maximum(v(xdut.b2)[80000,119999] - v(xdut.c1)[80000,119999])
  let m_h_two00_vbe_q2_min = minimum(v(xdut.b2)[80000,119999] - v(xdut.c1)[80000,119999])
  let w_h_two00_ic_q1 = @q.xdut.xq1.qnpn13g2[ic][80000,119999]
  let m_h_two00_ic_q1_max = maximum(w_h_two00_ic_q1)
  let m_h_two00_ic_q1_min = minimum(w_h_two00_ic_q1)
  let w_h_two00_ic_q2 = @q.xdut.xq2.qnpn13g2[ic][80000,119999]
  let m_h_two00_ic_q2_max = maximum(w_h_two00_ic_q2)
  let m_h_two00_ic_q2_min = minimum(w_h_two00_ic_q2)
  print m_h_two00_n m_h_two00_t0 m_h_two00_t1 m_h_two00_f1_c m_h_two00_f1_s m_h_two00_f2_c
  print m_h_two00_f2_s m_h_two00_im3l_c m_h_two00_im3l_s m_h_two00_im3h_c m_h_two00_im3h_s m_h_two00_fl_lo_c
  print m_h_two00_fl_lo_s m_h_two00_fl_hi_c m_h_two00_fl_hi_s m_h_two00_vce_q1_max m_h_two00_vce_q1_min m_h_two00_vce_q2_max
  print m_h_two00_vce_q2_min m_h_two00_vbe_q1_max m_h_two00_vbe_q1_min m_h_two00_vbe_q2_max m_h_two00_vbe_q2_min m_h_two00_ic_q1_max
  print m_h_two00_ic_q1_min m_h_two00_ic_q2_max m_h_two00_ic_q2_min
  * run h_two01: two-tone, available power -55 dBm per tone
  alterparam fq1 = 20900000000.0
  alterparam fq2 = 21000000000.0
  alterparam va1 = 0.0011246826503807
  alterparam va2 = 0.0011246826503807
  reset
  save all @q.xdut.xq1.qnpn13g2[ic] @q.xdut.xq2.qnpn13g2[ic]
  tran 5e-13 6e-08 0 5e-13
  linearize v(p2) v(xdut.c1) v(xdut.e1) v(xdut.oc) v(xdut.b1) v(xdut.b2) @q.xdut.xq1.qnpn13g2[ic] @q.xdut.xq2.qnpn13g2[ic]
  let tt = time[80000,119999]
  let xo = v(p2)[80000,119999]
  let m_h_two01_n = length(xo)
  let m_h_two01_t0 = tt[0]
  let m_h_two01_t1 = tt[39999]
  let m_h_two01_f1_c = 2*mean(xo*cos(2*pi*20900000000.0*tt))
  let m_h_two01_f1_s = 2*mean(xo*sin(2*pi*20900000000.0*tt))
  let m_h_two01_f2_c = 2*mean(xo*cos(2*pi*21000000000.0*tt))
  let m_h_two01_f2_s = 2*mean(xo*sin(2*pi*21000000000.0*tt))
  let m_h_two01_im3l_c = 2*mean(xo*cos(2*pi*20800000000.0*tt))
  let m_h_two01_im3l_s = 2*mean(xo*sin(2*pi*20800000000.0*tt))
  let m_h_two01_im3h_c = 2*mean(xo*cos(2*pi*21100000000.0*tt))
  let m_h_two01_im3h_s = 2*mean(xo*sin(2*pi*21100000000.0*tt))
  let m_h_two01_fl_lo_c = 2*mean(xo*cos(2*pi*20750000000.0*tt))
  let m_h_two01_fl_lo_s = 2*mean(xo*sin(2*pi*20750000000.0*tt))
  let m_h_two01_fl_hi_c = 2*mean(xo*cos(2*pi*21150000000.0*tt))
  let m_h_two01_fl_hi_s = 2*mean(xo*sin(2*pi*21150000000.0*tt))
  let m_h_two01_vce_q1_max = maximum(v(xdut.c1)[80000,119999] - v(xdut.e1)[80000,119999])
  let m_h_two01_vce_q1_min = minimum(v(xdut.c1)[80000,119999] - v(xdut.e1)[80000,119999])
  let m_h_two01_vce_q2_max = maximum(v(xdut.oc)[80000,119999] - v(xdut.c1)[80000,119999])
  let m_h_two01_vce_q2_min = minimum(v(xdut.oc)[80000,119999] - v(xdut.c1)[80000,119999])
  let m_h_two01_vbe_q1_max = maximum(v(xdut.b1)[80000,119999] - v(xdut.e1)[80000,119999])
  let m_h_two01_vbe_q1_min = minimum(v(xdut.b1)[80000,119999] - v(xdut.e1)[80000,119999])
  let m_h_two01_vbe_q2_max = maximum(v(xdut.b2)[80000,119999] - v(xdut.c1)[80000,119999])
  let m_h_two01_vbe_q2_min = minimum(v(xdut.b2)[80000,119999] - v(xdut.c1)[80000,119999])
  let w_h_two01_ic_q1 = @q.xdut.xq1.qnpn13g2[ic][80000,119999]
  let m_h_two01_ic_q1_max = maximum(w_h_two01_ic_q1)
  let m_h_two01_ic_q1_min = minimum(w_h_two01_ic_q1)
  let w_h_two01_ic_q2 = @q.xdut.xq2.qnpn13g2[ic][80000,119999]
  let m_h_two01_ic_q2_max = maximum(w_h_two01_ic_q2)
  let m_h_two01_ic_q2_min = minimum(w_h_two01_ic_q2)
  print m_h_two01_n m_h_two01_t0 m_h_two01_t1 m_h_two01_f1_c m_h_two01_f1_s m_h_two01_f2_c
  print m_h_two01_f2_s m_h_two01_im3l_c m_h_two01_im3l_s m_h_two01_im3h_c m_h_two01_im3h_s m_h_two01_fl_lo_c
  print m_h_two01_fl_lo_s m_h_two01_fl_hi_c m_h_two01_fl_hi_s m_h_two01_vce_q1_max m_h_two01_vce_q1_min m_h_two01_vce_q2_max
  print m_h_two01_vce_q2_min m_h_two01_vbe_q1_max m_h_two01_vbe_q1_min m_h_two01_vbe_q2_max m_h_two01_vbe_q2_min m_h_two01_ic_q1_max
  print m_h_two01_ic_q1_min m_h_two01_ic_q2_max m_h_two01_ic_q2_min
  * run h_two02: two-tone, available power -54 dBm per tone
  alterparam fq1 = 20900000000.0
  alterparam fq2 = 21000000000.0
  alterparam va1 = 0.00126191468896039
  alterparam va2 = 0.00126191468896039
  reset
  save all @q.xdut.xq1.qnpn13g2[ic] @q.xdut.xq2.qnpn13g2[ic]
  tran 5e-13 6e-08 0 5e-13
  linearize v(p2) v(xdut.c1) v(xdut.e1) v(xdut.oc) v(xdut.b1) v(xdut.b2) @q.xdut.xq1.qnpn13g2[ic] @q.xdut.xq2.qnpn13g2[ic]
  let tt = time[80000,119999]
  let xo = v(p2)[80000,119999]
  let m_h_two02_n = length(xo)
  let m_h_two02_t0 = tt[0]
  let m_h_two02_t1 = tt[39999]
  let m_h_two02_f1_c = 2*mean(xo*cos(2*pi*20900000000.0*tt))
  let m_h_two02_f1_s = 2*mean(xo*sin(2*pi*20900000000.0*tt))
  let m_h_two02_f2_c = 2*mean(xo*cos(2*pi*21000000000.0*tt))
  let m_h_two02_f2_s = 2*mean(xo*sin(2*pi*21000000000.0*tt))
  let m_h_two02_im3l_c = 2*mean(xo*cos(2*pi*20800000000.0*tt))
  let m_h_two02_im3l_s = 2*mean(xo*sin(2*pi*20800000000.0*tt))
  let m_h_two02_im3h_c = 2*mean(xo*cos(2*pi*21100000000.0*tt))
  let m_h_two02_im3h_s = 2*mean(xo*sin(2*pi*21100000000.0*tt))
  let m_h_two02_fl_lo_c = 2*mean(xo*cos(2*pi*20750000000.0*tt))
  let m_h_two02_fl_lo_s = 2*mean(xo*sin(2*pi*20750000000.0*tt))
  let m_h_two02_fl_hi_c = 2*mean(xo*cos(2*pi*21150000000.0*tt))
  let m_h_two02_fl_hi_s = 2*mean(xo*sin(2*pi*21150000000.0*tt))
  let m_h_two02_vce_q1_max = maximum(v(xdut.c1)[80000,119999] - v(xdut.e1)[80000,119999])
  let m_h_two02_vce_q1_min = minimum(v(xdut.c1)[80000,119999] - v(xdut.e1)[80000,119999])
  let m_h_two02_vce_q2_max = maximum(v(xdut.oc)[80000,119999] - v(xdut.c1)[80000,119999])
  let m_h_two02_vce_q2_min = minimum(v(xdut.oc)[80000,119999] - v(xdut.c1)[80000,119999])
  let m_h_two02_vbe_q1_max = maximum(v(xdut.b1)[80000,119999] - v(xdut.e1)[80000,119999])
  let m_h_two02_vbe_q1_min = minimum(v(xdut.b1)[80000,119999] - v(xdut.e1)[80000,119999])
  let m_h_two02_vbe_q2_max = maximum(v(xdut.b2)[80000,119999] - v(xdut.c1)[80000,119999])
  let m_h_two02_vbe_q2_min = minimum(v(xdut.b2)[80000,119999] - v(xdut.c1)[80000,119999])
  let w_h_two02_ic_q1 = @q.xdut.xq1.qnpn13g2[ic][80000,119999]
  let m_h_two02_ic_q1_max = maximum(w_h_two02_ic_q1)
  let m_h_two02_ic_q1_min = minimum(w_h_two02_ic_q1)
  let w_h_two02_ic_q2 = @q.xdut.xq2.qnpn13g2[ic][80000,119999]
  let m_h_two02_ic_q2_max = maximum(w_h_two02_ic_q2)
  let m_h_two02_ic_q2_min = minimum(w_h_two02_ic_q2)
  print m_h_two02_n m_h_two02_t0 m_h_two02_t1 m_h_two02_f1_c m_h_two02_f1_s m_h_two02_f2_c
  print m_h_two02_f2_s m_h_two02_im3l_c m_h_two02_im3l_s m_h_two02_im3h_c m_h_two02_im3h_s m_h_two02_fl_lo_c
  print m_h_two02_fl_lo_s m_h_two02_fl_hi_c m_h_two02_fl_hi_s m_h_two02_vce_q1_max m_h_two02_vce_q1_min m_h_two02_vce_q2_max
  print m_h_two02_vce_q2_min m_h_two02_vbe_q1_max m_h_two02_vbe_q1_min m_h_two02_vbe_q2_max m_h_two02_vbe_q2_min m_h_two02_ic_q1_max
  print m_h_two02_ic_q1_min m_h_two02_ic_q2_max m_h_two02_ic_q2_min
  * run h_two03: two-tone, available power -53 dBm per tone
  alterparam fq1 = 20900000000.0
  alterparam fq2 = 21000000000.0
  alterparam va1 = 0.00141589156876828
  alterparam va2 = 0.00141589156876828
  reset
  save all @q.xdut.xq1.qnpn13g2[ic] @q.xdut.xq2.qnpn13g2[ic]
  tran 5e-13 6e-08 0 5e-13
  linearize v(p2) v(xdut.c1) v(xdut.e1) v(xdut.oc) v(xdut.b1) v(xdut.b2) @q.xdut.xq1.qnpn13g2[ic] @q.xdut.xq2.qnpn13g2[ic]
  let tt = time[80000,119999]
  let xo = v(p2)[80000,119999]
  let m_h_two03_n = length(xo)
  let m_h_two03_t0 = tt[0]
  let m_h_two03_t1 = tt[39999]
  let m_h_two03_f1_c = 2*mean(xo*cos(2*pi*20900000000.0*tt))
  let m_h_two03_f1_s = 2*mean(xo*sin(2*pi*20900000000.0*tt))
  let m_h_two03_f2_c = 2*mean(xo*cos(2*pi*21000000000.0*tt))
  let m_h_two03_f2_s = 2*mean(xo*sin(2*pi*21000000000.0*tt))
  let m_h_two03_im3l_c = 2*mean(xo*cos(2*pi*20800000000.0*tt))
  let m_h_two03_im3l_s = 2*mean(xo*sin(2*pi*20800000000.0*tt))
  let m_h_two03_im3h_c = 2*mean(xo*cos(2*pi*21100000000.0*tt))
  let m_h_two03_im3h_s = 2*mean(xo*sin(2*pi*21100000000.0*tt))
  let m_h_two03_fl_lo_c = 2*mean(xo*cos(2*pi*20750000000.0*tt))
  let m_h_two03_fl_lo_s = 2*mean(xo*sin(2*pi*20750000000.0*tt))
  let m_h_two03_fl_hi_c = 2*mean(xo*cos(2*pi*21150000000.0*tt))
  let m_h_two03_fl_hi_s = 2*mean(xo*sin(2*pi*21150000000.0*tt))
  let m_h_two03_vce_q1_max = maximum(v(xdut.c1)[80000,119999] - v(xdut.e1)[80000,119999])
  let m_h_two03_vce_q1_min = minimum(v(xdut.c1)[80000,119999] - v(xdut.e1)[80000,119999])
  let m_h_two03_vce_q2_max = maximum(v(xdut.oc)[80000,119999] - v(xdut.c1)[80000,119999])
  let m_h_two03_vce_q2_min = minimum(v(xdut.oc)[80000,119999] - v(xdut.c1)[80000,119999])
  let m_h_two03_vbe_q1_max = maximum(v(xdut.b1)[80000,119999] - v(xdut.e1)[80000,119999])
  let m_h_two03_vbe_q1_min = minimum(v(xdut.b1)[80000,119999] - v(xdut.e1)[80000,119999])
  let m_h_two03_vbe_q2_max = maximum(v(xdut.b2)[80000,119999] - v(xdut.c1)[80000,119999])
  let m_h_two03_vbe_q2_min = minimum(v(xdut.b2)[80000,119999] - v(xdut.c1)[80000,119999])
  let w_h_two03_ic_q1 = @q.xdut.xq1.qnpn13g2[ic][80000,119999]
  let m_h_two03_ic_q1_max = maximum(w_h_two03_ic_q1)
  let m_h_two03_ic_q1_min = minimum(w_h_two03_ic_q1)
  let w_h_two03_ic_q2 = @q.xdut.xq2.qnpn13g2[ic][80000,119999]
  let m_h_two03_ic_q2_max = maximum(w_h_two03_ic_q2)
  let m_h_two03_ic_q2_min = minimum(w_h_two03_ic_q2)
  print m_h_two03_n m_h_two03_t0 m_h_two03_t1 m_h_two03_f1_c m_h_two03_f1_s m_h_two03_f2_c
  print m_h_two03_f2_s m_h_two03_im3l_c m_h_two03_im3l_s m_h_two03_im3h_c m_h_two03_im3h_s m_h_two03_fl_lo_c
  print m_h_two03_fl_lo_s m_h_two03_fl_hi_c m_h_two03_fl_hi_s m_h_two03_vce_q1_max m_h_two03_vce_q1_min m_h_two03_vce_q2_max
  print m_h_two03_vce_q2_min m_h_two03_vbe_q1_max m_h_two03_vbe_q1_min m_h_two03_vbe_q2_max m_h_two03_vbe_q2_min m_h_two03_ic_q1_max
  print m_h_two03_ic_q1_min m_h_two03_ic_q2_max m_h_two03_ic_q2_min
  * run h_two04: two-tone, available power -52 dBm per tone
  alterparam fq1 = 20900000000.0
  alterparam fq2 = 21000000000.0
  alterparam va1 = 0.00158865646944856
  alterparam va2 = 0.00158865646944856
  reset
  save all @q.xdut.xq1.qnpn13g2[ic] @q.xdut.xq2.qnpn13g2[ic]
  tran 5e-13 6e-08 0 5e-13
  linearize v(p2) v(xdut.c1) v(xdut.e1) v(xdut.oc) v(xdut.b1) v(xdut.b2) @q.xdut.xq1.qnpn13g2[ic] @q.xdut.xq2.qnpn13g2[ic]
  let tt = time[80000,119999]
  let xo = v(p2)[80000,119999]
  let m_h_two04_n = length(xo)
  let m_h_two04_t0 = tt[0]
  let m_h_two04_t1 = tt[39999]
  let m_h_two04_f1_c = 2*mean(xo*cos(2*pi*20900000000.0*tt))
  let m_h_two04_f1_s = 2*mean(xo*sin(2*pi*20900000000.0*tt))
  let m_h_two04_f2_c = 2*mean(xo*cos(2*pi*21000000000.0*tt))
  let m_h_two04_f2_s = 2*mean(xo*sin(2*pi*21000000000.0*tt))
  let m_h_two04_im3l_c = 2*mean(xo*cos(2*pi*20800000000.0*tt))
  let m_h_two04_im3l_s = 2*mean(xo*sin(2*pi*20800000000.0*tt))
  let m_h_two04_im3h_c = 2*mean(xo*cos(2*pi*21100000000.0*tt))
  let m_h_two04_im3h_s = 2*mean(xo*sin(2*pi*21100000000.0*tt))
  let m_h_two04_fl_lo_c = 2*mean(xo*cos(2*pi*20750000000.0*tt))
  let m_h_two04_fl_lo_s = 2*mean(xo*sin(2*pi*20750000000.0*tt))
  let m_h_two04_fl_hi_c = 2*mean(xo*cos(2*pi*21150000000.0*tt))
  let m_h_two04_fl_hi_s = 2*mean(xo*sin(2*pi*21150000000.0*tt))
  let m_h_two04_vce_q1_max = maximum(v(xdut.c1)[80000,119999] - v(xdut.e1)[80000,119999])
  let m_h_two04_vce_q1_min = minimum(v(xdut.c1)[80000,119999] - v(xdut.e1)[80000,119999])
  let m_h_two04_vce_q2_max = maximum(v(xdut.oc)[80000,119999] - v(xdut.c1)[80000,119999])
  let m_h_two04_vce_q2_min = minimum(v(xdut.oc)[80000,119999] - v(xdut.c1)[80000,119999])
  let m_h_two04_vbe_q1_max = maximum(v(xdut.b1)[80000,119999] - v(xdut.e1)[80000,119999])
  let m_h_two04_vbe_q1_min = minimum(v(xdut.b1)[80000,119999] - v(xdut.e1)[80000,119999])
  let m_h_two04_vbe_q2_max = maximum(v(xdut.b2)[80000,119999] - v(xdut.c1)[80000,119999])
  let m_h_two04_vbe_q2_min = minimum(v(xdut.b2)[80000,119999] - v(xdut.c1)[80000,119999])
  let w_h_two04_ic_q1 = @q.xdut.xq1.qnpn13g2[ic][80000,119999]
  let m_h_two04_ic_q1_max = maximum(w_h_two04_ic_q1)
  let m_h_two04_ic_q1_min = minimum(w_h_two04_ic_q1)
  let w_h_two04_ic_q2 = @q.xdut.xq2.qnpn13g2[ic][80000,119999]
  let m_h_two04_ic_q2_max = maximum(w_h_two04_ic_q2)
  let m_h_two04_ic_q2_min = minimum(w_h_two04_ic_q2)
  print m_h_two04_n m_h_two04_t0 m_h_two04_t1 m_h_two04_f1_c m_h_two04_f1_s m_h_two04_f2_c
  print m_h_two04_f2_s m_h_two04_im3l_c m_h_two04_im3l_s m_h_two04_im3h_c m_h_two04_im3h_s m_h_two04_fl_lo_c
  print m_h_two04_fl_lo_s m_h_two04_fl_hi_c m_h_two04_fl_hi_s m_h_two04_vce_q1_max m_h_two04_vce_q1_min m_h_two04_vce_q2_max
  print m_h_two04_vce_q2_min m_h_two04_vbe_q1_max m_h_two04_vbe_q1_min m_h_two04_vbe_q2_max m_h_two04_vbe_q2_min m_h_two04_ic_q1_max
  print m_h_two04_ic_q1_min m_h_two04_ic_q2_max m_h_two04_ic_q2_min
  * run h_two05: two-tone, available power -51 dBm per tone
  alterparam fq1 = 20900000000.0
  alterparam fq2 = 21000000000.0
  alterparam va1 = 0.00178250187626749
  alterparam va2 = 0.00178250187626749
  reset
  save all @q.xdut.xq1.qnpn13g2[ic] @q.xdut.xq2.qnpn13g2[ic]
  tran 5e-13 6e-08 0 5e-13
  linearize v(p2) v(xdut.c1) v(xdut.e1) v(xdut.oc) v(xdut.b1) v(xdut.b2) @q.xdut.xq1.qnpn13g2[ic] @q.xdut.xq2.qnpn13g2[ic]
  let tt = time[80000,119999]
  let xo = v(p2)[80000,119999]
  let m_h_two05_n = length(xo)
  let m_h_two05_t0 = tt[0]
  let m_h_two05_t1 = tt[39999]
  let m_h_two05_f1_c = 2*mean(xo*cos(2*pi*20900000000.0*tt))
  let m_h_two05_f1_s = 2*mean(xo*sin(2*pi*20900000000.0*tt))
  let m_h_two05_f2_c = 2*mean(xo*cos(2*pi*21000000000.0*tt))
  let m_h_two05_f2_s = 2*mean(xo*sin(2*pi*21000000000.0*tt))
  let m_h_two05_im3l_c = 2*mean(xo*cos(2*pi*20800000000.0*tt))
  let m_h_two05_im3l_s = 2*mean(xo*sin(2*pi*20800000000.0*tt))
  let m_h_two05_im3h_c = 2*mean(xo*cos(2*pi*21100000000.0*tt))
  let m_h_two05_im3h_s = 2*mean(xo*sin(2*pi*21100000000.0*tt))
  let m_h_two05_fl_lo_c = 2*mean(xo*cos(2*pi*20750000000.0*tt))
  let m_h_two05_fl_lo_s = 2*mean(xo*sin(2*pi*20750000000.0*tt))
  let m_h_two05_fl_hi_c = 2*mean(xo*cos(2*pi*21150000000.0*tt))
  let m_h_two05_fl_hi_s = 2*mean(xo*sin(2*pi*21150000000.0*tt))
  let m_h_two05_vce_q1_max = maximum(v(xdut.c1)[80000,119999] - v(xdut.e1)[80000,119999])
  let m_h_two05_vce_q1_min = minimum(v(xdut.c1)[80000,119999] - v(xdut.e1)[80000,119999])
  let m_h_two05_vce_q2_max = maximum(v(xdut.oc)[80000,119999] - v(xdut.c1)[80000,119999])
  let m_h_two05_vce_q2_min = minimum(v(xdut.oc)[80000,119999] - v(xdut.c1)[80000,119999])
  let m_h_two05_vbe_q1_max = maximum(v(xdut.b1)[80000,119999] - v(xdut.e1)[80000,119999])
  let m_h_two05_vbe_q1_min = minimum(v(xdut.b1)[80000,119999] - v(xdut.e1)[80000,119999])
  let m_h_two05_vbe_q2_max = maximum(v(xdut.b2)[80000,119999] - v(xdut.c1)[80000,119999])
  let m_h_two05_vbe_q2_min = minimum(v(xdut.b2)[80000,119999] - v(xdut.c1)[80000,119999])
  let w_h_two05_ic_q1 = @q.xdut.xq1.qnpn13g2[ic][80000,119999]
  let m_h_two05_ic_q1_max = maximum(w_h_two05_ic_q1)
  let m_h_two05_ic_q1_min = minimum(w_h_two05_ic_q1)
  let w_h_two05_ic_q2 = @q.xdut.xq2.qnpn13g2[ic][80000,119999]
  let m_h_two05_ic_q2_max = maximum(w_h_two05_ic_q2)
  let m_h_two05_ic_q2_min = minimum(w_h_two05_ic_q2)
  print m_h_two05_n m_h_two05_t0 m_h_two05_t1 m_h_two05_f1_c m_h_two05_f1_s m_h_two05_f2_c
  print m_h_two05_f2_s m_h_two05_im3l_c m_h_two05_im3l_s m_h_two05_im3h_c m_h_two05_im3h_s m_h_two05_fl_lo_c
  print m_h_two05_fl_lo_s m_h_two05_fl_hi_c m_h_two05_fl_hi_s m_h_two05_vce_q1_max m_h_two05_vce_q1_min m_h_two05_vce_q2_max
  print m_h_two05_vce_q2_min m_h_two05_vbe_q1_max m_h_two05_vbe_q1_min m_h_two05_vbe_q2_max m_h_two05_vbe_q2_min m_h_two05_ic_q1_max
  print m_h_two05_ic_q1_min m_h_two05_ic_q2_max m_h_two05_ic_q2_min
  * run h_two06: two-tone, available power -50 dBm per tone
  alterparam fq1 = 20900000000.0
  alterparam fq2 = 21000000000.0
  alterparam va1 = 0.002
  alterparam va2 = 0.002
  reset
  save all @q.xdut.xq1.qnpn13g2[ic] @q.xdut.xq2.qnpn13g2[ic]
  tran 5e-13 6e-08 0 5e-13
  linearize v(p2) v(xdut.c1) v(xdut.e1) v(xdut.oc) v(xdut.b1) v(xdut.b2) @q.xdut.xq1.qnpn13g2[ic] @q.xdut.xq2.qnpn13g2[ic]
  let tt = time[80000,119999]
  let xo = v(p2)[80000,119999]
  let m_h_two06_n = length(xo)
  let m_h_two06_t0 = tt[0]
  let m_h_two06_t1 = tt[39999]
  let m_h_two06_f1_c = 2*mean(xo*cos(2*pi*20900000000.0*tt))
  let m_h_two06_f1_s = 2*mean(xo*sin(2*pi*20900000000.0*tt))
  let m_h_two06_f2_c = 2*mean(xo*cos(2*pi*21000000000.0*tt))
  let m_h_two06_f2_s = 2*mean(xo*sin(2*pi*21000000000.0*tt))
  let m_h_two06_im3l_c = 2*mean(xo*cos(2*pi*20800000000.0*tt))
  let m_h_two06_im3l_s = 2*mean(xo*sin(2*pi*20800000000.0*tt))
  let m_h_two06_im3h_c = 2*mean(xo*cos(2*pi*21100000000.0*tt))
  let m_h_two06_im3h_s = 2*mean(xo*sin(2*pi*21100000000.0*tt))
  let m_h_two06_fl_lo_c = 2*mean(xo*cos(2*pi*20750000000.0*tt))
  let m_h_two06_fl_lo_s = 2*mean(xo*sin(2*pi*20750000000.0*tt))
  let m_h_two06_fl_hi_c = 2*mean(xo*cos(2*pi*21150000000.0*tt))
  let m_h_two06_fl_hi_s = 2*mean(xo*sin(2*pi*21150000000.0*tt))
  let m_h_two06_vce_q1_max = maximum(v(xdut.c1)[80000,119999] - v(xdut.e1)[80000,119999])
  let m_h_two06_vce_q1_min = minimum(v(xdut.c1)[80000,119999] - v(xdut.e1)[80000,119999])
  let m_h_two06_vce_q2_max = maximum(v(xdut.oc)[80000,119999] - v(xdut.c1)[80000,119999])
  let m_h_two06_vce_q2_min = minimum(v(xdut.oc)[80000,119999] - v(xdut.c1)[80000,119999])
  let m_h_two06_vbe_q1_max = maximum(v(xdut.b1)[80000,119999] - v(xdut.e1)[80000,119999])
  let m_h_two06_vbe_q1_min = minimum(v(xdut.b1)[80000,119999] - v(xdut.e1)[80000,119999])
  let m_h_two06_vbe_q2_max = maximum(v(xdut.b2)[80000,119999] - v(xdut.c1)[80000,119999])
  let m_h_two06_vbe_q2_min = minimum(v(xdut.b2)[80000,119999] - v(xdut.c1)[80000,119999])
  let w_h_two06_ic_q1 = @q.xdut.xq1.qnpn13g2[ic][80000,119999]
  let m_h_two06_ic_q1_max = maximum(w_h_two06_ic_q1)
  let m_h_two06_ic_q1_min = minimum(w_h_two06_ic_q1)
  let w_h_two06_ic_q2 = @q.xdut.xq2.qnpn13g2[ic][80000,119999]
  let m_h_two06_ic_q2_max = maximum(w_h_two06_ic_q2)
  let m_h_two06_ic_q2_min = minimum(w_h_two06_ic_q2)
  print m_h_two06_n m_h_two06_t0 m_h_two06_t1 m_h_two06_f1_c m_h_two06_f1_s m_h_two06_f2_c
  print m_h_two06_f2_s m_h_two06_im3l_c m_h_two06_im3l_s m_h_two06_im3h_c m_h_two06_im3h_s m_h_two06_fl_lo_c
  print m_h_two06_fl_lo_s m_h_two06_fl_hi_c m_h_two06_fl_hi_s m_h_two06_vce_q1_max m_h_two06_vce_q1_min m_h_two06_vce_q2_max
  print m_h_two06_vce_q2_min m_h_two06_vbe_q1_max m_h_two06_vbe_q1_min m_h_two06_vbe_q2_max m_h_two06_vbe_q2_min m_h_two06_ic_q1_max
  print m_h_two06_ic_q1_min m_h_two06_ic_q2_max m_h_two06_ic_q2_min
  * run h_two07: two-tone, available power -49 dBm per tone
  alterparam fq1 = 20900000000.0
  alterparam fq2 = 21000000000.0
  alterparam va1 = 0.00224403690860393
  alterparam va2 = 0.00224403690860393
  reset
  save all @q.xdut.xq1.qnpn13g2[ic] @q.xdut.xq2.qnpn13g2[ic]
  tran 5e-13 6e-08 0 5e-13
  linearize v(p2) v(xdut.c1) v(xdut.e1) v(xdut.oc) v(xdut.b1) v(xdut.b2) @q.xdut.xq1.qnpn13g2[ic] @q.xdut.xq2.qnpn13g2[ic]
  let tt = time[80000,119999]
  let xo = v(p2)[80000,119999]
  let m_h_two07_n = length(xo)
  let m_h_two07_t0 = tt[0]
  let m_h_two07_t1 = tt[39999]
  let m_h_two07_f1_c = 2*mean(xo*cos(2*pi*20900000000.0*tt))
  let m_h_two07_f1_s = 2*mean(xo*sin(2*pi*20900000000.0*tt))
  let m_h_two07_f2_c = 2*mean(xo*cos(2*pi*21000000000.0*tt))
  let m_h_two07_f2_s = 2*mean(xo*sin(2*pi*21000000000.0*tt))
  let m_h_two07_im3l_c = 2*mean(xo*cos(2*pi*20800000000.0*tt))
  let m_h_two07_im3l_s = 2*mean(xo*sin(2*pi*20800000000.0*tt))
  let m_h_two07_im3h_c = 2*mean(xo*cos(2*pi*21100000000.0*tt))
  let m_h_two07_im3h_s = 2*mean(xo*sin(2*pi*21100000000.0*tt))
  let m_h_two07_fl_lo_c = 2*mean(xo*cos(2*pi*20750000000.0*tt))
  let m_h_two07_fl_lo_s = 2*mean(xo*sin(2*pi*20750000000.0*tt))
  let m_h_two07_fl_hi_c = 2*mean(xo*cos(2*pi*21150000000.0*tt))
  let m_h_two07_fl_hi_s = 2*mean(xo*sin(2*pi*21150000000.0*tt))
  let m_h_two07_vce_q1_max = maximum(v(xdut.c1)[80000,119999] - v(xdut.e1)[80000,119999])
  let m_h_two07_vce_q1_min = minimum(v(xdut.c1)[80000,119999] - v(xdut.e1)[80000,119999])
  let m_h_two07_vce_q2_max = maximum(v(xdut.oc)[80000,119999] - v(xdut.c1)[80000,119999])
  let m_h_two07_vce_q2_min = minimum(v(xdut.oc)[80000,119999] - v(xdut.c1)[80000,119999])
  let m_h_two07_vbe_q1_max = maximum(v(xdut.b1)[80000,119999] - v(xdut.e1)[80000,119999])
  let m_h_two07_vbe_q1_min = minimum(v(xdut.b1)[80000,119999] - v(xdut.e1)[80000,119999])
  let m_h_two07_vbe_q2_max = maximum(v(xdut.b2)[80000,119999] - v(xdut.c1)[80000,119999])
  let m_h_two07_vbe_q2_min = minimum(v(xdut.b2)[80000,119999] - v(xdut.c1)[80000,119999])
  let w_h_two07_ic_q1 = @q.xdut.xq1.qnpn13g2[ic][80000,119999]
  let m_h_two07_ic_q1_max = maximum(w_h_two07_ic_q1)
  let m_h_two07_ic_q1_min = minimum(w_h_two07_ic_q1)
  let w_h_two07_ic_q2 = @q.xdut.xq2.qnpn13g2[ic][80000,119999]
  let m_h_two07_ic_q2_max = maximum(w_h_two07_ic_q2)
  let m_h_two07_ic_q2_min = minimum(w_h_two07_ic_q2)
  print m_h_two07_n m_h_two07_t0 m_h_two07_t1 m_h_two07_f1_c m_h_two07_f1_s m_h_two07_f2_c
  print m_h_two07_f2_s m_h_two07_im3l_c m_h_two07_im3l_s m_h_two07_im3h_c m_h_two07_im3h_s m_h_two07_fl_lo_c
  print m_h_two07_fl_lo_s m_h_two07_fl_hi_c m_h_two07_fl_hi_s m_h_two07_vce_q1_max m_h_two07_vce_q1_min m_h_two07_vce_q2_max
  print m_h_two07_vce_q2_min m_h_two07_vbe_q1_max m_h_two07_vbe_q1_min m_h_two07_vbe_q2_max m_h_two07_vbe_q2_min m_h_two07_ic_q1_max
  print m_h_two07_ic_q1_min m_h_two07_ic_q2_max m_h_two07_ic_q2_min
  * run h_two08: two-tone, available power -48 dBm per tone
  alterparam fq1 = 20900000000.0
  alterparam fq2 = 21000000000.0
  alterparam va1 = 0.00251785082358833
  alterparam va2 = 0.00251785082358833
  reset
  save all @q.xdut.xq1.qnpn13g2[ic] @q.xdut.xq2.qnpn13g2[ic]
  tran 5e-13 6e-08 0 5e-13
  linearize v(p2) v(xdut.c1) v(xdut.e1) v(xdut.oc) v(xdut.b1) v(xdut.b2) @q.xdut.xq1.qnpn13g2[ic] @q.xdut.xq2.qnpn13g2[ic]
  let tt = time[80000,119999]
  let xo = v(p2)[80000,119999]
  let m_h_two08_n = length(xo)
  let m_h_two08_t0 = tt[0]
  let m_h_two08_t1 = tt[39999]
  let m_h_two08_f1_c = 2*mean(xo*cos(2*pi*20900000000.0*tt))
  let m_h_two08_f1_s = 2*mean(xo*sin(2*pi*20900000000.0*tt))
  let m_h_two08_f2_c = 2*mean(xo*cos(2*pi*21000000000.0*tt))
  let m_h_two08_f2_s = 2*mean(xo*sin(2*pi*21000000000.0*tt))
  let m_h_two08_im3l_c = 2*mean(xo*cos(2*pi*20800000000.0*tt))
  let m_h_two08_im3l_s = 2*mean(xo*sin(2*pi*20800000000.0*tt))
  let m_h_two08_im3h_c = 2*mean(xo*cos(2*pi*21100000000.0*tt))
  let m_h_two08_im3h_s = 2*mean(xo*sin(2*pi*21100000000.0*tt))
  let m_h_two08_fl_lo_c = 2*mean(xo*cos(2*pi*20750000000.0*tt))
  let m_h_two08_fl_lo_s = 2*mean(xo*sin(2*pi*20750000000.0*tt))
  let m_h_two08_fl_hi_c = 2*mean(xo*cos(2*pi*21150000000.0*tt))
  let m_h_two08_fl_hi_s = 2*mean(xo*sin(2*pi*21150000000.0*tt))
  let m_h_two08_vce_q1_max = maximum(v(xdut.c1)[80000,119999] - v(xdut.e1)[80000,119999])
  let m_h_two08_vce_q1_min = minimum(v(xdut.c1)[80000,119999] - v(xdut.e1)[80000,119999])
  let m_h_two08_vce_q2_max = maximum(v(xdut.oc)[80000,119999] - v(xdut.c1)[80000,119999])
  let m_h_two08_vce_q2_min = minimum(v(xdut.oc)[80000,119999] - v(xdut.c1)[80000,119999])
  let m_h_two08_vbe_q1_max = maximum(v(xdut.b1)[80000,119999] - v(xdut.e1)[80000,119999])
  let m_h_two08_vbe_q1_min = minimum(v(xdut.b1)[80000,119999] - v(xdut.e1)[80000,119999])
  let m_h_two08_vbe_q2_max = maximum(v(xdut.b2)[80000,119999] - v(xdut.c1)[80000,119999])
  let m_h_two08_vbe_q2_min = minimum(v(xdut.b2)[80000,119999] - v(xdut.c1)[80000,119999])
  let w_h_two08_ic_q1 = @q.xdut.xq1.qnpn13g2[ic][80000,119999]
  let m_h_two08_ic_q1_max = maximum(w_h_two08_ic_q1)
  let m_h_two08_ic_q1_min = minimum(w_h_two08_ic_q1)
  let w_h_two08_ic_q2 = @q.xdut.xq2.qnpn13g2[ic][80000,119999]
  let m_h_two08_ic_q2_max = maximum(w_h_two08_ic_q2)
  let m_h_two08_ic_q2_min = minimum(w_h_two08_ic_q2)
  print m_h_two08_n m_h_two08_t0 m_h_two08_t1 m_h_two08_f1_c m_h_two08_f1_s m_h_two08_f2_c
  print m_h_two08_f2_s m_h_two08_im3l_c m_h_two08_im3l_s m_h_two08_im3h_c m_h_two08_im3h_s m_h_two08_fl_lo_c
  print m_h_two08_fl_lo_s m_h_two08_fl_hi_c m_h_two08_fl_hi_s m_h_two08_vce_q1_max m_h_two08_vce_q1_min m_h_two08_vce_q2_max
  print m_h_two08_vce_q2_min m_h_two08_vbe_q1_max m_h_two08_vbe_q1_min m_h_two08_vbe_q2_max m_h_two08_vbe_q2_min m_h_two08_ic_q1_max
  print m_h_two08_ic_q1_min m_h_two08_ic_q2_max m_h_two08_ic_q2_min
  * run h_two09: two-tone, available power -47 dBm per tone
  alterparam fq1 = 20900000000.0
  alterparam fq2 = 21000000000.0
  alterparam va1 = 0.00282507508924551
  alterparam va2 = 0.00282507508924551
  reset
  save all @q.xdut.xq1.qnpn13g2[ic] @q.xdut.xq2.qnpn13g2[ic]
  tran 5e-13 6e-08 0 5e-13
  linearize v(p2) v(xdut.c1) v(xdut.e1) v(xdut.oc) v(xdut.b1) v(xdut.b2) @q.xdut.xq1.qnpn13g2[ic] @q.xdut.xq2.qnpn13g2[ic]
  let tt = time[80000,119999]
  let xo = v(p2)[80000,119999]
  let m_h_two09_n = length(xo)
  let m_h_two09_t0 = tt[0]
  let m_h_two09_t1 = tt[39999]
  let m_h_two09_f1_c = 2*mean(xo*cos(2*pi*20900000000.0*tt))
  let m_h_two09_f1_s = 2*mean(xo*sin(2*pi*20900000000.0*tt))
  let m_h_two09_f2_c = 2*mean(xo*cos(2*pi*21000000000.0*tt))
  let m_h_two09_f2_s = 2*mean(xo*sin(2*pi*21000000000.0*tt))
  let m_h_two09_im3l_c = 2*mean(xo*cos(2*pi*20800000000.0*tt))
  let m_h_two09_im3l_s = 2*mean(xo*sin(2*pi*20800000000.0*tt))
  let m_h_two09_im3h_c = 2*mean(xo*cos(2*pi*21100000000.0*tt))
  let m_h_two09_im3h_s = 2*mean(xo*sin(2*pi*21100000000.0*tt))
  let m_h_two09_fl_lo_c = 2*mean(xo*cos(2*pi*20750000000.0*tt))
  let m_h_two09_fl_lo_s = 2*mean(xo*sin(2*pi*20750000000.0*tt))
  let m_h_two09_fl_hi_c = 2*mean(xo*cos(2*pi*21150000000.0*tt))
  let m_h_two09_fl_hi_s = 2*mean(xo*sin(2*pi*21150000000.0*tt))
  let m_h_two09_vce_q1_max = maximum(v(xdut.c1)[80000,119999] - v(xdut.e1)[80000,119999])
  let m_h_two09_vce_q1_min = minimum(v(xdut.c1)[80000,119999] - v(xdut.e1)[80000,119999])
  let m_h_two09_vce_q2_max = maximum(v(xdut.oc)[80000,119999] - v(xdut.c1)[80000,119999])
  let m_h_two09_vce_q2_min = minimum(v(xdut.oc)[80000,119999] - v(xdut.c1)[80000,119999])
  let m_h_two09_vbe_q1_max = maximum(v(xdut.b1)[80000,119999] - v(xdut.e1)[80000,119999])
  let m_h_two09_vbe_q1_min = minimum(v(xdut.b1)[80000,119999] - v(xdut.e1)[80000,119999])
  let m_h_two09_vbe_q2_max = maximum(v(xdut.b2)[80000,119999] - v(xdut.c1)[80000,119999])
  let m_h_two09_vbe_q2_min = minimum(v(xdut.b2)[80000,119999] - v(xdut.c1)[80000,119999])
  let w_h_two09_ic_q1 = @q.xdut.xq1.qnpn13g2[ic][80000,119999]
  let m_h_two09_ic_q1_max = maximum(w_h_two09_ic_q1)
  let m_h_two09_ic_q1_min = minimum(w_h_two09_ic_q1)
  let w_h_two09_ic_q2 = @q.xdut.xq2.qnpn13g2[ic][80000,119999]
  let m_h_two09_ic_q2_max = maximum(w_h_two09_ic_q2)
  let m_h_two09_ic_q2_min = minimum(w_h_two09_ic_q2)
  print m_h_two09_n m_h_two09_t0 m_h_two09_t1 m_h_two09_f1_c m_h_two09_f1_s m_h_two09_f2_c
  print m_h_two09_f2_s m_h_two09_im3l_c m_h_two09_im3l_s m_h_two09_im3h_c m_h_two09_im3h_s m_h_two09_fl_lo_c
  print m_h_two09_fl_lo_s m_h_two09_fl_hi_c m_h_two09_fl_hi_s m_h_two09_vce_q1_max m_h_two09_vce_q1_min m_h_two09_vce_q2_max
  print m_h_two09_vce_q2_min m_h_two09_vbe_q1_max m_h_two09_vbe_q1_min m_h_two09_vbe_q2_max m_h_two09_vbe_q2_min m_h_two09_ic_q1_max
  print m_h_two09_ic_q1_min m_h_two09_ic_q2_max m_h_two09_ic_q2_min
  * run h_two10: two-tone, available power -46 dBm per tone
  alterparam fq1 = 20900000000.0
  alterparam fq2 = 21000000000.0
  alterparam va1 = 0.00316978638492223
  alterparam va2 = 0.00316978638492223
  reset
  save all @q.xdut.xq1.qnpn13g2[ic] @q.xdut.xq2.qnpn13g2[ic]
  tran 5e-13 6e-08 0 5e-13
  linearize v(p2) v(xdut.c1) v(xdut.e1) v(xdut.oc) v(xdut.b1) v(xdut.b2) @q.xdut.xq1.qnpn13g2[ic] @q.xdut.xq2.qnpn13g2[ic]
  let tt = time[80000,119999]
  let xo = v(p2)[80000,119999]
  let m_h_two10_n = length(xo)
  let m_h_two10_t0 = tt[0]
  let m_h_two10_t1 = tt[39999]
  let m_h_two10_f1_c = 2*mean(xo*cos(2*pi*20900000000.0*tt))
  let m_h_two10_f1_s = 2*mean(xo*sin(2*pi*20900000000.0*tt))
  let m_h_two10_f2_c = 2*mean(xo*cos(2*pi*21000000000.0*tt))
  let m_h_two10_f2_s = 2*mean(xo*sin(2*pi*21000000000.0*tt))
  let m_h_two10_im3l_c = 2*mean(xo*cos(2*pi*20800000000.0*tt))
  let m_h_two10_im3l_s = 2*mean(xo*sin(2*pi*20800000000.0*tt))
  let m_h_two10_im3h_c = 2*mean(xo*cos(2*pi*21100000000.0*tt))
  let m_h_two10_im3h_s = 2*mean(xo*sin(2*pi*21100000000.0*tt))
  let m_h_two10_fl_lo_c = 2*mean(xo*cos(2*pi*20750000000.0*tt))
  let m_h_two10_fl_lo_s = 2*mean(xo*sin(2*pi*20750000000.0*tt))
  let m_h_two10_fl_hi_c = 2*mean(xo*cos(2*pi*21150000000.0*tt))
  let m_h_two10_fl_hi_s = 2*mean(xo*sin(2*pi*21150000000.0*tt))
  let m_h_two10_vce_q1_max = maximum(v(xdut.c1)[80000,119999] - v(xdut.e1)[80000,119999])
  let m_h_two10_vce_q1_min = minimum(v(xdut.c1)[80000,119999] - v(xdut.e1)[80000,119999])
  let m_h_two10_vce_q2_max = maximum(v(xdut.oc)[80000,119999] - v(xdut.c1)[80000,119999])
  let m_h_two10_vce_q2_min = minimum(v(xdut.oc)[80000,119999] - v(xdut.c1)[80000,119999])
  let m_h_two10_vbe_q1_max = maximum(v(xdut.b1)[80000,119999] - v(xdut.e1)[80000,119999])
  let m_h_two10_vbe_q1_min = minimum(v(xdut.b1)[80000,119999] - v(xdut.e1)[80000,119999])
  let m_h_two10_vbe_q2_max = maximum(v(xdut.b2)[80000,119999] - v(xdut.c1)[80000,119999])
  let m_h_two10_vbe_q2_min = minimum(v(xdut.b2)[80000,119999] - v(xdut.c1)[80000,119999])
  let w_h_two10_ic_q1 = @q.xdut.xq1.qnpn13g2[ic][80000,119999]
  let m_h_two10_ic_q1_max = maximum(w_h_two10_ic_q1)
  let m_h_two10_ic_q1_min = minimum(w_h_two10_ic_q1)
  let w_h_two10_ic_q2 = @q.xdut.xq2.qnpn13g2[ic][80000,119999]
  let m_h_two10_ic_q2_max = maximum(w_h_two10_ic_q2)
  let m_h_two10_ic_q2_min = minimum(w_h_two10_ic_q2)
  print m_h_two10_n m_h_two10_t0 m_h_two10_t1 m_h_two10_f1_c m_h_two10_f1_s m_h_two10_f2_c
  print m_h_two10_f2_s m_h_two10_im3l_c m_h_two10_im3l_s m_h_two10_im3h_c m_h_two10_im3h_s m_h_two10_fl_lo_c
  print m_h_two10_fl_lo_s m_h_two10_fl_hi_c m_h_two10_fl_hi_s m_h_two10_vce_q1_max m_h_two10_vce_q1_min m_h_two10_vce_q2_max
  print m_h_two10_vce_q2_min m_h_two10_vbe_q1_max m_h_two10_vbe_q1_min m_h_two10_vbe_q2_max m_h_two10_vbe_q2_min m_h_two10_ic_q1_max
  print m_h_two10_ic_q1_min m_h_two10_ic_q2_max m_h_two10_ic_q2_min
  * run h_two11: two-tone, available power -45 dBm per tone
  alterparam fq1 = 20900000000.0
  alterparam fq2 = 21000000000.0
  alterparam va1 = 0.00355655882007785
  alterparam va2 = 0.00355655882007785
  reset
  save all @q.xdut.xq1.qnpn13g2[ic] @q.xdut.xq2.qnpn13g2[ic]
  tran 5e-13 6e-08 0 5e-13
  linearize v(p2) v(xdut.c1) v(xdut.e1) v(xdut.oc) v(xdut.b1) v(xdut.b2) @q.xdut.xq1.qnpn13g2[ic] @q.xdut.xq2.qnpn13g2[ic]
  let tt = time[80000,119999]
  let xo = v(p2)[80000,119999]
  let m_h_two11_n = length(xo)
  let m_h_two11_t0 = tt[0]
  let m_h_two11_t1 = tt[39999]
  let m_h_two11_f1_c = 2*mean(xo*cos(2*pi*20900000000.0*tt))
  let m_h_two11_f1_s = 2*mean(xo*sin(2*pi*20900000000.0*tt))
  let m_h_two11_f2_c = 2*mean(xo*cos(2*pi*21000000000.0*tt))
  let m_h_two11_f2_s = 2*mean(xo*sin(2*pi*21000000000.0*tt))
  let m_h_two11_im3l_c = 2*mean(xo*cos(2*pi*20800000000.0*tt))
  let m_h_two11_im3l_s = 2*mean(xo*sin(2*pi*20800000000.0*tt))
  let m_h_two11_im3h_c = 2*mean(xo*cos(2*pi*21100000000.0*tt))
  let m_h_two11_im3h_s = 2*mean(xo*sin(2*pi*21100000000.0*tt))
  let m_h_two11_fl_lo_c = 2*mean(xo*cos(2*pi*20750000000.0*tt))
  let m_h_two11_fl_lo_s = 2*mean(xo*sin(2*pi*20750000000.0*tt))
  let m_h_two11_fl_hi_c = 2*mean(xo*cos(2*pi*21150000000.0*tt))
  let m_h_two11_fl_hi_s = 2*mean(xo*sin(2*pi*21150000000.0*tt))
  let m_h_two11_vce_q1_max = maximum(v(xdut.c1)[80000,119999] - v(xdut.e1)[80000,119999])
  let m_h_two11_vce_q1_min = minimum(v(xdut.c1)[80000,119999] - v(xdut.e1)[80000,119999])
  let m_h_two11_vce_q2_max = maximum(v(xdut.oc)[80000,119999] - v(xdut.c1)[80000,119999])
  let m_h_two11_vce_q2_min = minimum(v(xdut.oc)[80000,119999] - v(xdut.c1)[80000,119999])
  let m_h_two11_vbe_q1_max = maximum(v(xdut.b1)[80000,119999] - v(xdut.e1)[80000,119999])
  let m_h_two11_vbe_q1_min = minimum(v(xdut.b1)[80000,119999] - v(xdut.e1)[80000,119999])
  let m_h_two11_vbe_q2_max = maximum(v(xdut.b2)[80000,119999] - v(xdut.c1)[80000,119999])
  let m_h_two11_vbe_q2_min = minimum(v(xdut.b2)[80000,119999] - v(xdut.c1)[80000,119999])
  let w_h_two11_ic_q1 = @q.xdut.xq1.qnpn13g2[ic][80000,119999]
  let m_h_two11_ic_q1_max = maximum(w_h_two11_ic_q1)
  let m_h_two11_ic_q1_min = minimum(w_h_two11_ic_q1)
  let w_h_two11_ic_q2 = @q.xdut.xq2.qnpn13g2[ic][80000,119999]
  let m_h_two11_ic_q2_max = maximum(w_h_two11_ic_q2)
  let m_h_two11_ic_q2_min = minimum(w_h_two11_ic_q2)
  print m_h_two11_n m_h_two11_t0 m_h_two11_t1 m_h_two11_f1_c m_h_two11_f1_s m_h_two11_f2_c
  print m_h_two11_f2_s m_h_two11_im3l_c m_h_two11_im3l_s m_h_two11_im3h_c m_h_two11_im3h_s m_h_two11_fl_lo_c
  print m_h_two11_fl_lo_s m_h_two11_fl_hi_c m_h_two11_fl_hi_s m_h_two11_vce_q1_max m_h_two11_vce_q1_min m_h_two11_vce_q2_max
  print m_h_two11_vce_q2_min m_h_two11_vbe_q1_max m_h_two11_vbe_q1_min m_h_two11_vbe_q2_max m_h_two11_vbe_q2_min m_h_two11_ic_q1_max
  print m_h_two11_ic_q1_min m_h_two11_ic_q2_max m_h_two11_ic_q2_min
  * run h_two12: two-tone, available power -44 dBm per tone
  alterparam fq1 = 20900000000.0
  alterparam fq2 = 21000000000.0
  alterparam va1 = 0.00399052462993776
  alterparam va2 = 0.00399052462993776
  reset
  save all @q.xdut.xq1.qnpn13g2[ic] @q.xdut.xq2.qnpn13g2[ic]
  tran 5e-13 6e-08 0 5e-13
  linearize v(p2) v(xdut.c1) v(xdut.e1) v(xdut.oc) v(xdut.b1) v(xdut.b2) @q.xdut.xq1.qnpn13g2[ic] @q.xdut.xq2.qnpn13g2[ic]
  let tt = time[80000,119999]
  let xo = v(p2)[80000,119999]
  let m_h_two12_n = length(xo)
  let m_h_two12_t0 = tt[0]
  let m_h_two12_t1 = tt[39999]
  let m_h_two12_f1_c = 2*mean(xo*cos(2*pi*20900000000.0*tt))
  let m_h_two12_f1_s = 2*mean(xo*sin(2*pi*20900000000.0*tt))
  let m_h_two12_f2_c = 2*mean(xo*cos(2*pi*21000000000.0*tt))
  let m_h_two12_f2_s = 2*mean(xo*sin(2*pi*21000000000.0*tt))
  let m_h_two12_im3l_c = 2*mean(xo*cos(2*pi*20800000000.0*tt))
  let m_h_two12_im3l_s = 2*mean(xo*sin(2*pi*20800000000.0*tt))
  let m_h_two12_im3h_c = 2*mean(xo*cos(2*pi*21100000000.0*tt))
  let m_h_two12_im3h_s = 2*mean(xo*sin(2*pi*21100000000.0*tt))
  let m_h_two12_fl_lo_c = 2*mean(xo*cos(2*pi*20750000000.0*tt))
  let m_h_two12_fl_lo_s = 2*mean(xo*sin(2*pi*20750000000.0*tt))
  let m_h_two12_fl_hi_c = 2*mean(xo*cos(2*pi*21150000000.0*tt))
  let m_h_two12_fl_hi_s = 2*mean(xo*sin(2*pi*21150000000.0*tt))
  let m_h_two12_vce_q1_max = maximum(v(xdut.c1)[80000,119999] - v(xdut.e1)[80000,119999])
  let m_h_two12_vce_q1_min = minimum(v(xdut.c1)[80000,119999] - v(xdut.e1)[80000,119999])
  let m_h_two12_vce_q2_max = maximum(v(xdut.oc)[80000,119999] - v(xdut.c1)[80000,119999])
  let m_h_two12_vce_q2_min = minimum(v(xdut.oc)[80000,119999] - v(xdut.c1)[80000,119999])
  let m_h_two12_vbe_q1_max = maximum(v(xdut.b1)[80000,119999] - v(xdut.e1)[80000,119999])
  let m_h_two12_vbe_q1_min = minimum(v(xdut.b1)[80000,119999] - v(xdut.e1)[80000,119999])
  let m_h_two12_vbe_q2_max = maximum(v(xdut.b2)[80000,119999] - v(xdut.c1)[80000,119999])
  let m_h_two12_vbe_q2_min = minimum(v(xdut.b2)[80000,119999] - v(xdut.c1)[80000,119999])
  let w_h_two12_ic_q1 = @q.xdut.xq1.qnpn13g2[ic][80000,119999]
  let m_h_two12_ic_q1_max = maximum(w_h_two12_ic_q1)
  let m_h_two12_ic_q1_min = minimum(w_h_two12_ic_q1)
  let w_h_two12_ic_q2 = @q.xdut.xq2.qnpn13g2[ic][80000,119999]
  let m_h_two12_ic_q2_max = maximum(w_h_two12_ic_q2)
  let m_h_two12_ic_q2_min = minimum(w_h_two12_ic_q2)
  print m_h_two12_n m_h_two12_t0 m_h_two12_t1 m_h_two12_f1_c m_h_two12_f1_s m_h_two12_f2_c
  print m_h_two12_f2_s m_h_two12_im3l_c m_h_two12_im3l_s m_h_two12_im3h_c m_h_two12_im3h_s m_h_two12_fl_lo_c
  print m_h_two12_fl_lo_s m_h_two12_fl_hi_c m_h_two12_fl_hi_s m_h_two12_vce_q1_max m_h_two12_vce_q1_min m_h_two12_vce_q2_max
  print m_h_two12_vce_q2_min m_h_two12_vbe_q1_max m_h_two12_vbe_q1_min m_h_two12_vbe_q2_max m_h_two12_vbe_q2_min m_h_two12_ic_q1_max
  print m_h_two12_ic_q1_min m_h_two12_ic_q2_max m_h_two12_ic_q2_min
  * run h_two13: two-tone, available power -43 dBm per tone
  alterparam fq1 = 20900000000.0
  alterparam fq2 = 21000000000.0
  alterparam va1 = 0.00447744227713668
  alterparam va2 = 0.00447744227713668
  reset
  save all @q.xdut.xq1.qnpn13g2[ic] @q.xdut.xq2.qnpn13g2[ic]
  tran 5e-13 6e-08 0 5e-13
  linearize v(p2) v(xdut.c1) v(xdut.e1) v(xdut.oc) v(xdut.b1) v(xdut.b2) @q.xdut.xq1.qnpn13g2[ic] @q.xdut.xq2.qnpn13g2[ic]
  let tt = time[80000,119999]
  let xo = v(p2)[80000,119999]
  let m_h_two13_n = length(xo)
  let m_h_two13_t0 = tt[0]
  let m_h_two13_t1 = tt[39999]
  let m_h_two13_f1_c = 2*mean(xo*cos(2*pi*20900000000.0*tt))
  let m_h_two13_f1_s = 2*mean(xo*sin(2*pi*20900000000.0*tt))
  let m_h_two13_f2_c = 2*mean(xo*cos(2*pi*21000000000.0*tt))
  let m_h_two13_f2_s = 2*mean(xo*sin(2*pi*21000000000.0*tt))
  let m_h_two13_im3l_c = 2*mean(xo*cos(2*pi*20800000000.0*tt))
  let m_h_two13_im3l_s = 2*mean(xo*sin(2*pi*20800000000.0*tt))
  let m_h_two13_im3h_c = 2*mean(xo*cos(2*pi*21100000000.0*tt))
  let m_h_two13_im3h_s = 2*mean(xo*sin(2*pi*21100000000.0*tt))
  let m_h_two13_fl_lo_c = 2*mean(xo*cos(2*pi*20750000000.0*tt))
  let m_h_two13_fl_lo_s = 2*mean(xo*sin(2*pi*20750000000.0*tt))
  let m_h_two13_fl_hi_c = 2*mean(xo*cos(2*pi*21150000000.0*tt))
  let m_h_two13_fl_hi_s = 2*mean(xo*sin(2*pi*21150000000.0*tt))
  let m_h_two13_vce_q1_max = maximum(v(xdut.c1)[80000,119999] - v(xdut.e1)[80000,119999])
  let m_h_two13_vce_q1_min = minimum(v(xdut.c1)[80000,119999] - v(xdut.e1)[80000,119999])
  let m_h_two13_vce_q2_max = maximum(v(xdut.oc)[80000,119999] - v(xdut.c1)[80000,119999])
  let m_h_two13_vce_q2_min = minimum(v(xdut.oc)[80000,119999] - v(xdut.c1)[80000,119999])
  let m_h_two13_vbe_q1_max = maximum(v(xdut.b1)[80000,119999] - v(xdut.e1)[80000,119999])
  let m_h_two13_vbe_q1_min = minimum(v(xdut.b1)[80000,119999] - v(xdut.e1)[80000,119999])
  let m_h_two13_vbe_q2_max = maximum(v(xdut.b2)[80000,119999] - v(xdut.c1)[80000,119999])
  let m_h_two13_vbe_q2_min = minimum(v(xdut.b2)[80000,119999] - v(xdut.c1)[80000,119999])
  let w_h_two13_ic_q1 = @q.xdut.xq1.qnpn13g2[ic][80000,119999]
  let m_h_two13_ic_q1_max = maximum(w_h_two13_ic_q1)
  let m_h_two13_ic_q1_min = minimum(w_h_two13_ic_q1)
  let w_h_two13_ic_q2 = @q.xdut.xq2.qnpn13g2[ic][80000,119999]
  let m_h_two13_ic_q2_max = maximum(w_h_two13_ic_q2)
  let m_h_two13_ic_q2_min = minimum(w_h_two13_ic_q2)
  print m_h_two13_n m_h_two13_t0 m_h_two13_t1 m_h_two13_f1_c m_h_two13_f1_s m_h_two13_f2_c
  print m_h_two13_f2_s m_h_two13_im3l_c m_h_two13_im3l_s m_h_two13_im3h_c m_h_two13_im3h_s m_h_two13_fl_lo_c
  print m_h_two13_fl_lo_s m_h_two13_fl_hi_c m_h_two13_fl_hi_s m_h_two13_vce_q1_max m_h_two13_vce_q1_min m_h_two13_vce_q2_max
  print m_h_two13_vce_q2_min m_h_two13_vbe_q1_max m_h_two13_vbe_q1_min m_h_two13_vbe_q2_max m_h_two13_vbe_q2_min m_h_two13_ic_q1_max
  print m_h_two13_ic_q1_min m_h_two13_ic_q2_max m_h_two13_ic_q2_min
  * run h_two14: two-tone, available power -42 dBm per tone
  alterparam fq1 = 20900000000.0
  alterparam fq2 = 21000000000.0
  alterparam va1 = 0.00502377286301916
  alterparam va2 = 0.00502377286301916
  reset
  save all @q.xdut.xq1.qnpn13g2[ic] @q.xdut.xq2.qnpn13g2[ic]
  tran 5e-13 6e-08 0 5e-13
  linearize v(p2) v(xdut.c1) v(xdut.e1) v(xdut.oc) v(xdut.b1) v(xdut.b2) @q.xdut.xq1.qnpn13g2[ic] @q.xdut.xq2.qnpn13g2[ic]
  let tt = time[80000,119999]
  let xo = v(p2)[80000,119999]
  let m_h_two14_n = length(xo)
  let m_h_two14_t0 = tt[0]
  let m_h_two14_t1 = tt[39999]
  let m_h_two14_f1_c = 2*mean(xo*cos(2*pi*20900000000.0*tt))
  let m_h_two14_f1_s = 2*mean(xo*sin(2*pi*20900000000.0*tt))
  let m_h_two14_f2_c = 2*mean(xo*cos(2*pi*21000000000.0*tt))
  let m_h_two14_f2_s = 2*mean(xo*sin(2*pi*21000000000.0*tt))
  let m_h_two14_im3l_c = 2*mean(xo*cos(2*pi*20800000000.0*tt))
  let m_h_two14_im3l_s = 2*mean(xo*sin(2*pi*20800000000.0*tt))
  let m_h_two14_im3h_c = 2*mean(xo*cos(2*pi*21100000000.0*tt))
  let m_h_two14_im3h_s = 2*mean(xo*sin(2*pi*21100000000.0*tt))
  let m_h_two14_fl_lo_c = 2*mean(xo*cos(2*pi*20750000000.0*tt))
  let m_h_two14_fl_lo_s = 2*mean(xo*sin(2*pi*20750000000.0*tt))
  let m_h_two14_fl_hi_c = 2*mean(xo*cos(2*pi*21150000000.0*tt))
  let m_h_two14_fl_hi_s = 2*mean(xo*sin(2*pi*21150000000.0*tt))
  let m_h_two14_vce_q1_max = maximum(v(xdut.c1)[80000,119999] - v(xdut.e1)[80000,119999])
  let m_h_two14_vce_q1_min = minimum(v(xdut.c1)[80000,119999] - v(xdut.e1)[80000,119999])
  let m_h_two14_vce_q2_max = maximum(v(xdut.oc)[80000,119999] - v(xdut.c1)[80000,119999])
  let m_h_two14_vce_q2_min = minimum(v(xdut.oc)[80000,119999] - v(xdut.c1)[80000,119999])
  let m_h_two14_vbe_q1_max = maximum(v(xdut.b1)[80000,119999] - v(xdut.e1)[80000,119999])
  let m_h_two14_vbe_q1_min = minimum(v(xdut.b1)[80000,119999] - v(xdut.e1)[80000,119999])
  let m_h_two14_vbe_q2_max = maximum(v(xdut.b2)[80000,119999] - v(xdut.c1)[80000,119999])
  let m_h_two14_vbe_q2_min = minimum(v(xdut.b2)[80000,119999] - v(xdut.c1)[80000,119999])
  let w_h_two14_ic_q1 = @q.xdut.xq1.qnpn13g2[ic][80000,119999]
  let m_h_two14_ic_q1_max = maximum(w_h_two14_ic_q1)
  let m_h_two14_ic_q1_min = minimum(w_h_two14_ic_q1)
  let w_h_two14_ic_q2 = @q.xdut.xq2.qnpn13g2[ic][80000,119999]
  let m_h_two14_ic_q2_max = maximum(w_h_two14_ic_q2)
  let m_h_two14_ic_q2_min = minimum(w_h_two14_ic_q2)
  print m_h_two14_n m_h_two14_t0 m_h_two14_t1 m_h_two14_f1_c m_h_two14_f1_s m_h_two14_f2_c
  print m_h_two14_f2_s m_h_two14_im3l_c m_h_two14_im3l_s m_h_two14_im3h_c m_h_two14_im3h_s m_h_two14_fl_lo_c
  print m_h_two14_fl_lo_s m_h_two14_fl_hi_c m_h_two14_fl_hi_s m_h_two14_vce_q1_max m_h_two14_vce_q1_min m_h_two14_vce_q2_max
  print m_h_two14_vce_q2_min m_h_two14_vbe_q1_max m_h_two14_vbe_q1_min m_h_two14_vbe_q2_max m_h_two14_vbe_q2_min m_h_two14_ic_q1_max
  print m_h_two14_ic_q1_min m_h_two14_ic_q2_max m_h_two14_ic_q2_min
  * run h_two15: two-tone, available power -41 dBm per tone
  alterparam fq1 = 20900000000.0
  alterparam fq2 = 21000000000.0
  alterparam va1 = 0.00563676586252891
  alterparam va2 = 0.00563676586252891
  reset
  save all @q.xdut.xq1.qnpn13g2[ic] @q.xdut.xq2.qnpn13g2[ic]
  tran 5e-13 6e-08 0 5e-13
  linearize v(p2) v(xdut.c1) v(xdut.e1) v(xdut.oc) v(xdut.b1) v(xdut.b2) @q.xdut.xq1.qnpn13g2[ic] @q.xdut.xq2.qnpn13g2[ic]
  let tt = time[80000,119999]
  let xo = v(p2)[80000,119999]
  let m_h_two15_n = length(xo)
  let m_h_two15_t0 = tt[0]
  let m_h_two15_t1 = tt[39999]
  let m_h_two15_f1_c = 2*mean(xo*cos(2*pi*20900000000.0*tt))
  let m_h_two15_f1_s = 2*mean(xo*sin(2*pi*20900000000.0*tt))
  let m_h_two15_f2_c = 2*mean(xo*cos(2*pi*21000000000.0*tt))
  let m_h_two15_f2_s = 2*mean(xo*sin(2*pi*21000000000.0*tt))
  let m_h_two15_im3l_c = 2*mean(xo*cos(2*pi*20800000000.0*tt))
  let m_h_two15_im3l_s = 2*mean(xo*sin(2*pi*20800000000.0*tt))
  let m_h_two15_im3h_c = 2*mean(xo*cos(2*pi*21100000000.0*tt))
  let m_h_two15_im3h_s = 2*mean(xo*sin(2*pi*21100000000.0*tt))
  let m_h_two15_fl_lo_c = 2*mean(xo*cos(2*pi*20750000000.0*tt))
  let m_h_two15_fl_lo_s = 2*mean(xo*sin(2*pi*20750000000.0*tt))
  let m_h_two15_fl_hi_c = 2*mean(xo*cos(2*pi*21150000000.0*tt))
  let m_h_two15_fl_hi_s = 2*mean(xo*sin(2*pi*21150000000.0*tt))
  let m_h_two15_vce_q1_max = maximum(v(xdut.c1)[80000,119999] - v(xdut.e1)[80000,119999])
  let m_h_two15_vce_q1_min = minimum(v(xdut.c1)[80000,119999] - v(xdut.e1)[80000,119999])
  let m_h_two15_vce_q2_max = maximum(v(xdut.oc)[80000,119999] - v(xdut.c1)[80000,119999])
  let m_h_two15_vce_q2_min = minimum(v(xdut.oc)[80000,119999] - v(xdut.c1)[80000,119999])
  let m_h_two15_vbe_q1_max = maximum(v(xdut.b1)[80000,119999] - v(xdut.e1)[80000,119999])
  let m_h_two15_vbe_q1_min = minimum(v(xdut.b1)[80000,119999] - v(xdut.e1)[80000,119999])
  let m_h_two15_vbe_q2_max = maximum(v(xdut.b2)[80000,119999] - v(xdut.c1)[80000,119999])
  let m_h_two15_vbe_q2_min = minimum(v(xdut.b2)[80000,119999] - v(xdut.c1)[80000,119999])
  let w_h_two15_ic_q1 = @q.xdut.xq1.qnpn13g2[ic][80000,119999]
  let m_h_two15_ic_q1_max = maximum(w_h_two15_ic_q1)
  let m_h_two15_ic_q1_min = minimum(w_h_two15_ic_q1)
  let w_h_two15_ic_q2 = @q.xdut.xq2.qnpn13g2[ic][80000,119999]
  let m_h_two15_ic_q2_max = maximum(w_h_two15_ic_q2)
  let m_h_two15_ic_q2_min = minimum(w_h_two15_ic_q2)
  print m_h_two15_n m_h_two15_t0 m_h_two15_t1 m_h_two15_f1_c m_h_two15_f1_s m_h_two15_f2_c
  print m_h_two15_f2_s m_h_two15_im3l_c m_h_two15_im3l_s m_h_two15_im3h_c m_h_two15_im3h_s m_h_two15_fl_lo_c
  print m_h_two15_fl_lo_s m_h_two15_fl_hi_c m_h_two15_fl_hi_s m_h_two15_vce_q1_max m_h_two15_vce_q1_min m_h_two15_vce_q2_max
  print m_h_two15_vce_q2_min m_h_two15_vbe_q1_max m_h_two15_vbe_q1_min m_h_two15_vbe_q2_max m_h_two15_vbe_q2_min m_h_two15_ic_q1_max
  print m_h_two15_ic_q1_min m_h_two15_ic_q2_max m_h_two15_ic_q2_min
  * run h_two16: two-tone, available power -40 dBm per tone
  alterparam fq1 = 20900000000.0
  alterparam fq2 = 21000000000.0
  alterparam va1 = 0.00632455532033676
  alterparam va2 = 0.00632455532033676
  reset
  save all @q.xdut.xq1.qnpn13g2[ic] @q.xdut.xq2.qnpn13g2[ic]
  tran 5e-13 6e-08 0 5e-13
  linearize v(p2) v(xdut.c1) v(xdut.e1) v(xdut.oc) v(xdut.b1) v(xdut.b2) @q.xdut.xq1.qnpn13g2[ic] @q.xdut.xq2.qnpn13g2[ic]
  let tt = time[80000,119999]
  let xo = v(p2)[80000,119999]
  let m_h_two16_n = length(xo)
  let m_h_two16_t0 = tt[0]
  let m_h_two16_t1 = tt[39999]
  let m_h_two16_f1_c = 2*mean(xo*cos(2*pi*20900000000.0*tt))
  let m_h_two16_f1_s = 2*mean(xo*sin(2*pi*20900000000.0*tt))
  let m_h_two16_f2_c = 2*mean(xo*cos(2*pi*21000000000.0*tt))
  let m_h_two16_f2_s = 2*mean(xo*sin(2*pi*21000000000.0*tt))
  let m_h_two16_im3l_c = 2*mean(xo*cos(2*pi*20800000000.0*tt))
  let m_h_two16_im3l_s = 2*mean(xo*sin(2*pi*20800000000.0*tt))
  let m_h_two16_im3h_c = 2*mean(xo*cos(2*pi*21100000000.0*tt))
  let m_h_two16_im3h_s = 2*mean(xo*sin(2*pi*21100000000.0*tt))
  let m_h_two16_fl_lo_c = 2*mean(xo*cos(2*pi*20750000000.0*tt))
  let m_h_two16_fl_lo_s = 2*mean(xo*sin(2*pi*20750000000.0*tt))
  let m_h_two16_fl_hi_c = 2*mean(xo*cos(2*pi*21150000000.0*tt))
  let m_h_two16_fl_hi_s = 2*mean(xo*sin(2*pi*21150000000.0*tt))
  let m_h_two16_vce_q1_max = maximum(v(xdut.c1)[80000,119999] - v(xdut.e1)[80000,119999])
  let m_h_two16_vce_q1_min = minimum(v(xdut.c1)[80000,119999] - v(xdut.e1)[80000,119999])
  let m_h_two16_vce_q2_max = maximum(v(xdut.oc)[80000,119999] - v(xdut.c1)[80000,119999])
  let m_h_two16_vce_q2_min = minimum(v(xdut.oc)[80000,119999] - v(xdut.c1)[80000,119999])
  let m_h_two16_vbe_q1_max = maximum(v(xdut.b1)[80000,119999] - v(xdut.e1)[80000,119999])
  let m_h_two16_vbe_q1_min = minimum(v(xdut.b1)[80000,119999] - v(xdut.e1)[80000,119999])
  let m_h_two16_vbe_q2_max = maximum(v(xdut.b2)[80000,119999] - v(xdut.c1)[80000,119999])
  let m_h_two16_vbe_q2_min = minimum(v(xdut.b2)[80000,119999] - v(xdut.c1)[80000,119999])
  let w_h_two16_ic_q1 = @q.xdut.xq1.qnpn13g2[ic][80000,119999]
  let m_h_two16_ic_q1_max = maximum(w_h_two16_ic_q1)
  let m_h_two16_ic_q1_min = minimum(w_h_two16_ic_q1)
  let w_h_two16_ic_q2 = @q.xdut.xq2.qnpn13g2[ic][80000,119999]
  let m_h_two16_ic_q2_max = maximum(w_h_two16_ic_q2)
  let m_h_two16_ic_q2_min = minimum(w_h_two16_ic_q2)
  print m_h_two16_n m_h_two16_t0 m_h_two16_t1 m_h_two16_f1_c m_h_two16_f1_s m_h_two16_f2_c
  print m_h_two16_f2_s m_h_two16_im3l_c m_h_two16_im3l_s m_h_two16_im3h_c m_h_two16_im3h_s m_h_two16_fl_lo_c
  print m_h_two16_fl_lo_s m_h_two16_fl_hi_c m_h_two16_fl_hi_s m_h_two16_vce_q1_max m_h_two16_vce_q1_min m_h_two16_vce_q2_max
  print m_h_two16_vce_q2_min m_h_two16_vbe_q1_max m_h_two16_vbe_q1_min m_h_two16_vbe_q2_max m_h_two16_vbe_q2_min m_h_two16_ic_q1_max
  print m_h_two16_ic_q1_min m_h_two16_ic_q2_max m_h_two16_ic_q2_min
  * run h_two17: two-tone, available power -39 dBm per tone
  alterparam fq1 = 20900000000.0
  alterparam fq2 = 21000000000.0
  alterparam va1 = 0.00709626778467151
  alterparam va2 = 0.00709626778467151
  reset
  save all @q.xdut.xq1.qnpn13g2[ic] @q.xdut.xq2.qnpn13g2[ic]
  tran 5e-13 6e-08 0 5e-13
  linearize v(p2) v(xdut.c1) v(xdut.e1) v(xdut.oc) v(xdut.b1) v(xdut.b2) @q.xdut.xq1.qnpn13g2[ic] @q.xdut.xq2.qnpn13g2[ic]
  let tt = time[80000,119999]
  let xo = v(p2)[80000,119999]
  let m_h_two17_n = length(xo)
  let m_h_two17_t0 = tt[0]
  let m_h_two17_t1 = tt[39999]
  let m_h_two17_f1_c = 2*mean(xo*cos(2*pi*20900000000.0*tt))
  let m_h_two17_f1_s = 2*mean(xo*sin(2*pi*20900000000.0*tt))
  let m_h_two17_f2_c = 2*mean(xo*cos(2*pi*21000000000.0*tt))
  let m_h_two17_f2_s = 2*mean(xo*sin(2*pi*21000000000.0*tt))
  let m_h_two17_im3l_c = 2*mean(xo*cos(2*pi*20800000000.0*tt))
  let m_h_two17_im3l_s = 2*mean(xo*sin(2*pi*20800000000.0*tt))
  let m_h_two17_im3h_c = 2*mean(xo*cos(2*pi*21100000000.0*tt))
  let m_h_two17_im3h_s = 2*mean(xo*sin(2*pi*21100000000.0*tt))
  let m_h_two17_fl_lo_c = 2*mean(xo*cos(2*pi*20750000000.0*tt))
  let m_h_two17_fl_lo_s = 2*mean(xo*sin(2*pi*20750000000.0*tt))
  let m_h_two17_fl_hi_c = 2*mean(xo*cos(2*pi*21150000000.0*tt))
  let m_h_two17_fl_hi_s = 2*mean(xo*sin(2*pi*21150000000.0*tt))
  let m_h_two17_vce_q1_max = maximum(v(xdut.c1)[80000,119999] - v(xdut.e1)[80000,119999])
  let m_h_two17_vce_q1_min = minimum(v(xdut.c1)[80000,119999] - v(xdut.e1)[80000,119999])
  let m_h_two17_vce_q2_max = maximum(v(xdut.oc)[80000,119999] - v(xdut.c1)[80000,119999])
  let m_h_two17_vce_q2_min = minimum(v(xdut.oc)[80000,119999] - v(xdut.c1)[80000,119999])
  let m_h_two17_vbe_q1_max = maximum(v(xdut.b1)[80000,119999] - v(xdut.e1)[80000,119999])
  let m_h_two17_vbe_q1_min = minimum(v(xdut.b1)[80000,119999] - v(xdut.e1)[80000,119999])
  let m_h_two17_vbe_q2_max = maximum(v(xdut.b2)[80000,119999] - v(xdut.c1)[80000,119999])
  let m_h_two17_vbe_q2_min = minimum(v(xdut.b2)[80000,119999] - v(xdut.c1)[80000,119999])
  let w_h_two17_ic_q1 = @q.xdut.xq1.qnpn13g2[ic][80000,119999]
  let m_h_two17_ic_q1_max = maximum(w_h_two17_ic_q1)
  let m_h_two17_ic_q1_min = minimum(w_h_two17_ic_q1)
  let w_h_two17_ic_q2 = @q.xdut.xq2.qnpn13g2[ic][80000,119999]
  let m_h_two17_ic_q2_max = maximum(w_h_two17_ic_q2)
  let m_h_two17_ic_q2_min = minimum(w_h_two17_ic_q2)
  print m_h_two17_n m_h_two17_t0 m_h_two17_t1 m_h_two17_f1_c m_h_two17_f1_s m_h_two17_f2_c
  print m_h_two17_f2_s m_h_two17_im3l_c m_h_two17_im3l_s m_h_two17_im3h_c m_h_two17_im3h_s m_h_two17_fl_lo_c
  print m_h_two17_fl_lo_s m_h_two17_fl_hi_c m_h_two17_fl_hi_s m_h_two17_vce_q1_max m_h_two17_vce_q1_min m_h_two17_vce_q2_max
  print m_h_two17_vce_q2_min m_h_two17_vbe_q1_max m_h_two17_vbe_q1_min m_h_two17_vbe_q2_max m_h_two17_vbe_q2_min m_h_two17_ic_q1_max
  print m_h_two17_ic_q1_min m_h_two17_ic_q2_max m_h_two17_ic_q2_min
  * run h_two18: two-tone, available power -38 dBm per tone
  alterparam fq1 = 20900000000.0
  alterparam fq2 = 21000000000.0
  alterparam va1 = 0.00796214341106995
  alterparam va2 = 0.00796214341106995
  reset
  save all @q.xdut.xq1.qnpn13g2[ic] @q.xdut.xq2.qnpn13g2[ic]
  tran 5e-13 6e-08 0 5e-13
  linearize v(p2) v(xdut.c1) v(xdut.e1) v(xdut.oc) v(xdut.b1) v(xdut.b2) @q.xdut.xq1.qnpn13g2[ic] @q.xdut.xq2.qnpn13g2[ic]
  let tt = time[80000,119999]
  let xo = v(p2)[80000,119999]
  let m_h_two18_n = length(xo)
  let m_h_two18_t0 = tt[0]
  let m_h_two18_t1 = tt[39999]
  let m_h_two18_f1_c = 2*mean(xo*cos(2*pi*20900000000.0*tt))
  let m_h_two18_f1_s = 2*mean(xo*sin(2*pi*20900000000.0*tt))
  let m_h_two18_f2_c = 2*mean(xo*cos(2*pi*21000000000.0*tt))
  let m_h_two18_f2_s = 2*mean(xo*sin(2*pi*21000000000.0*tt))
  let m_h_two18_im3l_c = 2*mean(xo*cos(2*pi*20800000000.0*tt))
  let m_h_two18_im3l_s = 2*mean(xo*sin(2*pi*20800000000.0*tt))
  let m_h_two18_im3h_c = 2*mean(xo*cos(2*pi*21100000000.0*tt))
  let m_h_two18_im3h_s = 2*mean(xo*sin(2*pi*21100000000.0*tt))
  let m_h_two18_fl_lo_c = 2*mean(xo*cos(2*pi*20750000000.0*tt))
  let m_h_two18_fl_lo_s = 2*mean(xo*sin(2*pi*20750000000.0*tt))
  let m_h_two18_fl_hi_c = 2*mean(xo*cos(2*pi*21150000000.0*tt))
  let m_h_two18_fl_hi_s = 2*mean(xo*sin(2*pi*21150000000.0*tt))
  let m_h_two18_vce_q1_max = maximum(v(xdut.c1)[80000,119999] - v(xdut.e1)[80000,119999])
  let m_h_two18_vce_q1_min = minimum(v(xdut.c1)[80000,119999] - v(xdut.e1)[80000,119999])
  let m_h_two18_vce_q2_max = maximum(v(xdut.oc)[80000,119999] - v(xdut.c1)[80000,119999])
  let m_h_two18_vce_q2_min = minimum(v(xdut.oc)[80000,119999] - v(xdut.c1)[80000,119999])
  let m_h_two18_vbe_q1_max = maximum(v(xdut.b1)[80000,119999] - v(xdut.e1)[80000,119999])
  let m_h_two18_vbe_q1_min = minimum(v(xdut.b1)[80000,119999] - v(xdut.e1)[80000,119999])
  let m_h_two18_vbe_q2_max = maximum(v(xdut.b2)[80000,119999] - v(xdut.c1)[80000,119999])
  let m_h_two18_vbe_q2_min = minimum(v(xdut.b2)[80000,119999] - v(xdut.c1)[80000,119999])
  let w_h_two18_ic_q1 = @q.xdut.xq1.qnpn13g2[ic][80000,119999]
  let m_h_two18_ic_q1_max = maximum(w_h_two18_ic_q1)
  let m_h_two18_ic_q1_min = minimum(w_h_two18_ic_q1)
  let w_h_two18_ic_q2 = @q.xdut.xq2.qnpn13g2[ic][80000,119999]
  let m_h_two18_ic_q2_max = maximum(w_h_two18_ic_q2)
  let m_h_two18_ic_q2_min = minimum(w_h_two18_ic_q2)
  print m_h_two18_n m_h_two18_t0 m_h_two18_t1 m_h_two18_f1_c m_h_two18_f1_s m_h_two18_f2_c
  print m_h_two18_f2_s m_h_two18_im3l_c m_h_two18_im3l_s m_h_two18_im3h_c m_h_two18_im3h_s m_h_two18_fl_lo_c
  print m_h_two18_fl_lo_s m_h_two18_fl_hi_c m_h_two18_fl_hi_s m_h_two18_vce_q1_max m_h_two18_vce_q1_min m_h_two18_vce_q2_max
  print m_h_two18_vce_q2_min m_h_two18_vbe_q1_max m_h_two18_vbe_q1_min m_h_two18_vbe_q2_max m_h_two18_vbe_q2_min m_h_two18_ic_q1_max
  print m_h_two18_ic_q1_min m_h_two18_ic_q2_max m_h_two18_ic_q2_min
  * run h_two19: two-tone, available power -37 dBm per tone
  alterparam fq1 = 20900000000.0
  alterparam fq2 = 21000000000.0
  alterparam va1 = 0.00893367184301926
  alterparam va2 = 0.00893367184301926
  reset
  save all @q.xdut.xq1.qnpn13g2[ic] @q.xdut.xq2.qnpn13g2[ic]
  tran 5e-13 6e-08 0 5e-13
  linearize v(p2) v(xdut.c1) v(xdut.e1) v(xdut.oc) v(xdut.b1) v(xdut.b2) @q.xdut.xq1.qnpn13g2[ic] @q.xdut.xq2.qnpn13g2[ic]
  let tt = time[80000,119999]
  let xo = v(p2)[80000,119999]
  let m_h_two19_n = length(xo)
  let m_h_two19_t0 = tt[0]
  let m_h_two19_t1 = tt[39999]
  let m_h_two19_f1_c = 2*mean(xo*cos(2*pi*20900000000.0*tt))
  let m_h_two19_f1_s = 2*mean(xo*sin(2*pi*20900000000.0*tt))
  let m_h_two19_f2_c = 2*mean(xo*cos(2*pi*21000000000.0*tt))
  let m_h_two19_f2_s = 2*mean(xo*sin(2*pi*21000000000.0*tt))
  let m_h_two19_im3l_c = 2*mean(xo*cos(2*pi*20800000000.0*tt))
  let m_h_two19_im3l_s = 2*mean(xo*sin(2*pi*20800000000.0*tt))
  let m_h_two19_im3h_c = 2*mean(xo*cos(2*pi*21100000000.0*tt))
  let m_h_two19_im3h_s = 2*mean(xo*sin(2*pi*21100000000.0*tt))
  let m_h_two19_fl_lo_c = 2*mean(xo*cos(2*pi*20750000000.0*tt))
  let m_h_two19_fl_lo_s = 2*mean(xo*sin(2*pi*20750000000.0*tt))
  let m_h_two19_fl_hi_c = 2*mean(xo*cos(2*pi*21150000000.0*tt))
  let m_h_two19_fl_hi_s = 2*mean(xo*sin(2*pi*21150000000.0*tt))
  let m_h_two19_vce_q1_max = maximum(v(xdut.c1)[80000,119999] - v(xdut.e1)[80000,119999])
  let m_h_two19_vce_q1_min = minimum(v(xdut.c1)[80000,119999] - v(xdut.e1)[80000,119999])
  let m_h_two19_vce_q2_max = maximum(v(xdut.oc)[80000,119999] - v(xdut.c1)[80000,119999])
  let m_h_two19_vce_q2_min = minimum(v(xdut.oc)[80000,119999] - v(xdut.c1)[80000,119999])
  let m_h_two19_vbe_q1_max = maximum(v(xdut.b1)[80000,119999] - v(xdut.e1)[80000,119999])
  let m_h_two19_vbe_q1_min = minimum(v(xdut.b1)[80000,119999] - v(xdut.e1)[80000,119999])
  let m_h_two19_vbe_q2_max = maximum(v(xdut.b2)[80000,119999] - v(xdut.c1)[80000,119999])
  let m_h_two19_vbe_q2_min = minimum(v(xdut.b2)[80000,119999] - v(xdut.c1)[80000,119999])
  let w_h_two19_ic_q1 = @q.xdut.xq1.qnpn13g2[ic][80000,119999]
  let m_h_two19_ic_q1_max = maximum(w_h_two19_ic_q1)
  let m_h_two19_ic_q1_min = minimum(w_h_two19_ic_q1)
  let w_h_two19_ic_q2 = @q.xdut.xq2.qnpn13g2[ic][80000,119999]
  let m_h_two19_ic_q2_max = maximum(w_h_two19_ic_q2)
  let m_h_two19_ic_q2_min = minimum(w_h_two19_ic_q2)
  print m_h_two19_n m_h_two19_t0 m_h_two19_t1 m_h_two19_f1_c m_h_two19_f1_s m_h_two19_f2_c
  print m_h_two19_f2_s m_h_two19_im3l_c m_h_two19_im3l_s m_h_two19_im3h_c m_h_two19_im3h_s m_h_two19_fl_lo_c
  print m_h_two19_fl_lo_s m_h_two19_fl_hi_c m_h_two19_fl_hi_s m_h_two19_vce_q1_max m_h_two19_vce_q1_min m_h_two19_vce_q2_max
  print m_h_two19_vce_q2_min m_h_two19_vbe_q1_max m_h_two19_vbe_q1_min m_h_two19_vbe_q2_max m_h_two19_vbe_q2_min m_h_two19_ic_q1_max
  print m_h_two19_ic_q1_min m_h_two19_ic_q2_max m_h_two19_ic_q2_min
  * run h_two20: two-tone, available power -36 dBm per tone
  alterparam fq1 = 20900000000.0
  alterparam fq2 = 21000000000.0
  alterparam va1 = 0.0100237446725454
  alterparam va2 = 0.0100237446725454
  reset
  save all @q.xdut.xq1.qnpn13g2[ic] @q.xdut.xq2.qnpn13g2[ic]
  tran 5e-13 6e-08 0 5e-13
  linearize v(p2) v(xdut.c1) v(xdut.e1) v(xdut.oc) v(xdut.b1) v(xdut.b2) @q.xdut.xq1.qnpn13g2[ic] @q.xdut.xq2.qnpn13g2[ic]
  let tt = time[80000,119999]
  let xo = v(p2)[80000,119999]
  let m_h_two20_n = length(xo)
  let m_h_two20_t0 = tt[0]
  let m_h_two20_t1 = tt[39999]
  let m_h_two20_f1_c = 2*mean(xo*cos(2*pi*20900000000.0*tt))
  let m_h_two20_f1_s = 2*mean(xo*sin(2*pi*20900000000.0*tt))
  let m_h_two20_f2_c = 2*mean(xo*cos(2*pi*21000000000.0*tt))
  let m_h_two20_f2_s = 2*mean(xo*sin(2*pi*21000000000.0*tt))
  let m_h_two20_im3l_c = 2*mean(xo*cos(2*pi*20800000000.0*tt))
  let m_h_two20_im3l_s = 2*mean(xo*sin(2*pi*20800000000.0*tt))
  let m_h_two20_im3h_c = 2*mean(xo*cos(2*pi*21100000000.0*tt))
  let m_h_two20_im3h_s = 2*mean(xo*sin(2*pi*21100000000.0*tt))
  let m_h_two20_fl_lo_c = 2*mean(xo*cos(2*pi*20750000000.0*tt))
  let m_h_two20_fl_lo_s = 2*mean(xo*sin(2*pi*20750000000.0*tt))
  let m_h_two20_fl_hi_c = 2*mean(xo*cos(2*pi*21150000000.0*tt))
  let m_h_two20_fl_hi_s = 2*mean(xo*sin(2*pi*21150000000.0*tt))
  let m_h_two20_vce_q1_max = maximum(v(xdut.c1)[80000,119999] - v(xdut.e1)[80000,119999])
  let m_h_two20_vce_q1_min = minimum(v(xdut.c1)[80000,119999] - v(xdut.e1)[80000,119999])
  let m_h_two20_vce_q2_max = maximum(v(xdut.oc)[80000,119999] - v(xdut.c1)[80000,119999])
  let m_h_two20_vce_q2_min = minimum(v(xdut.oc)[80000,119999] - v(xdut.c1)[80000,119999])
  let m_h_two20_vbe_q1_max = maximum(v(xdut.b1)[80000,119999] - v(xdut.e1)[80000,119999])
  let m_h_two20_vbe_q1_min = minimum(v(xdut.b1)[80000,119999] - v(xdut.e1)[80000,119999])
  let m_h_two20_vbe_q2_max = maximum(v(xdut.b2)[80000,119999] - v(xdut.c1)[80000,119999])
  let m_h_two20_vbe_q2_min = minimum(v(xdut.b2)[80000,119999] - v(xdut.c1)[80000,119999])
  let w_h_two20_ic_q1 = @q.xdut.xq1.qnpn13g2[ic][80000,119999]
  let m_h_two20_ic_q1_max = maximum(w_h_two20_ic_q1)
  let m_h_two20_ic_q1_min = minimum(w_h_two20_ic_q1)
  let w_h_two20_ic_q2 = @q.xdut.xq2.qnpn13g2[ic][80000,119999]
  let m_h_two20_ic_q2_max = maximum(w_h_two20_ic_q2)
  let m_h_two20_ic_q2_min = minimum(w_h_two20_ic_q2)
  print m_h_two20_n m_h_two20_t0 m_h_two20_t1 m_h_two20_f1_c m_h_two20_f1_s m_h_two20_f2_c
  print m_h_two20_f2_s m_h_two20_im3l_c m_h_two20_im3l_s m_h_two20_im3h_c m_h_two20_im3h_s m_h_two20_fl_lo_c
  print m_h_two20_fl_lo_s m_h_two20_fl_hi_c m_h_two20_fl_hi_s m_h_two20_vce_q1_max m_h_two20_vce_q1_min m_h_two20_vce_q2_max
  print m_h_two20_vce_q2_min m_h_two20_vbe_q1_max m_h_two20_vbe_q1_min m_h_two20_vbe_q2_max m_h_two20_vbe_q2_min m_h_two20_ic_q1_max
  print m_h_two20_ic_q1_min m_h_two20_ic_q2_max m_h_two20_ic_q2_min
  * run d_two00: two-tone, available power -56 dBm per tone
  alterparam fq1 = 20900000000.0
  alterparam fq2 = 21000000000.0
  alterparam va1 = 0.00100237446725455
  alterparam va2 = 0.00100237446725455
  reset
  save all @q.xdut.xq1.qnpn13g2[ic] @q.xdut.xq2.qnpn13g2[ic]
  tran 1e-12 8e-08 0 1e-12
  linearize v(p2) v(xdut.c1) v(xdut.e1) v(xdut.oc) v(xdut.b1) v(xdut.b2) @q.xdut.xq1.qnpn13g2[ic] @q.xdut.xq2.qnpn13g2[ic]
  let tt = time[40000,79999]
  let xo = v(p2)[40000,79999]
  let m_d_two00_n = length(xo)
  let m_d_two00_t0 = tt[0]
  let m_d_two00_t1 = tt[39999]
  let m_d_two00_f1_c = 2*mean(xo*cos(2*pi*20900000000.0*tt))
  let m_d_two00_f1_s = 2*mean(xo*sin(2*pi*20900000000.0*tt))
  let m_d_two00_f2_c = 2*mean(xo*cos(2*pi*21000000000.0*tt))
  let m_d_two00_f2_s = 2*mean(xo*sin(2*pi*21000000000.0*tt))
  let m_d_two00_im3l_c = 2*mean(xo*cos(2*pi*20800000000.0*tt))
  let m_d_two00_im3l_s = 2*mean(xo*sin(2*pi*20800000000.0*tt))
  let m_d_two00_im3h_c = 2*mean(xo*cos(2*pi*21100000000.0*tt))
  let m_d_two00_im3h_s = 2*mean(xo*sin(2*pi*21100000000.0*tt))
  let m_d_two00_fl_lo_c = 2*mean(xo*cos(2*pi*20750000000.0*tt))
  let m_d_two00_fl_lo_s = 2*mean(xo*sin(2*pi*20750000000.0*tt))
  let m_d_two00_fl_hi_c = 2*mean(xo*cos(2*pi*21150000000.0*tt))
  let m_d_two00_fl_hi_s = 2*mean(xo*sin(2*pi*21150000000.0*tt))
  let m_d_two00_vce_q1_max = maximum(v(xdut.c1)[40000,79999] - v(xdut.e1)[40000,79999])
  let m_d_two00_vce_q1_min = minimum(v(xdut.c1)[40000,79999] - v(xdut.e1)[40000,79999])
  let m_d_two00_vce_q2_max = maximum(v(xdut.oc)[40000,79999] - v(xdut.c1)[40000,79999])
  let m_d_two00_vce_q2_min = minimum(v(xdut.oc)[40000,79999] - v(xdut.c1)[40000,79999])
  let m_d_two00_vbe_q1_max = maximum(v(xdut.b1)[40000,79999] - v(xdut.e1)[40000,79999])
  let m_d_two00_vbe_q1_min = minimum(v(xdut.b1)[40000,79999] - v(xdut.e1)[40000,79999])
  let m_d_two00_vbe_q2_max = maximum(v(xdut.b2)[40000,79999] - v(xdut.c1)[40000,79999])
  let m_d_two00_vbe_q2_min = minimum(v(xdut.b2)[40000,79999] - v(xdut.c1)[40000,79999])
  let w_d_two00_ic_q1 = @q.xdut.xq1.qnpn13g2[ic][40000,79999]
  let m_d_two00_ic_q1_max = maximum(w_d_two00_ic_q1)
  let m_d_two00_ic_q1_min = minimum(w_d_two00_ic_q1)
  let w_d_two00_ic_q2 = @q.xdut.xq2.qnpn13g2[ic][40000,79999]
  let m_d_two00_ic_q2_max = maximum(w_d_two00_ic_q2)
  let m_d_two00_ic_q2_min = minimum(w_d_two00_ic_q2)
  print m_d_two00_n m_d_two00_t0 m_d_two00_t1 m_d_two00_f1_c m_d_two00_f1_s m_d_two00_f2_c
  print m_d_two00_f2_s m_d_two00_im3l_c m_d_two00_im3l_s m_d_two00_im3h_c m_d_two00_im3h_s m_d_two00_fl_lo_c
  print m_d_two00_fl_lo_s m_d_two00_fl_hi_c m_d_two00_fl_hi_s m_d_two00_vce_q1_max m_d_two00_vce_q1_min m_d_two00_vce_q2_max
  print m_d_two00_vce_q2_min m_d_two00_vbe_q1_max m_d_two00_vbe_q1_min m_d_two00_vbe_q2_max m_d_two00_vbe_q2_min m_d_two00_ic_q1_max
  print m_d_two00_ic_q1_min m_d_two00_ic_q2_max m_d_two00_ic_q2_min
  * run d_two01: two-tone, available power -55 dBm per tone
  alterparam fq1 = 20900000000.0
  alterparam fq2 = 21000000000.0
  alterparam va1 = 0.0011246826503807
  alterparam va2 = 0.0011246826503807
  reset
  save all @q.xdut.xq1.qnpn13g2[ic] @q.xdut.xq2.qnpn13g2[ic]
  tran 1e-12 8e-08 0 1e-12
  linearize v(p2) v(xdut.c1) v(xdut.e1) v(xdut.oc) v(xdut.b1) v(xdut.b2) @q.xdut.xq1.qnpn13g2[ic] @q.xdut.xq2.qnpn13g2[ic]
  let tt = time[40000,79999]
  let xo = v(p2)[40000,79999]
  let m_d_two01_n = length(xo)
  let m_d_two01_t0 = tt[0]
  let m_d_two01_t1 = tt[39999]
  let m_d_two01_f1_c = 2*mean(xo*cos(2*pi*20900000000.0*tt))
  let m_d_two01_f1_s = 2*mean(xo*sin(2*pi*20900000000.0*tt))
  let m_d_two01_f2_c = 2*mean(xo*cos(2*pi*21000000000.0*tt))
  let m_d_two01_f2_s = 2*mean(xo*sin(2*pi*21000000000.0*tt))
  let m_d_two01_im3l_c = 2*mean(xo*cos(2*pi*20800000000.0*tt))
  let m_d_two01_im3l_s = 2*mean(xo*sin(2*pi*20800000000.0*tt))
  let m_d_two01_im3h_c = 2*mean(xo*cos(2*pi*21100000000.0*tt))
  let m_d_two01_im3h_s = 2*mean(xo*sin(2*pi*21100000000.0*tt))
  let m_d_two01_fl_lo_c = 2*mean(xo*cos(2*pi*20750000000.0*tt))
  let m_d_two01_fl_lo_s = 2*mean(xo*sin(2*pi*20750000000.0*tt))
  let m_d_two01_fl_hi_c = 2*mean(xo*cos(2*pi*21150000000.0*tt))
  let m_d_two01_fl_hi_s = 2*mean(xo*sin(2*pi*21150000000.0*tt))
  let m_d_two01_vce_q1_max = maximum(v(xdut.c1)[40000,79999] - v(xdut.e1)[40000,79999])
  let m_d_two01_vce_q1_min = minimum(v(xdut.c1)[40000,79999] - v(xdut.e1)[40000,79999])
  let m_d_two01_vce_q2_max = maximum(v(xdut.oc)[40000,79999] - v(xdut.c1)[40000,79999])
  let m_d_two01_vce_q2_min = minimum(v(xdut.oc)[40000,79999] - v(xdut.c1)[40000,79999])
  let m_d_two01_vbe_q1_max = maximum(v(xdut.b1)[40000,79999] - v(xdut.e1)[40000,79999])
  let m_d_two01_vbe_q1_min = minimum(v(xdut.b1)[40000,79999] - v(xdut.e1)[40000,79999])
  let m_d_two01_vbe_q2_max = maximum(v(xdut.b2)[40000,79999] - v(xdut.c1)[40000,79999])
  let m_d_two01_vbe_q2_min = minimum(v(xdut.b2)[40000,79999] - v(xdut.c1)[40000,79999])
  let w_d_two01_ic_q1 = @q.xdut.xq1.qnpn13g2[ic][40000,79999]
  let m_d_two01_ic_q1_max = maximum(w_d_two01_ic_q1)
  let m_d_two01_ic_q1_min = minimum(w_d_two01_ic_q1)
  let w_d_two01_ic_q2 = @q.xdut.xq2.qnpn13g2[ic][40000,79999]
  let m_d_two01_ic_q2_max = maximum(w_d_two01_ic_q2)
  let m_d_two01_ic_q2_min = minimum(w_d_two01_ic_q2)
  print m_d_two01_n m_d_two01_t0 m_d_two01_t1 m_d_two01_f1_c m_d_two01_f1_s m_d_two01_f2_c
  print m_d_two01_f2_s m_d_two01_im3l_c m_d_two01_im3l_s m_d_two01_im3h_c m_d_two01_im3h_s m_d_two01_fl_lo_c
  print m_d_two01_fl_lo_s m_d_two01_fl_hi_c m_d_two01_fl_hi_s m_d_two01_vce_q1_max m_d_two01_vce_q1_min m_d_two01_vce_q2_max
  print m_d_two01_vce_q2_min m_d_two01_vbe_q1_max m_d_two01_vbe_q1_min m_d_two01_vbe_q2_max m_d_two01_vbe_q2_min m_d_two01_ic_q1_max
  print m_d_two01_ic_q1_min m_d_two01_ic_q2_max m_d_two01_ic_q2_min
  * run d_two02: two-tone, available power -54 dBm per tone
  alterparam fq1 = 20900000000.0
  alterparam fq2 = 21000000000.0
  alterparam va1 = 0.00126191468896039
  alterparam va2 = 0.00126191468896039
  reset
  save all @q.xdut.xq1.qnpn13g2[ic] @q.xdut.xq2.qnpn13g2[ic]
  tran 1e-12 8e-08 0 1e-12
  linearize v(p2) v(xdut.c1) v(xdut.e1) v(xdut.oc) v(xdut.b1) v(xdut.b2) @q.xdut.xq1.qnpn13g2[ic] @q.xdut.xq2.qnpn13g2[ic]
  let tt = time[40000,79999]
  let xo = v(p2)[40000,79999]
  let m_d_two02_n = length(xo)
  let m_d_two02_t0 = tt[0]
  let m_d_two02_t1 = tt[39999]
  let m_d_two02_f1_c = 2*mean(xo*cos(2*pi*20900000000.0*tt))
  let m_d_two02_f1_s = 2*mean(xo*sin(2*pi*20900000000.0*tt))
  let m_d_two02_f2_c = 2*mean(xo*cos(2*pi*21000000000.0*tt))
  let m_d_two02_f2_s = 2*mean(xo*sin(2*pi*21000000000.0*tt))
  let m_d_two02_im3l_c = 2*mean(xo*cos(2*pi*20800000000.0*tt))
  let m_d_two02_im3l_s = 2*mean(xo*sin(2*pi*20800000000.0*tt))
  let m_d_two02_im3h_c = 2*mean(xo*cos(2*pi*21100000000.0*tt))
  let m_d_two02_im3h_s = 2*mean(xo*sin(2*pi*21100000000.0*tt))
  let m_d_two02_fl_lo_c = 2*mean(xo*cos(2*pi*20750000000.0*tt))
  let m_d_two02_fl_lo_s = 2*mean(xo*sin(2*pi*20750000000.0*tt))
  let m_d_two02_fl_hi_c = 2*mean(xo*cos(2*pi*21150000000.0*tt))
  let m_d_two02_fl_hi_s = 2*mean(xo*sin(2*pi*21150000000.0*tt))
  let m_d_two02_vce_q1_max = maximum(v(xdut.c1)[40000,79999] - v(xdut.e1)[40000,79999])
  let m_d_two02_vce_q1_min = minimum(v(xdut.c1)[40000,79999] - v(xdut.e1)[40000,79999])
  let m_d_two02_vce_q2_max = maximum(v(xdut.oc)[40000,79999] - v(xdut.c1)[40000,79999])
  let m_d_two02_vce_q2_min = minimum(v(xdut.oc)[40000,79999] - v(xdut.c1)[40000,79999])
  let m_d_two02_vbe_q1_max = maximum(v(xdut.b1)[40000,79999] - v(xdut.e1)[40000,79999])
  let m_d_two02_vbe_q1_min = minimum(v(xdut.b1)[40000,79999] - v(xdut.e1)[40000,79999])
  let m_d_two02_vbe_q2_max = maximum(v(xdut.b2)[40000,79999] - v(xdut.c1)[40000,79999])
  let m_d_two02_vbe_q2_min = minimum(v(xdut.b2)[40000,79999] - v(xdut.c1)[40000,79999])
  let w_d_two02_ic_q1 = @q.xdut.xq1.qnpn13g2[ic][40000,79999]
  let m_d_two02_ic_q1_max = maximum(w_d_two02_ic_q1)
  let m_d_two02_ic_q1_min = minimum(w_d_two02_ic_q1)
  let w_d_two02_ic_q2 = @q.xdut.xq2.qnpn13g2[ic][40000,79999]
  let m_d_two02_ic_q2_max = maximum(w_d_two02_ic_q2)
  let m_d_two02_ic_q2_min = minimum(w_d_two02_ic_q2)
  print m_d_two02_n m_d_two02_t0 m_d_two02_t1 m_d_two02_f1_c m_d_two02_f1_s m_d_two02_f2_c
  print m_d_two02_f2_s m_d_two02_im3l_c m_d_two02_im3l_s m_d_two02_im3h_c m_d_two02_im3h_s m_d_two02_fl_lo_c
  print m_d_two02_fl_lo_s m_d_two02_fl_hi_c m_d_two02_fl_hi_s m_d_two02_vce_q1_max m_d_two02_vce_q1_min m_d_two02_vce_q2_max
  print m_d_two02_vce_q2_min m_d_two02_vbe_q1_max m_d_two02_vbe_q1_min m_d_two02_vbe_q2_max m_d_two02_vbe_q2_min m_d_two02_ic_q1_max
  print m_d_two02_ic_q1_min m_d_two02_ic_q2_max m_d_two02_ic_q2_min
  * run d_two03: two-tone, available power -53 dBm per tone
  alterparam fq1 = 20900000000.0
  alterparam fq2 = 21000000000.0
  alterparam va1 = 0.00141589156876828
  alterparam va2 = 0.00141589156876828
  reset
  save all @q.xdut.xq1.qnpn13g2[ic] @q.xdut.xq2.qnpn13g2[ic]
  tran 1e-12 8e-08 0 1e-12
  linearize v(p2) v(xdut.c1) v(xdut.e1) v(xdut.oc) v(xdut.b1) v(xdut.b2) @q.xdut.xq1.qnpn13g2[ic] @q.xdut.xq2.qnpn13g2[ic]
  let tt = time[40000,79999]
  let xo = v(p2)[40000,79999]
  let m_d_two03_n = length(xo)
  let m_d_two03_t0 = tt[0]
  let m_d_two03_t1 = tt[39999]
  let m_d_two03_f1_c = 2*mean(xo*cos(2*pi*20900000000.0*tt))
  let m_d_two03_f1_s = 2*mean(xo*sin(2*pi*20900000000.0*tt))
  let m_d_two03_f2_c = 2*mean(xo*cos(2*pi*21000000000.0*tt))
  let m_d_two03_f2_s = 2*mean(xo*sin(2*pi*21000000000.0*tt))
  let m_d_two03_im3l_c = 2*mean(xo*cos(2*pi*20800000000.0*tt))
  let m_d_two03_im3l_s = 2*mean(xo*sin(2*pi*20800000000.0*tt))
  let m_d_two03_im3h_c = 2*mean(xo*cos(2*pi*21100000000.0*tt))
  let m_d_two03_im3h_s = 2*mean(xo*sin(2*pi*21100000000.0*tt))
  let m_d_two03_fl_lo_c = 2*mean(xo*cos(2*pi*20750000000.0*tt))
  let m_d_two03_fl_lo_s = 2*mean(xo*sin(2*pi*20750000000.0*tt))
  let m_d_two03_fl_hi_c = 2*mean(xo*cos(2*pi*21150000000.0*tt))
  let m_d_two03_fl_hi_s = 2*mean(xo*sin(2*pi*21150000000.0*tt))
  let m_d_two03_vce_q1_max = maximum(v(xdut.c1)[40000,79999] - v(xdut.e1)[40000,79999])
  let m_d_two03_vce_q1_min = minimum(v(xdut.c1)[40000,79999] - v(xdut.e1)[40000,79999])
  let m_d_two03_vce_q2_max = maximum(v(xdut.oc)[40000,79999] - v(xdut.c1)[40000,79999])
  let m_d_two03_vce_q2_min = minimum(v(xdut.oc)[40000,79999] - v(xdut.c1)[40000,79999])
  let m_d_two03_vbe_q1_max = maximum(v(xdut.b1)[40000,79999] - v(xdut.e1)[40000,79999])
  let m_d_two03_vbe_q1_min = minimum(v(xdut.b1)[40000,79999] - v(xdut.e1)[40000,79999])
  let m_d_two03_vbe_q2_max = maximum(v(xdut.b2)[40000,79999] - v(xdut.c1)[40000,79999])
  let m_d_two03_vbe_q2_min = minimum(v(xdut.b2)[40000,79999] - v(xdut.c1)[40000,79999])
  let w_d_two03_ic_q1 = @q.xdut.xq1.qnpn13g2[ic][40000,79999]
  let m_d_two03_ic_q1_max = maximum(w_d_two03_ic_q1)
  let m_d_two03_ic_q1_min = minimum(w_d_two03_ic_q1)
  let w_d_two03_ic_q2 = @q.xdut.xq2.qnpn13g2[ic][40000,79999]
  let m_d_two03_ic_q2_max = maximum(w_d_two03_ic_q2)
  let m_d_two03_ic_q2_min = minimum(w_d_two03_ic_q2)
  print m_d_two03_n m_d_two03_t0 m_d_two03_t1 m_d_two03_f1_c m_d_two03_f1_s m_d_two03_f2_c
  print m_d_two03_f2_s m_d_two03_im3l_c m_d_two03_im3l_s m_d_two03_im3h_c m_d_two03_im3h_s m_d_two03_fl_lo_c
  print m_d_two03_fl_lo_s m_d_two03_fl_hi_c m_d_two03_fl_hi_s m_d_two03_vce_q1_max m_d_two03_vce_q1_min m_d_two03_vce_q2_max
  print m_d_two03_vce_q2_min m_d_two03_vbe_q1_max m_d_two03_vbe_q1_min m_d_two03_vbe_q2_max m_d_two03_vbe_q2_min m_d_two03_ic_q1_max
  print m_d_two03_ic_q1_min m_d_two03_ic_q2_max m_d_two03_ic_q2_min
  * run d_two04: two-tone, available power -52 dBm per tone
  alterparam fq1 = 20900000000.0
  alterparam fq2 = 21000000000.0
  alterparam va1 = 0.00158865646944856
  alterparam va2 = 0.00158865646944856
  reset
  save all @q.xdut.xq1.qnpn13g2[ic] @q.xdut.xq2.qnpn13g2[ic]
  tran 1e-12 8e-08 0 1e-12
  linearize v(p2) v(xdut.c1) v(xdut.e1) v(xdut.oc) v(xdut.b1) v(xdut.b2) @q.xdut.xq1.qnpn13g2[ic] @q.xdut.xq2.qnpn13g2[ic]
  let tt = time[40000,79999]
  let xo = v(p2)[40000,79999]
  let m_d_two04_n = length(xo)
  let m_d_two04_t0 = tt[0]
  let m_d_two04_t1 = tt[39999]
  let m_d_two04_f1_c = 2*mean(xo*cos(2*pi*20900000000.0*tt))
  let m_d_two04_f1_s = 2*mean(xo*sin(2*pi*20900000000.0*tt))
  let m_d_two04_f2_c = 2*mean(xo*cos(2*pi*21000000000.0*tt))
  let m_d_two04_f2_s = 2*mean(xo*sin(2*pi*21000000000.0*tt))
  let m_d_two04_im3l_c = 2*mean(xo*cos(2*pi*20800000000.0*tt))
  let m_d_two04_im3l_s = 2*mean(xo*sin(2*pi*20800000000.0*tt))
  let m_d_two04_im3h_c = 2*mean(xo*cos(2*pi*21100000000.0*tt))
  let m_d_two04_im3h_s = 2*mean(xo*sin(2*pi*21100000000.0*tt))
  let m_d_two04_fl_lo_c = 2*mean(xo*cos(2*pi*20750000000.0*tt))
  let m_d_two04_fl_lo_s = 2*mean(xo*sin(2*pi*20750000000.0*tt))
  let m_d_two04_fl_hi_c = 2*mean(xo*cos(2*pi*21150000000.0*tt))
  let m_d_two04_fl_hi_s = 2*mean(xo*sin(2*pi*21150000000.0*tt))
  let m_d_two04_vce_q1_max = maximum(v(xdut.c1)[40000,79999] - v(xdut.e1)[40000,79999])
  let m_d_two04_vce_q1_min = minimum(v(xdut.c1)[40000,79999] - v(xdut.e1)[40000,79999])
  let m_d_two04_vce_q2_max = maximum(v(xdut.oc)[40000,79999] - v(xdut.c1)[40000,79999])
  let m_d_two04_vce_q2_min = minimum(v(xdut.oc)[40000,79999] - v(xdut.c1)[40000,79999])
  let m_d_two04_vbe_q1_max = maximum(v(xdut.b1)[40000,79999] - v(xdut.e1)[40000,79999])
  let m_d_two04_vbe_q1_min = minimum(v(xdut.b1)[40000,79999] - v(xdut.e1)[40000,79999])
  let m_d_two04_vbe_q2_max = maximum(v(xdut.b2)[40000,79999] - v(xdut.c1)[40000,79999])
  let m_d_two04_vbe_q2_min = minimum(v(xdut.b2)[40000,79999] - v(xdut.c1)[40000,79999])
  let w_d_two04_ic_q1 = @q.xdut.xq1.qnpn13g2[ic][40000,79999]
  let m_d_two04_ic_q1_max = maximum(w_d_two04_ic_q1)
  let m_d_two04_ic_q1_min = minimum(w_d_two04_ic_q1)
  let w_d_two04_ic_q2 = @q.xdut.xq2.qnpn13g2[ic][40000,79999]
  let m_d_two04_ic_q2_max = maximum(w_d_two04_ic_q2)
  let m_d_two04_ic_q2_min = minimum(w_d_two04_ic_q2)
  print m_d_two04_n m_d_two04_t0 m_d_two04_t1 m_d_two04_f1_c m_d_two04_f1_s m_d_two04_f2_c
  print m_d_two04_f2_s m_d_two04_im3l_c m_d_two04_im3l_s m_d_two04_im3h_c m_d_two04_im3h_s m_d_two04_fl_lo_c
  print m_d_two04_fl_lo_s m_d_two04_fl_hi_c m_d_two04_fl_hi_s m_d_two04_vce_q1_max m_d_two04_vce_q1_min m_d_two04_vce_q2_max
  print m_d_two04_vce_q2_min m_d_two04_vbe_q1_max m_d_two04_vbe_q1_min m_d_two04_vbe_q2_max m_d_two04_vbe_q2_min m_d_two04_ic_q1_max
  print m_d_two04_ic_q1_min m_d_two04_ic_q2_max m_d_two04_ic_q2_min
  * run d_two05: two-tone, available power -51 dBm per tone
  alterparam fq1 = 20900000000.0
  alterparam fq2 = 21000000000.0
  alterparam va1 = 0.00178250187626749
  alterparam va2 = 0.00178250187626749
  reset
  save all @q.xdut.xq1.qnpn13g2[ic] @q.xdut.xq2.qnpn13g2[ic]
  tran 1e-12 8e-08 0 1e-12
  linearize v(p2) v(xdut.c1) v(xdut.e1) v(xdut.oc) v(xdut.b1) v(xdut.b2) @q.xdut.xq1.qnpn13g2[ic] @q.xdut.xq2.qnpn13g2[ic]
  let tt = time[40000,79999]
  let xo = v(p2)[40000,79999]
  let m_d_two05_n = length(xo)
  let m_d_two05_t0 = tt[0]
  let m_d_two05_t1 = tt[39999]
  let m_d_two05_f1_c = 2*mean(xo*cos(2*pi*20900000000.0*tt))
  let m_d_two05_f1_s = 2*mean(xo*sin(2*pi*20900000000.0*tt))
  let m_d_two05_f2_c = 2*mean(xo*cos(2*pi*21000000000.0*tt))
  let m_d_two05_f2_s = 2*mean(xo*sin(2*pi*21000000000.0*tt))
  let m_d_two05_im3l_c = 2*mean(xo*cos(2*pi*20800000000.0*tt))
  let m_d_two05_im3l_s = 2*mean(xo*sin(2*pi*20800000000.0*tt))
  let m_d_two05_im3h_c = 2*mean(xo*cos(2*pi*21100000000.0*tt))
  let m_d_two05_im3h_s = 2*mean(xo*sin(2*pi*21100000000.0*tt))
  let m_d_two05_fl_lo_c = 2*mean(xo*cos(2*pi*20750000000.0*tt))
  let m_d_two05_fl_lo_s = 2*mean(xo*sin(2*pi*20750000000.0*tt))
  let m_d_two05_fl_hi_c = 2*mean(xo*cos(2*pi*21150000000.0*tt))
  let m_d_two05_fl_hi_s = 2*mean(xo*sin(2*pi*21150000000.0*tt))
  let m_d_two05_vce_q1_max = maximum(v(xdut.c1)[40000,79999] - v(xdut.e1)[40000,79999])
  let m_d_two05_vce_q1_min = minimum(v(xdut.c1)[40000,79999] - v(xdut.e1)[40000,79999])
  let m_d_two05_vce_q2_max = maximum(v(xdut.oc)[40000,79999] - v(xdut.c1)[40000,79999])
  let m_d_two05_vce_q2_min = minimum(v(xdut.oc)[40000,79999] - v(xdut.c1)[40000,79999])
  let m_d_two05_vbe_q1_max = maximum(v(xdut.b1)[40000,79999] - v(xdut.e1)[40000,79999])
  let m_d_two05_vbe_q1_min = minimum(v(xdut.b1)[40000,79999] - v(xdut.e1)[40000,79999])
  let m_d_two05_vbe_q2_max = maximum(v(xdut.b2)[40000,79999] - v(xdut.c1)[40000,79999])
  let m_d_two05_vbe_q2_min = minimum(v(xdut.b2)[40000,79999] - v(xdut.c1)[40000,79999])
  let w_d_two05_ic_q1 = @q.xdut.xq1.qnpn13g2[ic][40000,79999]
  let m_d_two05_ic_q1_max = maximum(w_d_two05_ic_q1)
  let m_d_two05_ic_q1_min = minimum(w_d_two05_ic_q1)
  let w_d_two05_ic_q2 = @q.xdut.xq2.qnpn13g2[ic][40000,79999]
  let m_d_two05_ic_q2_max = maximum(w_d_two05_ic_q2)
  let m_d_two05_ic_q2_min = minimum(w_d_two05_ic_q2)
  print m_d_two05_n m_d_two05_t0 m_d_two05_t1 m_d_two05_f1_c m_d_two05_f1_s m_d_two05_f2_c
  print m_d_two05_f2_s m_d_two05_im3l_c m_d_two05_im3l_s m_d_two05_im3h_c m_d_two05_im3h_s m_d_two05_fl_lo_c
  print m_d_two05_fl_lo_s m_d_two05_fl_hi_c m_d_two05_fl_hi_s m_d_two05_vce_q1_max m_d_two05_vce_q1_min m_d_two05_vce_q2_max
  print m_d_two05_vce_q2_min m_d_two05_vbe_q1_max m_d_two05_vbe_q1_min m_d_two05_vbe_q2_max m_d_two05_vbe_q2_min m_d_two05_ic_q1_max
  print m_d_two05_ic_q1_min m_d_two05_ic_q2_max m_d_two05_ic_q2_min
  * run d_two06: two-tone, available power -50 dBm per tone
  alterparam fq1 = 20900000000.0
  alterparam fq2 = 21000000000.0
  alterparam va1 = 0.002
  alterparam va2 = 0.002
  reset
  save all @q.xdut.xq1.qnpn13g2[ic] @q.xdut.xq2.qnpn13g2[ic]
  tran 1e-12 8e-08 0 1e-12
  linearize v(p2) v(xdut.c1) v(xdut.e1) v(xdut.oc) v(xdut.b1) v(xdut.b2) @q.xdut.xq1.qnpn13g2[ic] @q.xdut.xq2.qnpn13g2[ic]
  let tt = time[40000,79999]
  let xo = v(p2)[40000,79999]
  let m_d_two06_n = length(xo)
  let m_d_two06_t0 = tt[0]
  let m_d_two06_t1 = tt[39999]
  let m_d_two06_f1_c = 2*mean(xo*cos(2*pi*20900000000.0*tt))
  let m_d_two06_f1_s = 2*mean(xo*sin(2*pi*20900000000.0*tt))
  let m_d_two06_f2_c = 2*mean(xo*cos(2*pi*21000000000.0*tt))
  let m_d_two06_f2_s = 2*mean(xo*sin(2*pi*21000000000.0*tt))
  let m_d_two06_im3l_c = 2*mean(xo*cos(2*pi*20800000000.0*tt))
  let m_d_two06_im3l_s = 2*mean(xo*sin(2*pi*20800000000.0*tt))
  let m_d_two06_im3h_c = 2*mean(xo*cos(2*pi*21100000000.0*tt))
  let m_d_two06_im3h_s = 2*mean(xo*sin(2*pi*21100000000.0*tt))
  let m_d_two06_fl_lo_c = 2*mean(xo*cos(2*pi*20750000000.0*tt))
  let m_d_two06_fl_lo_s = 2*mean(xo*sin(2*pi*20750000000.0*tt))
  let m_d_two06_fl_hi_c = 2*mean(xo*cos(2*pi*21150000000.0*tt))
  let m_d_two06_fl_hi_s = 2*mean(xo*sin(2*pi*21150000000.0*tt))
  let m_d_two06_vce_q1_max = maximum(v(xdut.c1)[40000,79999] - v(xdut.e1)[40000,79999])
  let m_d_two06_vce_q1_min = minimum(v(xdut.c1)[40000,79999] - v(xdut.e1)[40000,79999])
  let m_d_two06_vce_q2_max = maximum(v(xdut.oc)[40000,79999] - v(xdut.c1)[40000,79999])
  let m_d_two06_vce_q2_min = minimum(v(xdut.oc)[40000,79999] - v(xdut.c1)[40000,79999])
  let m_d_two06_vbe_q1_max = maximum(v(xdut.b1)[40000,79999] - v(xdut.e1)[40000,79999])
  let m_d_two06_vbe_q1_min = minimum(v(xdut.b1)[40000,79999] - v(xdut.e1)[40000,79999])
  let m_d_two06_vbe_q2_max = maximum(v(xdut.b2)[40000,79999] - v(xdut.c1)[40000,79999])
  let m_d_two06_vbe_q2_min = minimum(v(xdut.b2)[40000,79999] - v(xdut.c1)[40000,79999])
  let w_d_two06_ic_q1 = @q.xdut.xq1.qnpn13g2[ic][40000,79999]
  let m_d_two06_ic_q1_max = maximum(w_d_two06_ic_q1)
  let m_d_two06_ic_q1_min = minimum(w_d_two06_ic_q1)
  let w_d_two06_ic_q2 = @q.xdut.xq2.qnpn13g2[ic][40000,79999]
  let m_d_two06_ic_q2_max = maximum(w_d_two06_ic_q2)
  let m_d_two06_ic_q2_min = minimum(w_d_two06_ic_q2)
  print m_d_two06_n m_d_two06_t0 m_d_two06_t1 m_d_two06_f1_c m_d_two06_f1_s m_d_two06_f2_c
  print m_d_two06_f2_s m_d_two06_im3l_c m_d_two06_im3l_s m_d_two06_im3h_c m_d_two06_im3h_s m_d_two06_fl_lo_c
  print m_d_two06_fl_lo_s m_d_two06_fl_hi_c m_d_two06_fl_hi_s m_d_two06_vce_q1_max m_d_two06_vce_q1_min m_d_two06_vce_q2_max
  print m_d_two06_vce_q2_min m_d_two06_vbe_q1_max m_d_two06_vbe_q1_min m_d_two06_vbe_q2_max m_d_two06_vbe_q2_min m_d_two06_ic_q1_max
  print m_d_two06_ic_q1_min m_d_two06_ic_q2_max m_d_two06_ic_q2_min
  * run d_two07: two-tone, available power -49 dBm per tone
  alterparam fq1 = 20900000000.0
  alterparam fq2 = 21000000000.0
  alterparam va1 = 0.00224403690860393
  alterparam va2 = 0.00224403690860393
  reset
  save all @q.xdut.xq1.qnpn13g2[ic] @q.xdut.xq2.qnpn13g2[ic]
  tran 1e-12 8e-08 0 1e-12
  linearize v(p2) v(xdut.c1) v(xdut.e1) v(xdut.oc) v(xdut.b1) v(xdut.b2) @q.xdut.xq1.qnpn13g2[ic] @q.xdut.xq2.qnpn13g2[ic]
  let tt = time[40000,79999]
  let xo = v(p2)[40000,79999]
  let m_d_two07_n = length(xo)
  let m_d_two07_t0 = tt[0]
  let m_d_two07_t1 = tt[39999]
  let m_d_two07_f1_c = 2*mean(xo*cos(2*pi*20900000000.0*tt))
  let m_d_two07_f1_s = 2*mean(xo*sin(2*pi*20900000000.0*tt))
  let m_d_two07_f2_c = 2*mean(xo*cos(2*pi*21000000000.0*tt))
  let m_d_two07_f2_s = 2*mean(xo*sin(2*pi*21000000000.0*tt))
  let m_d_two07_im3l_c = 2*mean(xo*cos(2*pi*20800000000.0*tt))
  let m_d_two07_im3l_s = 2*mean(xo*sin(2*pi*20800000000.0*tt))
  let m_d_two07_im3h_c = 2*mean(xo*cos(2*pi*21100000000.0*tt))
  let m_d_two07_im3h_s = 2*mean(xo*sin(2*pi*21100000000.0*tt))
  let m_d_two07_fl_lo_c = 2*mean(xo*cos(2*pi*20750000000.0*tt))
  let m_d_two07_fl_lo_s = 2*mean(xo*sin(2*pi*20750000000.0*tt))
  let m_d_two07_fl_hi_c = 2*mean(xo*cos(2*pi*21150000000.0*tt))
  let m_d_two07_fl_hi_s = 2*mean(xo*sin(2*pi*21150000000.0*tt))
  let m_d_two07_vce_q1_max = maximum(v(xdut.c1)[40000,79999] - v(xdut.e1)[40000,79999])
  let m_d_two07_vce_q1_min = minimum(v(xdut.c1)[40000,79999] - v(xdut.e1)[40000,79999])
  let m_d_two07_vce_q2_max = maximum(v(xdut.oc)[40000,79999] - v(xdut.c1)[40000,79999])
  let m_d_two07_vce_q2_min = minimum(v(xdut.oc)[40000,79999] - v(xdut.c1)[40000,79999])
  let m_d_two07_vbe_q1_max = maximum(v(xdut.b1)[40000,79999] - v(xdut.e1)[40000,79999])
  let m_d_two07_vbe_q1_min = minimum(v(xdut.b1)[40000,79999] - v(xdut.e1)[40000,79999])
  let m_d_two07_vbe_q2_max = maximum(v(xdut.b2)[40000,79999] - v(xdut.c1)[40000,79999])
  let m_d_two07_vbe_q2_min = minimum(v(xdut.b2)[40000,79999] - v(xdut.c1)[40000,79999])
  let w_d_two07_ic_q1 = @q.xdut.xq1.qnpn13g2[ic][40000,79999]
  let m_d_two07_ic_q1_max = maximum(w_d_two07_ic_q1)
  let m_d_two07_ic_q1_min = minimum(w_d_two07_ic_q1)
  let w_d_two07_ic_q2 = @q.xdut.xq2.qnpn13g2[ic][40000,79999]
  let m_d_two07_ic_q2_max = maximum(w_d_two07_ic_q2)
  let m_d_two07_ic_q2_min = minimum(w_d_two07_ic_q2)
  print m_d_two07_n m_d_two07_t0 m_d_two07_t1 m_d_two07_f1_c m_d_two07_f1_s m_d_two07_f2_c
  print m_d_two07_f2_s m_d_two07_im3l_c m_d_two07_im3l_s m_d_two07_im3h_c m_d_two07_im3h_s m_d_two07_fl_lo_c
  print m_d_two07_fl_lo_s m_d_two07_fl_hi_c m_d_two07_fl_hi_s m_d_two07_vce_q1_max m_d_two07_vce_q1_min m_d_two07_vce_q2_max
  print m_d_two07_vce_q2_min m_d_two07_vbe_q1_max m_d_two07_vbe_q1_min m_d_two07_vbe_q2_max m_d_two07_vbe_q2_min m_d_two07_ic_q1_max
  print m_d_two07_ic_q1_min m_d_two07_ic_q2_max m_d_two07_ic_q2_min
  * run d_two08: two-tone, available power -48 dBm per tone
  alterparam fq1 = 20900000000.0
  alterparam fq2 = 21000000000.0
  alterparam va1 = 0.00251785082358833
  alterparam va2 = 0.00251785082358833
  reset
  save all @q.xdut.xq1.qnpn13g2[ic] @q.xdut.xq2.qnpn13g2[ic]
  tran 1e-12 8e-08 0 1e-12
  linearize v(p2) v(xdut.c1) v(xdut.e1) v(xdut.oc) v(xdut.b1) v(xdut.b2) @q.xdut.xq1.qnpn13g2[ic] @q.xdut.xq2.qnpn13g2[ic]
  let tt = time[40000,79999]
  let xo = v(p2)[40000,79999]
  let m_d_two08_n = length(xo)
  let m_d_two08_t0 = tt[0]
  let m_d_two08_t1 = tt[39999]
  let m_d_two08_f1_c = 2*mean(xo*cos(2*pi*20900000000.0*tt))
  let m_d_two08_f1_s = 2*mean(xo*sin(2*pi*20900000000.0*tt))
  let m_d_two08_f2_c = 2*mean(xo*cos(2*pi*21000000000.0*tt))
  let m_d_two08_f2_s = 2*mean(xo*sin(2*pi*21000000000.0*tt))
  let m_d_two08_im3l_c = 2*mean(xo*cos(2*pi*20800000000.0*tt))
  let m_d_two08_im3l_s = 2*mean(xo*sin(2*pi*20800000000.0*tt))
  let m_d_two08_im3h_c = 2*mean(xo*cos(2*pi*21100000000.0*tt))
  let m_d_two08_im3h_s = 2*mean(xo*sin(2*pi*21100000000.0*tt))
  let m_d_two08_fl_lo_c = 2*mean(xo*cos(2*pi*20750000000.0*tt))
  let m_d_two08_fl_lo_s = 2*mean(xo*sin(2*pi*20750000000.0*tt))
  let m_d_two08_fl_hi_c = 2*mean(xo*cos(2*pi*21150000000.0*tt))
  let m_d_two08_fl_hi_s = 2*mean(xo*sin(2*pi*21150000000.0*tt))
  let m_d_two08_vce_q1_max = maximum(v(xdut.c1)[40000,79999] - v(xdut.e1)[40000,79999])
  let m_d_two08_vce_q1_min = minimum(v(xdut.c1)[40000,79999] - v(xdut.e1)[40000,79999])
  let m_d_two08_vce_q2_max = maximum(v(xdut.oc)[40000,79999] - v(xdut.c1)[40000,79999])
  let m_d_two08_vce_q2_min = minimum(v(xdut.oc)[40000,79999] - v(xdut.c1)[40000,79999])
  let m_d_two08_vbe_q1_max = maximum(v(xdut.b1)[40000,79999] - v(xdut.e1)[40000,79999])
  let m_d_two08_vbe_q1_min = minimum(v(xdut.b1)[40000,79999] - v(xdut.e1)[40000,79999])
  let m_d_two08_vbe_q2_max = maximum(v(xdut.b2)[40000,79999] - v(xdut.c1)[40000,79999])
  let m_d_two08_vbe_q2_min = minimum(v(xdut.b2)[40000,79999] - v(xdut.c1)[40000,79999])
  let w_d_two08_ic_q1 = @q.xdut.xq1.qnpn13g2[ic][40000,79999]
  let m_d_two08_ic_q1_max = maximum(w_d_two08_ic_q1)
  let m_d_two08_ic_q1_min = minimum(w_d_two08_ic_q1)
  let w_d_two08_ic_q2 = @q.xdut.xq2.qnpn13g2[ic][40000,79999]
  let m_d_two08_ic_q2_max = maximum(w_d_two08_ic_q2)
  let m_d_two08_ic_q2_min = minimum(w_d_two08_ic_q2)
  print m_d_two08_n m_d_two08_t0 m_d_two08_t1 m_d_two08_f1_c m_d_two08_f1_s m_d_two08_f2_c
  print m_d_two08_f2_s m_d_two08_im3l_c m_d_two08_im3l_s m_d_two08_im3h_c m_d_two08_im3h_s m_d_two08_fl_lo_c
  print m_d_two08_fl_lo_s m_d_two08_fl_hi_c m_d_two08_fl_hi_s m_d_two08_vce_q1_max m_d_two08_vce_q1_min m_d_two08_vce_q2_max
  print m_d_two08_vce_q2_min m_d_two08_vbe_q1_max m_d_two08_vbe_q1_min m_d_two08_vbe_q2_max m_d_two08_vbe_q2_min m_d_two08_ic_q1_max
  print m_d_two08_ic_q1_min m_d_two08_ic_q2_max m_d_two08_ic_q2_min
  * run d_two09: two-tone, available power -47 dBm per tone
  alterparam fq1 = 20900000000.0
  alterparam fq2 = 21000000000.0
  alterparam va1 = 0.00282507508924551
  alterparam va2 = 0.00282507508924551
  reset
  save all @q.xdut.xq1.qnpn13g2[ic] @q.xdut.xq2.qnpn13g2[ic]
  tran 1e-12 8e-08 0 1e-12
  linearize v(p2) v(xdut.c1) v(xdut.e1) v(xdut.oc) v(xdut.b1) v(xdut.b2) @q.xdut.xq1.qnpn13g2[ic] @q.xdut.xq2.qnpn13g2[ic]
  let tt = time[40000,79999]
  let xo = v(p2)[40000,79999]
  let m_d_two09_n = length(xo)
  let m_d_two09_t0 = tt[0]
  let m_d_two09_t1 = tt[39999]
  let m_d_two09_f1_c = 2*mean(xo*cos(2*pi*20900000000.0*tt))
  let m_d_two09_f1_s = 2*mean(xo*sin(2*pi*20900000000.0*tt))
  let m_d_two09_f2_c = 2*mean(xo*cos(2*pi*21000000000.0*tt))
  let m_d_two09_f2_s = 2*mean(xo*sin(2*pi*21000000000.0*tt))
  let m_d_two09_im3l_c = 2*mean(xo*cos(2*pi*20800000000.0*tt))
  let m_d_two09_im3l_s = 2*mean(xo*sin(2*pi*20800000000.0*tt))
  let m_d_two09_im3h_c = 2*mean(xo*cos(2*pi*21100000000.0*tt))
  let m_d_two09_im3h_s = 2*mean(xo*sin(2*pi*21100000000.0*tt))
  let m_d_two09_fl_lo_c = 2*mean(xo*cos(2*pi*20750000000.0*tt))
  let m_d_two09_fl_lo_s = 2*mean(xo*sin(2*pi*20750000000.0*tt))
  let m_d_two09_fl_hi_c = 2*mean(xo*cos(2*pi*21150000000.0*tt))
  let m_d_two09_fl_hi_s = 2*mean(xo*sin(2*pi*21150000000.0*tt))
  let m_d_two09_vce_q1_max = maximum(v(xdut.c1)[40000,79999] - v(xdut.e1)[40000,79999])
  let m_d_two09_vce_q1_min = minimum(v(xdut.c1)[40000,79999] - v(xdut.e1)[40000,79999])
  let m_d_two09_vce_q2_max = maximum(v(xdut.oc)[40000,79999] - v(xdut.c1)[40000,79999])
  let m_d_two09_vce_q2_min = minimum(v(xdut.oc)[40000,79999] - v(xdut.c1)[40000,79999])
  let m_d_two09_vbe_q1_max = maximum(v(xdut.b1)[40000,79999] - v(xdut.e1)[40000,79999])
  let m_d_two09_vbe_q1_min = minimum(v(xdut.b1)[40000,79999] - v(xdut.e1)[40000,79999])
  let m_d_two09_vbe_q2_max = maximum(v(xdut.b2)[40000,79999] - v(xdut.c1)[40000,79999])
  let m_d_two09_vbe_q2_min = minimum(v(xdut.b2)[40000,79999] - v(xdut.c1)[40000,79999])
  let w_d_two09_ic_q1 = @q.xdut.xq1.qnpn13g2[ic][40000,79999]
  let m_d_two09_ic_q1_max = maximum(w_d_two09_ic_q1)
  let m_d_two09_ic_q1_min = minimum(w_d_two09_ic_q1)
  let w_d_two09_ic_q2 = @q.xdut.xq2.qnpn13g2[ic][40000,79999]
  let m_d_two09_ic_q2_max = maximum(w_d_two09_ic_q2)
  let m_d_two09_ic_q2_min = minimum(w_d_two09_ic_q2)
  print m_d_two09_n m_d_two09_t0 m_d_two09_t1 m_d_two09_f1_c m_d_two09_f1_s m_d_two09_f2_c
  print m_d_two09_f2_s m_d_two09_im3l_c m_d_two09_im3l_s m_d_two09_im3h_c m_d_two09_im3h_s m_d_two09_fl_lo_c
  print m_d_two09_fl_lo_s m_d_two09_fl_hi_c m_d_two09_fl_hi_s m_d_two09_vce_q1_max m_d_two09_vce_q1_min m_d_two09_vce_q2_max
  print m_d_two09_vce_q2_min m_d_two09_vbe_q1_max m_d_two09_vbe_q1_min m_d_two09_vbe_q2_max m_d_two09_vbe_q2_min m_d_two09_ic_q1_max
  print m_d_two09_ic_q1_min m_d_two09_ic_q2_max m_d_two09_ic_q2_min
  * run d_two10: two-tone, available power -46 dBm per tone
  alterparam fq1 = 20900000000.0
  alterparam fq2 = 21000000000.0
  alterparam va1 = 0.00316978638492223
  alterparam va2 = 0.00316978638492223
  reset
  save all @q.xdut.xq1.qnpn13g2[ic] @q.xdut.xq2.qnpn13g2[ic]
  tran 1e-12 8e-08 0 1e-12
  linearize v(p2) v(xdut.c1) v(xdut.e1) v(xdut.oc) v(xdut.b1) v(xdut.b2) @q.xdut.xq1.qnpn13g2[ic] @q.xdut.xq2.qnpn13g2[ic]
  let tt = time[40000,79999]
  let xo = v(p2)[40000,79999]
  let m_d_two10_n = length(xo)
  let m_d_two10_t0 = tt[0]
  let m_d_two10_t1 = tt[39999]
  let m_d_two10_f1_c = 2*mean(xo*cos(2*pi*20900000000.0*tt))
  let m_d_two10_f1_s = 2*mean(xo*sin(2*pi*20900000000.0*tt))
  let m_d_two10_f2_c = 2*mean(xo*cos(2*pi*21000000000.0*tt))
  let m_d_two10_f2_s = 2*mean(xo*sin(2*pi*21000000000.0*tt))
  let m_d_two10_im3l_c = 2*mean(xo*cos(2*pi*20800000000.0*tt))
  let m_d_two10_im3l_s = 2*mean(xo*sin(2*pi*20800000000.0*tt))
  let m_d_two10_im3h_c = 2*mean(xo*cos(2*pi*21100000000.0*tt))
  let m_d_two10_im3h_s = 2*mean(xo*sin(2*pi*21100000000.0*tt))
  let m_d_two10_fl_lo_c = 2*mean(xo*cos(2*pi*20750000000.0*tt))
  let m_d_two10_fl_lo_s = 2*mean(xo*sin(2*pi*20750000000.0*tt))
  let m_d_two10_fl_hi_c = 2*mean(xo*cos(2*pi*21150000000.0*tt))
  let m_d_two10_fl_hi_s = 2*mean(xo*sin(2*pi*21150000000.0*tt))
  let m_d_two10_vce_q1_max = maximum(v(xdut.c1)[40000,79999] - v(xdut.e1)[40000,79999])
  let m_d_two10_vce_q1_min = minimum(v(xdut.c1)[40000,79999] - v(xdut.e1)[40000,79999])
  let m_d_two10_vce_q2_max = maximum(v(xdut.oc)[40000,79999] - v(xdut.c1)[40000,79999])
  let m_d_two10_vce_q2_min = minimum(v(xdut.oc)[40000,79999] - v(xdut.c1)[40000,79999])
  let m_d_two10_vbe_q1_max = maximum(v(xdut.b1)[40000,79999] - v(xdut.e1)[40000,79999])
  let m_d_two10_vbe_q1_min = minimum(v(xdut.b1)[40000,79999] - v(xdut.e1)[40000,79999])
  let m_d_two10_vbe_q2_max = maximum(v(xdut.b2)[40000,79999] - v(xdut.c1)[40000,79999])
  let m_d_two10_vbe_q2_min = minimum(v(xdut.b2)[40000,79999] - v(xdut.c1)[40000,79999])
  let w_d_two10_ic_q1 = @q.xdut.xq1.qnpn13g2[ic][40000,79999]
  let m_d_two10_ic_q1_max = maximum(w_d_two10_ic_q1)
  let m_d_two10_ic_q1_min = minimum(w_d_two10_ic_q1)
  let w_d_two10_ic_q2 = @q.xdut.xq2.qnpn13g2[ic][40000,79999]
  let m_d_two10_ic_q2_max = maximum(w_d_two10_ic_q2)
  let m_d_two10_ic_q2_min = minimum(w_d_two10_ic_q2)
  print m_d_two10_n m_d_two10_t0 m_d_two10_t1 m_d_two10_f1_c m_d_two10_f1_s m_d_two10_f2_c
  print m_d_two10_f2_s m_d_two10_im3l_c m_d_two10_im3l_s m_d_two10_im3h_c m_d_two10_im3h_s m_d_two10_fl_lo_c
  print m_d_two10_fl_lo_s m_d_two10_fl_hi_c m_d_two10_fl_hi_s m_d_two10_vce_q1_max m_d_two10_vce_q1_min m_d_two10_vce_q2_max
  print m_d_two10_vce_q2_min m_d_two10_vbe_q1_max m_d_two10_vbe_q1_min m_d_two10_vbe_q2_max m_d_two10_vbe_q2_min m_d_two10_ic_q1_max
  print m_d_two10_ic_q1_min m_d_two10_ic_q2_max m_d_two10_ic_q2_min
  * run d_two11: two-tone, available power -45 dBm per tone
  alterparam fq1 = 20900000000.0
  alterparam fq2 = 21000000000.0
  alterparam va1 = 0.00355655882007785
  alterparam va2 = 0.00355655882007785
  reset
  save all @q.xdut.xq1.qnpn13g2[ic] @q.xdut.xq2.qnpn13g2[ic]
  tran 1e-12 8e-08 0 1e-12
  linearize v(p2) v(xdut.c1) v(xdut.e1) v(xdut.oc) v(xdut.b1) v(xdut.b2) @q.xdut.xq1.qnpn13g2[ic] @q.xdut.xq2.qnpn13g2[ic]
  let tt = time[40000,79999]
  let xo = v(p2)[40000,79999]
  let m_d_two11_n = length(xo)
  let m_d_two11_t0 = tt[0]
  let m_d_two11_t1 = tt[39999]
  let m_d_two11_f1_c = 2*mean(xo*cos(2*pi*20900000000.0*tt))
  let m_d_two11_f1_s = 2*mean(xo*sin(2*pi*20900000000.0*tt))
  let m_d_two11_f2_c = 2*mean(xo*cos(2*pi*21000000000.0*tt))
  let m_d_two11_f2_s = 2*mean(xo*sin(2*pi*21000000000.0*tt))
  let m_d_two11_im3l_c = 2*mean(xo*cos(2*pi*20800000000.0*tt))
  let m_d_two11_im3l_s = 2*mean(xo*sin(2*pi*20800000000.0*tt))
  let m_d_two11_im3h_c = 2*mean(xo*cos(2*pi*21100000000.0*tt))
  let m_d_two11_im3h_s = 2*mean(xo*sin(2*pi*21100000000.0*tt))
  let m_d_two11_fl_lo_c = 2*mean(xo*cos(2*pi*20750000000.0*tt))
  let m_d_two11_fl_lo_s = 2*mean(xo*sin(2*pi*20750000000.0*tt))
  let m_d_two11_fl_hi_c = 2*mean(xo*cos(2*pi*21150000000.0*tt))
  let m_d_two11_fl_hi_s = 2*mean(xo*sin(2*pi*21150000000.0*tt))
  let m_d_two11_vce_q1_max = maximum(v(xdut.c1)[40000,79999] - v(xdut.e1)[40000,79999])
  let m_d_two11_vce_q1_min = minimum(v(xdut.c1)[40000,79999] - v(xdut.e1)[40000,79999])
  let m_d_two11_vce_q2_max = maximum(v(xdut.oc)[40000,79999] - v(xdut.c1)[40000,79999])
  let m_d_two11_vce_q2_min = minimum(v(xdut.oc)[40000,79999] - v(xdut.c1)[40000,79999])
  let m_d_two11_vbe_q1_max = maximum(v(xdut.b1)[40000,79999] - v(xdut.e1)[40000,79999])
  let m_d_two11_vbe_q1_min = minimum(v(xdut.b1)[40000,79999] - v(xdut.e1)[40000,79999])
  let m_d_two11_vbe_q2_max = maximum(v(xdut.b2)[40000,79999] - v(xdut.c1)[40000,79999])
  let m_d_two11_vbe_q2_min = minimum(v(xdut.b2)[40000,79999] - v(xdut.c1)[40000,79999])
  let w_d_two11_ic_q1 = @q.xdut.xq1.qnpn13g2[ic][40000,79999]
  let m_d_two11_ic_q1_max = maximum(w_d_two11_ic_q1)
  let m_d_two11_ic_q1_min = minimum(w_d_two11_ic_q1)
  let w_d_two11_ic_q2 = @q.xdut.xq2.qnpn13g2[ic][40000,79999]
  let m_d_two11_ic_q2_max = maximum(w_d_two11_ic_q2)
  let m_d_two11_ic_q2_min = minimum(w_d_two11_ic_q2)
  print m_d_two11_n m_d_two11_t0 m_d_two11_t1 m_d_two11_f1_c m_d_two11_f1_s m_d_two11_f2_c
  print m_d_two11_f2_s m_d_two11_im3l_c m_d_two11_im3l_s m_d_two11_im3h_c m_d_two11_im3h_s m_d_two11_fl_lo_c
  print m_d_two11_fl_lo_s m_d_two11_fl_hi_c m_d_two11_fl_hi_s m_d_two11_vce_q1_max m_d_two11_vce_q1_min m_d_two11_vce_q2_max
  print m_d_two11_vce_q2_min m_d_two11_vbe_q1_max m_d_two11_vbe_q1_min m_d_two11_vbe_q2_max m_d_two11_vbe_q2_min m_d_two11_ic_q1_max
  print m_d_two11_ic_q1_min m_d_two11_ic_q2_max m_d_two11_ic_q2_min
  * run d_two12: two-tone, available power -44 dBm per tone
  alterparam fq1 = 20900000000.0
  alterparam fq2 = 21000000000.0
  alterparam va1 = 0.00399052462993776
  alterparam va2 = 0.00399052462993776
  reset
  save all @q.xdut.xq1.qnpn13g2[ic] @q.xdut.xq2.qnpn13g2[ic]
  tran 1e-12 8e-08 0 1e-12
  linearize v(p2) v(xdut.c1) v(xdut.e1) v(xdut.oc) v(xdut.b1) v(xdut.b2) @q.xdut.xq1.qnpn13g2[ic] @q.xdut.xq2.qnpn13g2[ic]
  let tt = time[40000,79999]
  let xo = v(p2)[40000,79999]
  let m_d_two12_n = length(xo)
  let m_d_two12_t0 = tt[0]
  let m_d_two12_t1 = tt[39999]
  let m_d_two12_f1_c = 2*mean(xo*cos(2*pi*20900000000.0*tt))
  let m_d_two12_f1_s = 2*mean(xo*sin(2*pi*20900000000.0*tt))
  let m_d_two12_f2_c = 2*mean(xo*cos(2*pi*21000000000.0*tt))
  let m_d_two12_f2_s = 2*mean(xo*sin(2*pi*21000000000.0*tt))
  let m_d_two12_im3l_c = 2*mean(xo*cos(2*pi*20800000000.0*tt))
  let m_d_two12_im3l_s = 2*mean(xo*sin(2*pi*20800000000.0*tt))
  let m_d_two12_im3h_c = 2*mean(xo*cos(2*pi*21100000000.0*tt))
  let m_d_two12_im3h_s = 2*mean(xo*sin(2*pi*21100000000.0*tt))
  let m_d_two12_fl_lo_c = 2*mean(xo*cos(2*pi*20750000000.0*tt))
  let m_d_two12_fl_lo_s = 2*mean(xo*sin(2*pi*20750000000.0*tt))
  let m_d_two12_fl_hi_c = 2*mean(xo*cos(2*pi*21150000000.0*tt))
  let m_d_two12_fl_hi_s = 2*mean(xo*sin(2*pi*21150000000.0*tt))
  let m_d_two12_vce_q1_max = maximum(v(xdut.c1)[40000,79999] - v(xdut.e1)[40000,79999])
  let m_d_two12_vce_q1_min = minimum(v(xdut.c1)[40000,79999] - v(xdut.e1)[40000,79999])
  let m_d_two12_vce_q2_max = maximum(v(xdut.oc)[40000,79999] - v(xdut.c1)[40000,79999])
  let m_d_two12_vce_q2_min = minimum(v(xdut.oc)[40000,79999] - v(xdut.c1)[40000,79999])
  let m_d_two12_vbe_q1_max = maximum(v(xdut.b1)[40000,79999] - v(xdut.e1)[40000,79999])
  let m_d_two12_vbe_q1_min = minimum(v(xdut.b1)[40000,79999] - v(xdut.e1)[40000,79999])
  let m_d_two12_vbe_q2_max = maximum(v(xdut.b2)[40000,79999] - v(xdut.c1)[40000,79999])
  let m_d_two12_vbe_q2_min = minimum(v(xdut.b2)[40000,79999] - v(xdut.c1)[40000,79999])
  let w_d_two12_ic_q1 = @q.xdut.xq1.qnpn13g2[ic][40000,79999]
  let m_d_two12_ic_q1_max = maximum(w_d_two12_ic_q1)
  let m_d_two12_ic_q1_min = minimum(w_d_two12_ic_q1)
  let w_d_two12_ic_q2 = @q.xdut.xq2.qnpn13g2[ic][40000,79999]
  let m_d_two12_ic_q2_max = maximum(w_d_two12_ic_q2)
  let m_d_two12_ic_q2_min = minimum(w_d_two12_ic_q2)
  print m_d_two12_n m_d_two12_t0 m_d_two12_t1 m_d_two12_f1_c m_d_two12_f1_s m_d_two12_f2_c
  print m_d_two12_f2_s m_d_two12_im3l_c m_d_two12_im3l_s m_d_two12_im3h_c m_d_two12_im3h_s m_d_two12_fl_lo_c
  print m_d_two12_fl_lo_s m_d_two12_fl_hi_c m_d_two12_fl_hi_s m_d_two12_vce_q1_max m_d_two12_vce_q1_min m_d_two12_vce_q2_max
  print m_d_two12_vce_q2_min m_d_two12_vbe_q1_max m_d_two12_vbe_q1_min m_d_two12_vbe_q2_max m_d_two12_vbe_q2_min m_d_two12_ic_q1_max
  print m_d_two12_ic_q1_min m_d_two12_ic_q2_max m_d_two12_ic_q2_min
  * run d_two13: two-tone, available power -43 dBm per tone
  alterparam fq1 = 20900000000.0
  alterparam fq2 = 21000000000.0
  alterparam va1 = 0.00447744227713668
  alterparam va2 = 0.00447744227713668
  reset
  save all @q.xdut.xq1.qnpn13g2[ic] @q.xdut.xq2.qnpn13g2[ic]
  tran 1e-12 8e-08 0 1e-12
  linearize v(p2) v(xdut.c1) v(xdut.e1) v(xdut.oc) v(xdut.b1) v(xdut.b2) @q.xdut.xq1.qnpn13g2[ic] @q.xdut.xq2.qnpn13g2[ic]
  let tt = time[40000,79999]
  let xo = v(p2)[40000,79999]
  let m_d_two13_n = length(xo)
  let m_d_two13_t0 = tt[0]
  let m_d_two13_t1 = tt[39999]
  let m_d_two13_f1_c = 2*mean(xo*cos(2*pi*20900000000.0*tt))
  let m_d_two13_f1_s = 2*mean(xo*sin(2*pi*20900000000.0*tt))
  let m_d_two13_f2_c = 2*mean(xo*cos(2*pi*21000000000.0*tt))
  let m_d_two13_f2_s = 2*mean(xo*sin(2*pi*21000000000.0*tt))
  let m_d_two13_im3l_c = 2*mean(xo*cos(2*pi*20800000000.0*tt))
  let m_d_two13_im3l_s = 2*mean(xo*sin(2*pi*20800000000.0*tt))
  let m_d_two13_im3h_c = 2*mean(xo*cos(2*pi*21100000000.0*tt))
  let m_d_two13_im3h_s = 2*mean(xo*sin(2*pi*21100000000.0*tt))
  let m_d_two13_fl_lo_c = 2*mean(xo*cos(2*pi*20750000000.0*tt))
  let m_d_two13_fl_lo_s = 2*mean(xo*sin(2*pi*20750000000.0*tt))
  let m_d_two13_fl_hi_c = 2*mean(xo*cos(2*pi*21150000000.0*tt))
  let m_d_two13_fl_hi_s = 2*mean(xo*sin(2*pi*21150000000.0*tt))
  let m_d_two13_vce_q1_max = maximum(v(xdut.c1)[40000,79999] - v(xdut.e1)[40000,79999])
  let m_d_two13_vce_q1_min = minimum(v(xdut.c1)[40000,79999] - v(xdut.e1)[40000,79999])
  let m_d_two13_vce_q2_max = maximum(v(xdut.oc)[40000,79999] - v(xdut.c1)[40000,79999])
  let m_d_two13_vce_q2_min = minimum(v(xdut.oc)[40000,79999] - v(xdut.c1)[40000,79999])
  let m_d_two13_vbe_q1_max = maximum(v(xdut.b1)[40000,79999] - v(xdut.e1)[40000,79999])
  let m_d_two13_vbe_q1_min = minimum(v(xdut.b1)[40000,79999] - v(xdut.e1)[40000,79999])
  let m_d_two13_vbe_q2_max = maximum(v(xdut.b2)[40000,79999] - v(xdut.c1)[40000,79999])
  let m_d_two13_vbe_q2_min = minimum(v(xdut.b2)[40000,79999] - v(xdut.c1)[40000,79999])
  let w_d_two13_ic_q1 = @q.xdut.xq1.qnpn13g2[ic][40000,79999]
  let m_d_two13_ic_q1_max = maximum(w_d_two13_ic_q1)
  let m_d_two13_ic_q1_min = minimum(w_d_two13_ic_q1)
  let w_d_two13_ic_q2 = @q.xdut.xq2.qnpn13g2[ic][40000,79999]
  let m_d_two13_ic_q2_max = maximum(w_d_two13_ic_q2)
  let m_d_two13_ic_q2_min = minimum(w_d_two13_ic_q2)
  print m_d_two13_n m_d_two13_t0 m_d_two13_t1 m_d_two13_f1_c m_d_two13_f1_s m_d_two13_f2_c
  print m_d_two13_f2_s m_d_two13_im3l_c m_d_two13_im3l_s m_d_two13_im3h_c m_d_two13_im3h_s m_d_two13_fl_lo_c
  print m_d_two13_fl_lo_s m_d_two13_fl_hi_c m_d_two13_fl_hi_s m_d_two13_vce_q1_max m_d_two13_vce_q1_min m_d_two13_vce_q2_max
  print m_d_two13_vce_q2_min m_d_two13_vbe_q1_max m_d_two13_vbe_q1_min m_d_two13_vbe_q2_max m_d_two13_vbe_q2_min m_d_two13_ic_q1_max
  print m_d_two13_ic_q1_min m_d_two13_ic_q2_max m_d_two13_ic_q2_min
  * run d_two14: two-tone, available power -42 dBm per tone
  alterparam fq1 = 20900000000.0
  alterparam fq2 = 21000000000.0
  alterparam va1 = 0.00502377286301916
  alterparam va2 = 0.00502377286301916
  reset
  save all @q.xdut.xq1.qnpn13g2[ic] @q.xdut.xq2.qnpn13g2[ic]
  tran 1e-12 8e-08 0 1e-12
  linearize v(p2) v(xdut.c1) v(xdut.e1) v(xdut.oc) v(xdut.b1) v(xdut.b2) @q.xdut.xq1.qnpn13g2[ic] @q.xdut.xq2.qnpn13g2[ic]
  let tt = time[40000,79999]
  let xo = v(p2)[40000,79999]
  let m_d_two14_n = length(xo)
  let m_d_two14_t0 = tt[0]
  let m_d_two14_t1 = tt[39999]
  let m_d_two14_f1_c = 2*mean(xo*cos(2*pi*20900000000.0*tt))
  let m_d_two14_f1_s = 2*mean(xo*sin(2*pi*20900000000.0*tt))
  let m_d_two14_f2_c = 2*mean(xo*cos(2*pi*21000000000.0*tt))
  let m_d_two14_f2_s = 2*mean(xo*sin(2*pi*21000000000.0*tt))
  let m_d_two14_im3l_c = 2*mean(xo*cos(2*pi*20800000000.0*tt))
  let m_d_two14_im3l_s = 2*mean(xo*sin(2*pi*20800000000.0*tt))
  let m_d_two14_im3h_c = 2*mean(xo*cos(2*pi*21100000000.0*tt))
  let m_d_two14_im3h_s = 2*mean(xo*sin(2*pi*21100000000.0*tt))
  let m_d_two14_fl_lo_c = 2*mean(xo*cos(2*pi*20750000000.0*tt))
  let m_d_two14_fl_lo_s = 2*mean(xo*sin(2*pi*20750000000.0*tt))
  let m_d_two14_fl_hi_c = 2*mean(xo*cos(2*pi*21150000000.0*tt))
  let m_d_two14_fl_hi_s = 2*mean(xo*sin(2*pi*21150000000.0*tt))
  let m_d_two14_vce_q1_max = maximum(v(xdut.c1)[40000,79999] - v(xdut.e1)[40000,79999])
  let m_d_two14_vce_q1_min = minimum(v(xdut.c1)[40000,79999] - v(xdut.e1)[40000,79999])
  let m_d_two14_vce_q2_max = maximum(v(xdut.oc)[40000,79999] - v(xdut.c1)[40000,79999])
  let m_d_two14_vce_q2_min = minimum(v(xdut.oc)[40000,79999] - v(xdut.c1)[40000,79999])
  let m_d_two14_vbe_q1_max = maximum(v(xdut.b1)[40000,79999] - v(xdut.e1)[40000,79999])
  let m_d_two14_vbe_q1_min = minimum(v(xdut.b1)[40000,79999] - v(xdut.e1)[40000,79999])
  let m_d_two14_vbe_q2_max = maximum(v(xdut.b2)[40000,79999] - v(xdut.c1)[40000,79999])
  let m_d_two14_vbe_q2_min = minimum(v(xdut.b2)[40000,79999] - v(xdut.c1)[40000,79999])
  let w_d_two14_ic_q1 = @q.xdut.xq1.qnpn13g2[ic][40000,79999]
  let m_d_two14_ic_q1_max = maximum(w_d_two14_ic_q1)
  let m_d_two14_ic_q1_min = minimum(w_d_two14_ic_q1)
  let w_d_two14_ic_q2 = @q.xdut.xq2.qnpn13g2[ic][40000,79999]
  let m_d_two14_ic_q2_max = maximum(w_d_two14_ic_q2)
  let m_d_two14_ic_q2_min = minimum(w_d_two14_ic_q2)
  print m_d_two14_n m_d_two14_t0 m_d_two14_t1 m_d_two14_f1_c m_d_two14_f1_s m_d_two14_f2_c
  print m_d_two14_f2_s m_d_two14_im3l_c m_d_two14_im3l_s m_d_two14_im3h_c m_d_two14_im3h_s m_d_two14_fl_lo_c
  print m_d_two14_fl_lo_s m_d_two14_fl_hi_c m_d_two14_fl_hi_s m_d_two14_vce_q1_max m_d_two14_vce_q1_min m_d_two14_vce_q2_max
  print m_d_two14_vce_q2_min m_d_two14_vbe_q1_max m_d_two14_vbe_q1_min m_d_two14_vbe_q2_max m_d_two14_vbe_q2_min m_d_two14_ic_q1_max
  print m_d_two14_ic_q1_min m_d_two14_ic_q2_max m_d_two14_ic_q2_min
  * run d_two15: two-tone, available power -41 dBm per tone
  alterparam fq1 = 20900000000.0
  alterparam fq2 = 21000000000.0
  alterparam va1 = 0.00563676586252891
  alterparam va2 = 0.00563676586252891
  reset
  save all @q.xdut.xq1.qnpn13g2[ic] @q.xdut.xq2.qnpn13g2[ic]
  tran 1e-12 8e-08 0 1e-12
  linearize v(p2) v(xdut.c1) v(xdut.e1) v(xdut.oc) v(xdut.b1) v(xdut.b2) @q.xdut.xq1.qnpn13g2[ic] @q.xdut.xq2.qnpn13g2[ic]
  let tt = time[40000,79999]
  let xo = v(p2)[40000,79999]
  let m_d_two15_n = length(xo)
  let m_d_two15_t0 = tt[0]
  let m_d_two15_t1 = tt[39999]
  let m_d_two15_f1_c = 2*mean(xo*cos(2*pi*20900000000.0*tt))
  let m_d_two15_f1_s = 2*mean(xo*sin(2*pi*20900000000.0*tt))
  let m_d_two15_f2_c = 2*mean(xo*cos(2*pi*21000000000.0*tt))
  let m_d_two15_f2_s = 2*mean(xo*sin(2*pi*21000000000.0*tt))
  let m_d_two15_im3l_c = 2*mean(xo*cos(2*pi*20800000000.0*tt))
  let m_d_two15_im3l_s = 2*mean(xo*sin(2*pi*20800000000.0*tt))
  let m_d_two15_im3h_c = 2*mean(xo*cos(2*pi*21100000000.0*tt))
  let m_d_two15_im3h_s = 2*mean(xo*sin(2*pi*21100000000.0*tt))
  let m_d_two15_fl_lo_c = 2*mean(xo*cos(2*pi*20750000000.0*tt))
  let m_d_two15_fl_lo_s = 2*mean(xo*sin(2*pi*20750000000.0*tt))
  let m_d_two15_fl_hi_c = 2*mean(xo*cos(2*pi*21150000000.0*tt))
  let m_d_two15_fl_hi_s = 2*mean(xo*sin(2*pi*21150000000.0*tt))
  let m_d_two15_vce_q1_max = maximum(v(xdut.c1)[40000,79999] - v(xdut.e1)[40000,79999])
  let m_d_two15_vce_q1_min = minimum(v(xdut.c1)[40000,79999] - v(xdut.e1)[40000,79999])
  let m_d_two15_vce_q2_max = maximum(v(xdut.oc)[40000,79999] - v(xdut.c1)[40000,79999])
  let m_d_two15_vce_q2_min = minimum(v(xdut.oc)[40000,79999] - v(xdut.c1)[40000,79999])
  let m_d_two15_vbe_q1_max = maximum(v(xdut.b1)[40000,79999] - v(xdut.e1)[40000,79999])
  let m_d_two15_vbe_q1_min = minimum(v(xdut.b1)[40000,79999] - v(xdut.e1)[40000,79999])
  let m_d_two15_vbe_q2_max = maximum(v(xdut.b2)[40000,79999] - v(xdut.c1)[40000,79999])
  let m_d_two15_vbe_q2_min = minimum(v(xdut.b2)[40000,79999] - v(xdut.c1)[40000,79999])
  let w_d_two15_ic_q1 = @q.xdut.xq1.qnpn13g2[ic][40000,79999]
  let m_d_two15_ic_q1_max = maximum(w_d_two15_ic_q1)
  let m_d_two15_ic_q1_min = minimum(w_d_two15_ic_q1)
  let w_d_two15_ic_q2 = @q.xdut.xq2.qnpn13g2[ic][40000,79999]
  let m_d_two15_ic_q2_max = maximum(w_d_two15_ic_q2)
  let m_d_two15_ic_q2_min = minimum(w_d_two15_ic_q2)
  print m_d_two15_n m_d_two15_t0 m_d_two15_t1 m_d_two15_f1_c m_d_two15_f1_s m_d_two15_f2_c
  print m_d_two15_f2_s m_d_two15_im3l_c m_d_two15_im3l_s m_d_two15_im3h_c m_d_two15_im3h_s m_d_two15_fl_lo_c
  print m_d_two15_fl_lo_s m_d_two15_fl_hi_c m_d_two15_fl_hi_s m_d_two15_vce_q1_max m_d_two15_vce_q1_min m_d_two15_vce_q2_max
  print m_d_two15_vce_q2_min m_d_two15_vbe_q1_max m_d_two15_vbe_q1_min m_d_two15_vbe_q2_max m_d_two15_vbe_q2_min m_d_two15_ic_q1_max
  print m_d_two15_ic_q1_min m_d_two15_ic_q2_max m_d_two15_ic_q2_min
  * run d_two16: two-tone, available power -40 dBm per tone
  alterparam fq1 = 20900000000.0
  alterparam fq2 = 21000000000.0
  alterparam va1 = 0.00632455532033676
  alterparam va2 = 0.00632455532033676
  reset
  save all @q.xdut.xq1.qnpn13g2[ic] @q.xdut.xq2.qnpn13g2[ic]
  tran 1e-12 8e-08 0 1e-12
  linearize v(p2) v(xdut.c1) v(xdut.e1) v(xdut.oc) v(xdut.b1) v(xdut.b2) @q.xdut.xq1.qnpn13g2[ic] @q.xdut.xq2.qnpn13g2[ic]
  let tt = time[40000,79999]
  let xo = v(p2)[40000,79999]
  let m_d_two16_n = length(xo)
  let m_d_two16_t0 = tt[0]
  let m_d_two16_t1 = tt[39999]
  let m_d_two16_f1_c = 2*mean(xo*cos(2*pi*20900000000.0*tt))
  let m_d_two16_f1_s = 2*mean(xo*sin(2*pi*20900000000.0*tt))
  let m_d_two16_f2_c = 2*mean(xo*cos(2*pi*21000000000.0*tt))
  let m_d_two16_f2_s = 2*mean(xo*sin(2*pi*21000000000.0*tt))
  let m_d_two16_im3l_c = 2*mean(xo*cos(2*pi*20800000000.0*tt))
  let m_d_two16_im3l_s = 2*mean(xo*sin(2*pi*20800000000.0*tt))
  let m_d_two16_im3h_c = 2*mean(xo*cos(2*pi*21100000000.0*tt))
  let m_d_two16_im3h_s = 2*mean(xo*sin(2*pi*21100000000.0*tt))
  let m_d_two16_fl_lo_c = 2*mean(xo*cos(2*pi*20750000000.0*tt))
  let m_d_two16_fl_lo_s = 2*mean(xo*sin(2*pi*20750000000.0*tt))
  let m_d_two16_fl_hi_c = 2*mean(xo*cos(2*pi*21150000000.0*tt))
  let m_d_two16_fl_hi_s = 2*mean(xo*sin(2*pi*21150000000.0*tt))
  let m_d_two16_vce_q1_max = maximum(v(xdut.c1)[40000,79999] - v(xdut.e1)[40000,79999])
  let m_d_two16_vce_q1_min = minimum(v(xdut.c1)[40000,79999] - v(xdut.e1)[40000,79999])
  let m_d_two16_vce_q2_max = maximum(v(xdut.oc)[40000,79999] - v(xdut.c1)[40000,79999])
  let m_d_two16_vce_q2_min = minimum(v(xdut.oc)[40000,79999] - v(xdut.c1)[40000,79999])
  let m_d_two16_vbe_q1_max = maximum(v(xdut.b1)[40000,79999] - v(xdut.e1)[40000,79999])
  let m_d_two16_vbe_q1_min = minimum(v(xdut.b1)[40000,79999] - v(xdut.e1)[40000,79999])
  let m_d_two16_vbe_q2_max = maximum(v(xdut.b2)[40000,79999] - v(xdut.c1)[40000,79999])
  let m_d_two16_vbe_q2_min = minimum(v(xdut.b2)[40000,79999] - v(xdut.c1)[40000,79999])
  let w_d_two16_ic_q1 = @q.xdut.xq1.qnpn13g2[ic][40000,79999]
  let m_d_two16_ic_q1_max = maximum(w_d_two16_ic_q1)
  let m_d_two16_ic_q1_min = minimum(w_d_two16_ic_q1)
  let w_d_two16_ic_q2 = @q.xdut.xq2.qnpn13g2[ic][40000,79999]
  let m_d_two16_ic_q2_max = maximum(w_d_two16_ic_q2)
  let m_d_two16_ic_q2_min = minimum(w_d_two16_ic_q2)
  print m_d_two16_n m_d_two16_t0 m_d_two16_t1 m_d_two16_f1_c m_d_two16_f1_s m_d_two16_f2_c
  print m_d_two16_f2_s m_d_two16_im3l_c m_d_two16_im3l_s m_d_two16_im3h_c m_d_two16_im3h_s m_d_two16_fl_lo_c
  print m_d_two16_fl_lo_s m_d_two16_fl_hi_c m_d_two16_fl_hi_s m_d_two16_vce_q1_max m_d_two16_vce_q1_min m_d_two16_vce_q2_max
  print m_d_two16_vce_q2_min m_d_two16_vbe_q1_max m_d_two16_vbe_q1_min m_d_two16_vbe_q2_max m_d_two16_vbe_q2_min m_d_two16_ic_q1_max
  print m_d_two16_ic_q1_min m_d_two16_ic_q2_max m_d_two16_ic_q2_min
  * run d_two17: two-tone, available power -39 dBm per tone
  alterparam fq1 = 20900000000.0
  alterparam fq2 = 21000000000.0
  alterparam va1 = 0.00709626778467151
  alterparam va2 = 0.00709626778467151
  reset
  save all @q.xdut.xq1.qnpn13g2[ic] @q.xdut.xq2.qnpn13g2[ic]
  tran 1e-12 8e-08 0 1e-12
  linearize v(p2) v(xdut.c1) v(xdut.e1) v(xdut.oc) v(xdut.b1) v(xdut.b2) @q.xdut.xq1.qnpn13g2[ic] @q.xdut.xq2.qnpn13g2[ic]
  let tt = time[40000,79999]
  let xo = v(p2)[40000,79999]
  let m_d_two17_n = length(xo)
  let m_d_two17_t0 = tt[0]
  let m_d_two17_t1 = tt[39999]
  let m_d_two17_f1_c = 2*mean(xo*cos(2*pi*20900000000.0*tt))
  let m_d_two17_f1_s = 2*mean(xo*sin(2*pi*20900000000.0*tt))
  let m_d_two17_f2_c = 2*mean(xo*cos(2*pi*21000000000.0*tt))
  let m_d_two17_f2_s = 2*mean(xo*sin(2*pi*21000000000.0*tt))
  let m_d_two17_im3l_c = 2*mean(xo*cos(2*pi*20800000000.0*tt))
  let m_d_two17_im3l_s = 2*mean(xo*sin(2*pi*20800000000.0*tt))
  let m_d_two17_im3h_c = 2*mean(xo*cos(2*pi*21100000000.0*tt))
  let m_d_two17_im3h_s = 2*mean(xo*sin(2*pi*21100000000.0*tt))
  let m_d_two17_fl_lo_c = 2*mean(xo*cos(2*pi*20750000000.0*tt))
  let m_d_two17_fl_lo_s = 2*mean(xo*sin(2*pi*20750000000.0*tt))
  let m_d_two17_fl_hi_c = 2*mean(xo*cos(2*pi*21150000000.0*tt))
  let m_d_two17_fl_hi_s = 2*mean(xo*sin(2*pi*21150000000.0*tt))
  let m_d_two17_vce_q1_max = maximum(v(xdut.c1)[40000,79999] - v(xdut.e1)[40000,79999])
  let m_d_two17_vce_q1_min = minimum(v(xdut.c1)[40000,79999] - v(xdut.e1)[40000,79999])
  let m_d_two17_vce_q2_max = maximum(v(xdut.oc)[40000,79999] - v(xdut.c1)[40000,79999])
  let m_d_two17_vce_q2_min = minimum(v(xdut.oc)[40000,79999] - v(xdut.c1)[40000,79999])
  let m_d_two17_vbe_q1_max = maximum(v(xdut.b1)[40000,79999] - v(xdut.e1)[40000,79999])
  let m_d_two17_vbe_q1_min = minimum(v(xdut.b1)[40000,79999] - v(xdut.e1)[40000,79999])
  let m_d_two17_vbe_q2_max = maximum(v(xdut.b2)[40000,79999] - v(xdut.c1)[40000,79999])
  let m_d_two17_vbe_q2_min = minimum(v(xdut.b2)[40000,79999] - v(xdut.c1)[40000,79999])
  let w_d_two17_ic_q1 = @q.xdut.xq1.qnpn13g2[ic][40000,79999]
  let m_d_two17_ic_q1_max = maximum(w_d_two17_ic_q1)
  let m_d_two17_ic_q1_min = minimum(w_d_two17_ic_q1)
  let w_d_two17_ic_q2 = @q.xdut.xq2.qnpn13g2[ic][40000,79999]
  let m_d_two17_ic_q2_max = maximum(w_d_two17_ic_q2)
  let m_d_two17_ic_q2_min = minimum(w_d_two17_ic_q2)
  print m_d_two17_n m_d_two17_t0 m_d_two17_t1 m_d_two17_f1_c m_d_two17_f1_s m_d_two17_f2_c
  print m_d_two17_f2_s m_d_two17_im3l_c m_d_two17_im3l_s m_d_two17_im3h_c m_d_two17_im3h_s m_d_two17_fl_lo_c
  print m_d_two17_fl_lo_s m_d_two17_fl_hi_c m_d_two17_fl_hi_s m_d_two17_vce_q1_max m_d_two17_vce_q1_min m_d_two17_vce_q2_max
  print m_d_two17_vce_q2_min m_d_two17_vbe_q1_max m_d_two17_vbe_q1_min m_d_two17_vbe_q2_max m_d_two17_vbe_q2_min m_d_two17_ic_q1_max
  print m_d_two17_ic_q1_min m_d_two17_ic_q2_max m_d_two17_ic_q2_min
  * run d_two18: two-tone, available power -38 dBm per tone
  alterparam fq1 = 20900000000.0
  alterparam fq2 = 21000000000.0
  alterparam va1 = 0.00796214341106995
  alterparam va2 = 0.00796214341106995
  reset
  save all @q.xdut.xq1.qnpn13g2[ic] @q.xdut.xq2.qnpn13g2[ic]
  tran 1e-12 8e-08 0 1e-12
  linearize v(p2) v(xdut.c1) v(xdut.e1) v(xdut.oc) v(xdut.b1) v(xdut.b2) @q.xdut.xq1.qnpn13g2[ic] @q.xdut.xq2.qnpn13g2[ic]
  let tt = time[40000,79999]
  let xo = v(p2)[40000,79999]
  let m_d_two18_n = length(xo)
  let m_d_two18_t0 = tt[0]
  let m_d_two18_t1 = tt[39999]
  let m_d_two18_f1_c = 2*mean(xo*cos(2*pi*20900000000.0*tt))
  let m_d_two18_f1_s = 2*mean(xo*sin(2*pi*20900000000.0*tt))
  let m_d_two18_f2_c = 2*mean(xo*cos(2*pi*21000000000.0*tt))
  let m_d_two18_f2_s = 2*mean(xo*sin(2*pi*21000000000.0*tt))
  let m_d_two18_im3l_c = 2*mean(xo*cos(2*pi*20800000000.0*tt))
  let m_d_two18_im3l_s = 2*mean(xo*sin(2*pi*20800000000.0*tt))
  let m_d_two18_im3h_c = 2*mean(xo*cos(2*pi*21100000000.0*tt))
  let m_d_two18_im3h_s = 2*mean(xo*sin(2*pi*21100000000.0*tt))
  let m_d_two18_fl_lo_c = 2*mean(xo*cos(2*pi*20750000000.0*tt))
  let m_d_two18_fl_lo_s = 2*mean(xo*sin(2*pi*20750000000.0*tt))
  let m_d_two18_fl_hi_c = 2*mean(xo*cos(2*pi*21150000000.0*tt))
  let m_d_two18_fl_hi_s = 2*mean(xo*sin(2*pi*21150000000.0*tt))
  let m_d_two18_vce_q1_max = maximum(v(xdut.c1)[40000,79999] - v(xdut.e1)[40000,79999])
  let m_d_two18_vce_q1_min = minimum(v(xdut.c1)[40000,79999] - v(xdut.e1)[40000,79999])
  let m_d_two18_vce_q2_max = maximum(v(xdut.oc)[40000,79999] - v(xdut.c1)[40000,79999])
  let m_d_two18_vce_q2_min = minimum(v(xdut.oc)[40000,79999] - v(xdut.c1)[40000,79999])
  let m_d_two18_vbe_q1_max = maximum(v(xdut.b1)[40000,79999] - v(xdut.e1)[40000,79999])
  let m_d_two18_vbe_q1_min = minimum(v(xdut.b1)[40000,79999] - v(xdut.e1)[40000,79999])
  let m_d_two18_vbe_q2_max = maximum(v(xdut.b2)[40000,79999] - v(xdut.c1)[40000,79999])
  let m_d_two18_vbe_q2_min = minimum(v(xdut.b2)[40000,79999] - v(xdut.c1)[40000,79999])
  let w_d_two18_ic_q1 = @q.xdut.xq1.qnpn13g2[ic][40000,79999]
  let m_d_two18_ic_q1_max = maximum(w_d_two18_ic_q1)
  let m_d_two18_ic_q1_min = minimum(w_d_two18_ic_q1)
  let w_d_two18_ic_q2 = @q.xdut.xq2.qnpn13g2[ic][40000,79999]
  let m_d_two18_ic_q2_max = maximum(w_d_two18_ic_q2)
  let m_d_two18_ic_q2_min = minimum(w_d_two18_ic_q2)
  print m_d_two18_n m_d_two18_t0 m_d_two18_t1 m_d_two18_f1_c m_d_two18_f1_s m_d_two18_f2_c
  print m_d_two18_f2_s m_d_two18_im3l_c m_d_two18_im3l_s m_d_two18_im3h_c m_d_two18_im3h_s m_d_two18_fl_lo_c
  print m_d_two18_fl_lo_s m_d_two18_fl_hi_c m_d_two18_fl_hi_s m_d_two18_vce_q1_max m_d_two18_vce_q1_min m_d_two18_vce_q2_max
  print m_d_two18_vce_q2_min m_d_two18_vbe_q1_max m_d_two18_vbe_q1_min m_d_two18_vbe_q2_max m_d_two18_vbe_q2_min m_d_two18_ic_q1_max
  print m_d_two18_ic_q1_min m_d_two18_ic_q2_max m_d_two18_ic_q2_min
  * run d_two19: two-tone, available power -37 dBm per tone
  alterparam fq1 = 20900000000.0
  alterparam fq2 = 21000000000.0
  alterparam va1 = 0.00893367184301926
  alterparam va2 = 0.00893367184301926
  reset
  save all @q.xdut.xq1.qnpn13g2[ic] @q.xdut.xq2.qnpn13g2[ic]
  tran 1e-12 8e-08 0 1e-12
  linearize v(p2) v(xdut.c1) v(xdut.e1) v(xdut.oc) v(xdut.b1) v(xdut.b2) @q.xdut.xq1.qnpn13g2[ic] @q.xdut.xq2.qnpn13g2[ic]
  let tt = time[40000,79999]
  let xo = v(p2)[40000,79999]
  let m_d_two19_n = length(xo)
  let m_d_two19_t0 = tt[0]
  let m_d_two19_t1 = tt[39999]
  let m_d_two19_f1_c = 2*mean(xo*cos(2*pi*20900000000.0*tt))
  let m_d_two19_f1_s = 2*mean(xo*sin(2*pi*20900000000.0*tt))
  let m_d_two19_f2_c = 2*mean(xo*cos(2*pi*21000000000.0*tt))
  let m_d_two19_f2_s = 2*mean(xo*sin(2*pi*21000000000.0*tt))
  let m_d_two19_im3l_c = 2*mean(xo*cos(2*pi*20800000000.0*tt))
  let m_d_two19_im3l_s = 2*mean(xo*sin(2*pi*20800000000.0*tt))
  let m_d_two19_im3h_c = 2*mean(xo*cos(2*pi*21100000000.0*tt))
  let m_d_two19_im3h_s = 2*mean(xo*sin(2*pi*21100000000.0*tt))
  let m_d_two19_fl_lo_c = 2*mean(xo*cos(2*pi*20750000000.0*tt))
  let m_d_two19_fl_lo_s = 2*mean(xo*sin(2*pi*20750000000.0*tt))
  let m_d_two19_fl_hi_c = 2*mean(xo*cos(2*pi*21150000000.0*tt))
  let m_d_two19_fl_hi_s = 2*mean(xo*sin(2*pi*21150000000.0*tt))
  let m_d_two19_vce_q1_max = maximum(v(xdut.c1)[40000,79999] - v(xdut.e1)[40000,79999])
  let m_d_two19_vce_q1_min = minimum(v(xdut.c1)[40000,79999] - v(xdut.e1)[40000,79999])
  let m_d_two19_vce_q2_max = maximum(v(xdut.oc)[40000,79999] - v(xdut.c1)[40000,79999])
  let m_d_two19_vce_q2_min = minimum(v(xdut.oc)[40000,79999] - v(xdut.c1)[40000,79999])
  let m_d_two19_vbe_q1_max = maximum(v(xdut.b1)[40000,79999] - v(xdut.e1)[40000,79999])
  let m_d_two19_vbe_q1_min = minimum(v(xdut.b1)[40000,79999] - v(xdut.e1)[40000,79999])
  let m_d_two19_vbe_q2_max = maximum(v(xdut.b2)[40000,79999] - v(xdut.c1)[40000,79999])
  let m_d_two19_vbe_q2_min = minimum(v(xdut.b2)[40000,79999] - v(xdut.c1)[40000,79999])
  let w_d_two19_ic_q1 = @q.xdut.xq1.qnpn13g2[ic][40000,79999]
  let m_d_two19_ic_q1_max = maximum(w_d_two19_ic_q1)
  let m_d_two19_ic_q1_min = minimum(w_d_two19_ic_q1)
  let w_d_two19_ic_q2 = @q.xdut.xq2.qnpn13g2[ic][40000,79999]
  let m_d_two19_ic_q2_max = maximum(w_d_two19_ic_q2)
  let m_d_two19_ic_q2_min = minimum(w_d_two19_ic_q2)
  print m_d_two19_n m_d_two19_t0 m_d_two19_t1 m_d_two19_f1_c m_d_two19_f1_s m_d_two19_f2_c
  print m_d_two19_f2_s m_d_two19_im3l_c m_d_two19_im3l_s m_d_two19_im3h_c m_d_two19_im3h_s m_d_two19_fl_lo_c
  print m_d_two19_fl_lo_s m_d_two19_fl_hi_c m_d_two19_fl_hi_s m_d_two19_vce_q1_max m_d_two19_vce_q1_min m_d_two19_vce_q2_max
  print m_d_two19_vce_q2_min m_d_two19_vbe_q1_max m_d_two19_vbe_q1_min m_d_two19_vbe_q2_max m_d_two19_vbe_q2_min m_d_two19_ic_q1_max
  print m_d_two19_ic_q1_min m_d_two19_ic_q2_max m_d_two19_ic_q2_min
  * run d_two20: two-tone, available power -36 dBm per tone
  alterparam fq1 = 20900000000.0
  alterparam fq2 = 21000000000.0
  alterparam va1 = 0.0100237446725454
  alterparam va2 = 0.0100237446725454
  reset
  save all @q.xdut.xq1.qnpn13g2[ic] @q.xdut.xq2.qnpn13g2[ic]
  tran 1e-12 8e-08 0 1e-12
  linearize v(p2) v(xdut.c1) v(xdut.e1) v(xdut.oc) v(xdut.b1) v(xdut.b2) @q.xdut.xq1.qnpn13g2[ic] @q.xdut.xq2.qnpn13g2[ic]
  let tt = time[40000,79999]
  let xo = v(p2)[40000,79999]
  let m_d_two20_n = length(xo)
  let m_d_two20_t0 = tt[0]
  let m_d_two20_t1 = tt[39999]
  let m_d_two20_f1_c = 2*mean(xo*cos(2*pi*20900000000.0*tt))
  let m_d_two20_f1_s = 2*mean(xo*sin(2*pi*20900000000.0*tt))
  let m_d_two20_f2_c = 2*mean(xo*cos(2*pi*21000000000.0*tt))
  let m_d_two20_f2_s = 2*mean(xo*sin(2*pi*21000000000.0*tt))
  let m_d_two20_im3l_c = 2*mean(xo*cos(2*pi*20800000000.0*tt))
  let m_d_two20_im3l_s = 2*mean(xo*sin(2*pi*20800000000.0*tt))
  let m_d_two20_im3h_c = 2*mean(xo*cos(2*pi*21100000000.0*tt))
  let m_d_two20_im3h_s = 2*mean(xo*sin(2*pi*21100000000.0*tt))
  let m_d_two20_fl_lo_c = 2*mean(xo*cos(2*pi*20750000000.0*tt))
  let m_d_two20_fl_lo_s = 2*mean(xo*sin(2*pi*20750000000.0*tt))
  let m_d_two20_fl_hi_c = 2*mean(xo*cos(2*pi*21150000000.0*tt))
  let m_d_two20_fl_hi_s = 2*mean(xo*sin(2*pi*21150000000.0*tt))
  let m_d_two20_vce_q1_max = maximum(v(xdut.c1)[40000,79999] - v(xdut.e1)[40000,79999])
  let m_d_two20_vce_q1_min = minimum(v(xdut.c1)[40000,79999] - v(xdut.e1)[40000,79999])
  let m_d_two20_vce_q2_max = maximum(v(xdut.oc)[40000,79999] - v(xdut.c1)[40000,79999])
  let m_d_two20_vce_q2_min = minimum(v(xdut.oc)[40000,79999] - v(xdut.c1)[40000,79999])
  let m_d_two20_vbe_q1_max = maximum(v(xdut.b1)[40000,79999] - v(xdut.e1)[40000,79999])
  let m_d_two20_vbe_q1_min = minimum(v(xdut.b1)[40000,79999] - v(xdut.e1)[40000,79999])
  let m_d_two20_vbe_q2_max = maximum(v(xdut.b2)[40000,79999] - v(xdut.c1)[40000,79999])
  let m_d_two20_vbe_q2_min = minimum(v(xdut.b2)[40000,79999] - v(xdut.c1)[40000,79999])
  let w_d_two20_ic_q1 = @q.xdut.xq1.qnpn13g2[ic][40000,79999]
  let m_d_two20_ic_q1_max = maximum(w_d_two20_ic_q1)
  let m_d_two20_ic_q1_min = minimum(w_d_two20_ic_q1)
  let w_d_two20_ic_q2 = @q.xdut.xq2.qnpn13g2[ic][40000,79999]
  let m_d_two20_ic_q2_max = maximum(w_d_two20_ic_q2)
  let m_d_two20_ic_q2_min = minimum(w_d_two20_ic_q2)
  print m_d_two20_n m_d_two20_t0 m_d_two20_t1 m_d_two20_f1_c m_d_two20_f1_s m_d_two20_f2_c
  print m_d_two20_f2_s m_d_two20_im3l_c m_d_two20_im3l_s m_d_two20_im3h_c m_d_two20_im3h_s m_d_two20_fl_lo_c
  print m_d_two20_fl_lo_s m_d_two20_fl_hi_c m_d_two20_fl_hi_s m_d_two20_vce_q1_max m_d_two20_vce_q1_min m_d_two20_vce_q2_max
  print m_d_two20_vce_q2_min m_d_two20_vbe_q1_max m_d_two20_vbe_q1_min m_d_two20_vbe_q2_max m_d_two20_vbe_q2_min m_d_two20_ic_q1_max
  print m_d_two20_ic_q1_min m_d_two20_ic_q2_max m_d_two20_ic_q2_min
  echo LNLIN_DONE
.endc
