* lna-linearity control_one -- GENERATED by sim/lna-linearity/run.py, do not edit
.param z0=50
.param va1=0 va2=0

Rin p1 0 {z0}
Bamp ya 0 V = 10.0*v(p1) + -2000.0*v(p1)*v(p1)*v(p1)
Rout ya p2 {z0}
.options reltol=1e-06
.param fq1=1e10 fq2=1e10
Bs n2 0 V = (time<5e-09 ? 0.5*(1-cos(pi*time/5e-09)) : 1)*({va1}*sin(2*pi*{fq1}*time) + {va2}*sin(2*pi*{fq2}*time))
Rs n2 p1 {z0}
RL p2 0 {z0}

.control
set numdgt=12
set noaskquit
  * run b_one00: one-tone, available power -56 dBm per tone
  alterparam fq1 = 19450000000.0
  alterparam fq2 = 19450000000.0
  alterparam va1 = 0.00100237446725455
  alterparam va2 = 0.0
  reset
  tran 1e-12 6e-08 0 1e-12
  linearize v(p2)
  let tt = time[40000,59999]
  let xo = v(p2)[40000,59999]
  let m_b_one00_n = length(xo)
  let m_b_one00_t0 = tt[0]
  let m_b_one00_t1 = tt[19999]
  let m_b_one00_f0_c = 2*mean(xo*cos(2*pi*19450000000.0*tt))
  let m_b_one00_f0_s = 2*mean(xo*sin(2*pi*19450000000.0*tt))
  let m_b_one00_fl_lo_c = 2*mean(xo*cos(2*pi*19400000000.0*tt))
  let m_b_one00_fl_lo_s = 2*mean(xo*sin(2*pi*19400000000.0*tt))
  let m_b_one00_fl_hi_c = 2*mean(xo*cos(2*pi*19500000000.0*tt))
  let m_b_one00_fl_hi_s = 2*mean(xo*sin(2*pi*19500000000.0*tt))
  print m_b_one00_n m_b_one00_t0 m_b_one00_t1 m_b_one00_f0_c m_b_one00_f0_s m_b_one00_fl_lo_c
  print m_b_one00_fl_lo_s m_b_one00_fl_hi_c m_b_one00_fl_hi_s
  * run b_one01: one-tone, available power -54 dBm per tone
  alterparam fq1 = 19450000000.0
  alterparam fq2 = 19450000000.0
  alterparam va1 = 0.00126191468896039
  alterparam va2 = 0.0
  reset
  tran 1e-12 6e-08 0 1e-12
  linearize v(p2)
  let tt = time[40000,59999]
  let xo = v(p2)[40000,59999]
  let m_b_one01_n = length(xo)
  let m_b_one01_t0 = tt[0]
  let m_b_one01_t1 = tt[19999]
  let m_b_one01_f0_c = 2*mean(xo*cos(2*pi*19450000000.0*tt))
  let m_b_one01_f0_s = 2*mean(xo*sin(2*pi*19450000000.0*tt))
  let m_b_one01_fl_lo_c = 2*mean(xo*cos(2*pi*19400000000.0*tt))
  let m_b_one01_fl_lo_s = 2*mean(xo*sin(2*pi*19400000000.0*tt))
  let m_b_one01_fl_hi_c = 2*mean(xo*cos(2*pi*19500000000.0*tt))
  let m_b_one01_fl_hi_s = 2*mean(xo*sin(2*pi*19500000000.0*tt))
  print m_b_one01_n m_b_one01_t0 m_b_one01_t1 m_b_one01_f0_c m_b_one01_f0_s m_b_one01_fl_lo_c
  print m_b_one01_fl_lo_s m_b_one01_fl_hi_c m_b_one01_fl_hi_s
  * run b_one02: one-tone, available power -52 dBm per tone
  alterparam fq1 = 19450000000.0
  alterparam fq2 = 19450000000.0
  alterparam va1 = 0.00158865646944856
  alterparam va2 = 0.0
  reset
  tran 1e-12 6e-08 0 1e-12
  linearize v(p2)
  let tt = time[40000,59999]
  let xo = v(p2)[40000,59999]
  let m_b_one02_n = length(xo)
  let m_b_one02_t0 = tt[0]
  let m_b_one02_t1 = tt[19999]
  let m_b_one02_f0_c = 2*mean(xo*cos(2*pi*19450000000.0*tt))
  let m_b_one02_f0_s = 2*mean(xo*sin(2*pi*19450000000.0*tt))
  let m_b_one02_fl_lo_c = 2*mean(xo*cos(2*pi*19400000000.0*tt))
  let m_b_one02_fl_lo_s = 2*mean(xo*sin(2*pi*19400000000.0*tt))
  let m_b_one02_fl_hi_c = 2*mean(xo*cos(2*pi*19500000000.0*tt))
  let m_b_one02_fl_hi_s = 2*mean(xo*sin(2*pi*19500000000.0*tt))
  print m_b_one02_n m_b_one02_t0 m_b_one02_t1 m_b_one02_f0_c m_b_one02_f0_s m_b_one02_fl_lo_c
  print m_b_one02_fl_lo_s m_b_one02_fl_hi_c m_b_one02_fl_hi_s
  * run b_one03: one-tone, available power -50 dBm per tone
  alterparam fq1 = 19450000000.0
  alterparam fq2 = 19450000000.0
  alterparam va1 = 0.002
  alterparam va2 = 0.0
  reset
  tran 1e-12 6e-08 0 1e-12
  linearize v(p2)
  let tt = time[40000,59999]
  let xo = v(p2)[40000,59999]
  let m_b_one03_n = length(xo)
  let m_b_one03_t0 = tt[0]
  let m_b_one03_t1 = tt[19999]
  let m_b_one03_f0_c = 2*mean(xo*cos(2*pi*19450000000.0*tt))
  let m_b_one03_f0_s = 2*mean(xo*sin(2*pi*19450000000.0*tt))
  let m_b_one03_fl_lo_c = 2*mean(xo*cos(2*pi*19400000000.0*tt))
  let m_b_one03_fl_lo_s = 2*mean(xo*sin(2*pi*19400000000.0*tt))
  let m_b_one03_fl_hi_c = 2*mean(xo*cos(2*pi*19500000000.0*tt))
  let m_b_one03_fl_hi_s = 2*mean(xo*sin(2*pi*19500000000.0*tt))
  print m_b_one03_n m_b_one03_t0 m_b_one03_t1 m_b_one03_f0_c m_b_one03_f0_s m_b_one03_fl_lo_c
  print m_b_one03_fl_lo_s m_b_one03_fl_hi_c m_b_one03_fl_hi_s
  * run b_one04: one-tone, available power -48 dBm per tone
  alterparam fq1 = 19450000000.0
  alterparam fq2 = 19450000000.0
  alterparam va1 = 0.00251785082358833
  alterparam va2 = 0.0
  reset
  tran 1e-12 6e-08 0 1e-12
  linearize v(p2)
  let tt = time[40000,59999]
  let xo = v(p2)[40000,59999]
  let m_b_one04_n = length(xo)
  let m_b_one04_t0 = tt[0]
  let m_b_one04_t1 = tt[19999]
  let m_b_one04_f0_c = 2*mean(xo*cos(2*pi*19450000000.0*tt))
  let m_b_one04_f0_s = 2*mean(xo*sin(2*pi*19450000000.0*tt))
  let m_b_one04_fl_lo_c = 2*mean(xo*cos(2*pi*19400000000.0*tt))
  let m_b_one04_fl_lo_s = 2*mean(xo*sin(2*pi*19400000000.0*tt))
  let m_b_one04_fl_hi_c = 2*mean(xo*cos(2*pi*19500000000.0*tt))
  let m_b_one04_fl_hi_s = 2*mean(xo*sin(2*pi*19500000000.0*tt))
  print m_b_one04_n m_b_one04_t0 m_b_one04_t1 m_b_one04_f0_c m_b_one04_f0_s m_b_one04_fl_lo_c
  print m_b_one04_fl_lo_s m_b_one04_fl_hi_c m_b_one04_fl_hi_s
  * run b_one05: one-tone, available power -46 dBm per tone
  alterparam fq1 = 19450000000.0
  alterparam fq2 = 19450000000.0
  alterparam va1 = 0.00316978638492223
  alterparam va2 = 0.0
  reset
  tran 1e-12 6e-08 0 1e-12
  linearize v(p2)
  let tt = time[40000,59999]
  let xo = v(p2)[40000,59999]
  let m_b_one05_n = length(xo)
  let m_b_one05_t0 = tt[0]
  let m_b_one05_t1 = tt[19999]
  let m_b_one05_f0_c = 2*mean(xo*cos(2*pi*19450000000.0*tt))
  let m_b_one05_f0_s = 2*mean(xo*sin(2*pi*19450000000.0*tt))
  let m_b_one05_fl_lo_c = 2*mean(xo*cos(2*pi*19400000000.0*tt))
  let m_b_one05_fl_lo_s = 2*mean(xo*sin(2*pi*19400000000.0*tt))
  let m_b_one05_fl_hi_c = 2*mean(xo*cos(2*pi*19500000000.0*tt))
  let m_b_one05_fl_hi_s = 2*mean(xo*sin(2*pi*19500000000.0*tt))
  print m_b_one05_n m_b_one05_t0 m_b_one05_t1 m_b_one05_f0_c m_b_one05_f0_s m_b_one05_fl_lo_c
  print m_b_one05_fl_lo_s m_b_one05_fl_hi_c m_b_one05_fl_hi_s
  * run b_one06: one-tone, available power -44 dBm per tone
  alterparam fq1 = 19450000000.0
  alterparam fq2 = 19450000000.0
  alterparam va1 = 0.00399052462993776
  alterparam va2 = 0.0
  reset
  tran 1e-12 6e-08 0 1e-12
  linearize v(p2)
  let tt = time[40000,59999]
  let xo = v(p2)[40000,59999]
  let m_b_one06_n = length(xo)
  let m_b_one06_t0 = tt[0]
  let m_b_one06_t1 = tt[19999]
  let m_b_one06_f0_c = 2*mean(xo*cos(2*pi*19450000000.0*tt))
  let m_b_one06_f0_s = 2*mean(xo*sin(2*pi*19450000000.0*tt))
  let m_b_one06_fl_lo_c = 2*mean(xo*cos(2*pi*19400000000.0*tt))
  let m_b_one06_fl_lo_s = 2*mean(xo*sin(2*pi*19400000000.0*tt))
  let m_b_one06_fl_hi_c = 2*mean(xo*cos(2*pi*19500000000.0*tt))
  let m_b_one06_fl_hi_s = 2*mean(xo*sin(2*pi*19500000000.0*tt))
  print m_b_one06_n m_b_one06_t0 m_b_one06_t1 m_b_one06_f0_c m_b_one06_f0_s m_b_one06_fl_lo_c
  print m_b_one06_fl_lo_s m_b_one06_fl_hi_c m_b_one06_fl_hi_s
  * run b_one07: one-tone, available power -42 dBm per tone
  alterparam fq1 = 19450000000.0
  alterparam fq2 = 19450000000.0
  alterparam va1 = 0.00502377286301916
  alterparam va2 = 0.0
  reset
  tran 1e-12 6e-08 0 1e-12
  linearize v(p2)
  let tt = time[40000,59999]
  let xo = v(p2)[40000,59999]
  let m_b_one07_n = length(xo)
  let m_b_one07_t0 = tt[0]
  let m_b_one07_t1 = tt[19999]
  let m_b_one07_f0_c = 2*mean(xo*cos(2*pi*19450000000.0*tt))
  let m_b_one07_f0_s = 2*mean(xo*sin(2*pi*19450000000.0*tt))
  let m_b_one07_fl_lo_c = 2*mean(xo*cos(2*pi*19400000000.0*tt))
  let m_b_one07_fl_lo_s = 2*mean(xo*sin(2*pi*19400000000.0*tt))
  let m_b_one07_fl_hi_c = 2*mean(xo*cos(2*pi*19500000000.0*tt))
  let m_b_one07_fl_hi_s = 2*mean(xo*sin(2*pi*19500000000.0*tt))
  print m_b_one07_n m_b_one07_t0 m_b_one07_t1 m_b_one07_f0_c m_b_one07_f0_s m_b_one07_fl_lo_c
  print m_b_one07_fl_lo_s m_b_one07_fl_hi_c m_b_one07_fl_hi_s
  * run b_one08: one-tone, available power -40 dBm per tone
  alterparam fq1 = 19450000000.0
  alterparam fq2 = 19450000000.0
  alterparam va1 = 0.00632455532033676
  alterparam va2 = 0.0
  reset
  tran 1e-12 6e-08 0 1e-12
  linearize v(p2)
  let tt = time[40000,59999]
  let xo = v(p2)[40000,59999]
  let m_b_one08_n = length(xo)
  let m_b_one08_t0 = tt[0]
  let m_b_one08_t1 = tt[19999]
  let m_b_one08_f0_c = 2*mean(xo*cos(2*pi*19450000000.0*tt))
  let m_b_one08_f0_s = 2*mean(xo*sin(2*pi*19450000000.0*tt))
  let m_b_one08_fl_lo_c = 2*mean(xo*cos(2*pi*19400000000.0*tt))
  let m_b_one08_fl_lo_s = 2*mean(xo*sin(2*pi*19400000000.0*tt))
  let m_b_one08_fl_hi_c = 2*mean(xo*cos(2*pi*19500000000.0*tt))
  let m_b_one08_fl_hi_s = 2*mean(xo*sin(2*pi*19500000000.0*tt))
  print m_b_one08_n m_b_one08_t0 m_b_one08_t1 m_b_one08_f0_c m_b_one08_f0_s m_b_one08_fl_lo_c
  print m_b_one08_fl_lo_s m_b_one08_fl_hi_c m_b_one08_fl_hi_s
  * run b_one09: one-tone, available power -38 dBm per tone
  alterparam fq1 = 19450000000.0
  alterparam fq2 = 19450000000.0
  alterparam va1 = 0.00796214341106995
  alterparam va2 = 0.0
  reset
  tran 1e-12 6e-08 0 1e-12
  linearize v(p2)
  let tt = time[40000,59999]
  let xo = v(p2)[40000,59999]
  let m_b_one09_n = length(xo)
  let m_b_one09_t0 = tt[0]
  let m_b_one09_t1 = tt[19999]
  let m_b_one09_f0_c = 2*mean(xo*cos(2*pi*19450000000.0*tt))
  let m_b_one09_f0_s = 2*mean(xo*sin(2*pi*19450000000.0*tt))
  let m_b_one09_fl_lo_c = 2*mean(xo*cos(2*pi*19400000000.0*tt))
  let m_b_one09_fl_lo_s = 2*mean(xo*sin(2*pi*19400000000.0*tt))
  let m_b_one09_fl_hi_c = 2*mean(xo*cos(2*pi*19500000000.0*tt))
  let m_b_one09_fl_hi_s = 2*mean(xo*sin(2*pi*19500000000.0*tt))
  print m_b_one09_n m_b_one09_t0 m_b_one09_t1 m_b_one09_f0_c m_b_one09_f0_s m_b_one09_fl_lo_c
  print m_b_one09_fl_lo_s m_b_one09_fl_hi_c m_b_one09_fl_hi_s
  * run b_one10: one-tone, available power -36 dBm per tone
  alterparam fq1 = 19450000000.0
  alterparam fq2 = 19450000000.0
  alterparam va1 = 0.0100237446725454
  alterparam va2 = 0.0
  reset
  tran 1e-12 6e-08 0 1e-12
  linearize v(p2)
  let tt = time[40000,59999]
  let xo = v(p2)[40000,59999]
  let m_b_one10_n = length(xo)
  let m_b_one10_t0 = tt[0]
  let m_b_one10_t1 = tt[19999]
  let m_b_one10_f0_c = 2*mean(xo*cos(2*pi*19450000000.0*tt))
  let m_b_one10_f0_s = 2*mean(xo*sin(2*pi*19450000000.0*tt))
  let m_b_one10_fl_lo_c = 2*mean(xo*cos(2*pi*19400000000.0*tt))
  let m_b_one10_fl_lo_s = 2*mean(xo*sin(2*pi*19400000000.0*tt))
  let m_b_one10_fl_hi_c = 2*mean(xo*cos(2*pi*19500000000.0*tt))
  let m_b_one10_fl_hi_s = 2*mean(xo*sin(2*pi*19500000000.0*tt))
  print m_b_one10_n m_b_one10_t0 m_b_one10_t1 m_b_one10_f0_c m_b_one10_f0_s m_b_one10_fl_lo_c
  print m_b_one10_fl_lo_s m_b_one10_fl_hi_c m_b_one10_fl_hi_s
  * run b_one11: one-tone, available power -34 dBm per tone
  alterparam fq1 = 19450000000.0
  alterparam fq2 = 19450000000.0
  alterparam va1 = 0.0126191468896039
  alterparam va2 = 0.0
  reset
  tran 1e-12 6e-08 0 1e-12
  linearize v(p2)
  let tt = time[40000,59999]
  let xo = v(p2)[40000,59999]
  let m_b_one11_n = length(xo)
  let m_b_one11_t0 = tt[0]
  let m_b_one11_t1 = tt[19999]
  let m_b_one11_f0_c = 2*mean(xo*cos(2*pi*19450000000.0*tt))
  let m_b_one11_f0_s = 2*mean(xo*sin(2*pi*19450000000.0*tt))
  let m_b_one11_fl_lo_c = 2*mean(xo*cos(2*pi*19400000000.0*tt))
  let m_b_one11_fl_lo_s = 2*mean(xo*sin(2*pi*19400000000.0*tt))
  let m_b_one11_fl_hi_c = 2*mean(xo*cos(2*pi*19500000000.0*tt))
  let m_b_one11_fl_hi_s = 2*mean(xo*sin(2*pi*19500000000.0*tt))
  print m_b_one11_n m_b_one11_t0 m_b_one11_t1 m_b_one11_f0_c m_b_one11_f0_s m_b_one11_fl_lo_c
  print m_b_one11_fl_lo_s m_b_one11_fl_hi_c m_b_one11_fl_hi_s
  * run b_one12: one-tone, available power -32 dBm per tone
  alterparam fq1 = 19450000000.0
  alterparam fq2 = 19450000000.0
  alterparam va1 = 0.0158865646944856
  alterparam va2 = 0.0
  reset
  tran 1e-12 6e-08 0 1e-12
  linearize v(p2)
  let tt = time[40000,59999]
  let xo = v(p2)[40000,59999]
  let m_b_one12_n = length(xo)
  let m_b_one12_t0 = tt[0]
  let m_b_one12_t1 = tt[19999]
  let m_b_one12_f0_c = 2*mean(xo*cos(2*pi*19450000000.0*tt))
  let m_b_one12_f0_s = 2*mean(xo*sin(2*pi*19450000000.0*tt))
  let m_b_one12_fl_lo_c = 2*mean(xo*cos(2*pi*19400000000.0*tt))
  let m_b_one12_fl_lo_s = 2*mean(xo*sin(2*pi*19400000000.0*tt))
  let m_b_one12_fl_hi_c = 2*mean(xo*cos(2*pi*19500000000.0*tt))
  let m_b_one12_fl_hi_s = 2*mean(xo*sin(2*pi*19500000000.0*tt))
  print m_b_one12_n m_b_one12_t0 m_b_one12_t1 m_b_one12_f0_c m_b_one12_f0_s m_b_one12_fl_lo_c
  print m_b_one12_fl_lo_s m_b_one12_fl_hi_c m_b_one12_fl_hi_s
  * run b_one13: one-tone, available power -30 dBm per tone
  alterparam fq1 = 19450000000.0
  alterparam fq2 = 19450000000.0
  alterparam va1 = 0.02
  alterparam va2 = 0.0
  reset
  tran 1e-12 6e-08 0 1e-12
  linearize v(p2)
  let tt = time[40000,59999]
  let xo = v(p2)[40000,59999]
  let m_b_one13_n = length(xo)
  let m_b_one13_t0 = tt[0]
  let m_b_one13_t1 = tt[19999]
  let m_b_one13_f0_c = 2*mean(xo*cos(2*pi*19450000000.0*tt))
  let m_b_one13_f0_s = 2*mean(xo*sin(2*pi*19450000000.0*tt))
  let m_b_one13_fl_lo_c = 2*mean(xo*cos(2*pi*19400000000.0*tt))
  let m_b_one13_fl_lo_s = 2*mean(xo*sin(2*pi*19400000000.0*tt))
  let m_b_one13_fl_hi_c = 2*mean(xo*cos(2*pi*19500000000.0*tt))
  let m_b_one13_fl_hi_s = 2*mean(xo*sin(2*pi*19500000000.0*tt))
  print m_b_one13_n m_b_one13_t0 m_b_one13_t1 m_b_one13_f0_c m_b_one13_f0_s m_b_one13_fl_lo_c
  print m_b_one13_fl_lo_s m_b_one13_fl_hi_c m_b_one13_fl_hi_s
  * run b_one14: one-tone, available power -28 dBm per tone
  alterparam fq1 = 19450000000.0
  alterparam fq2 = 19450000000.0
  alterparam va1 = 0.0251785082358833
  alterparam va2 = 0.0
  reset
  tran 1e-12 6e-08 0 1e-12
  linearize v(p2)
  let tt = time[40000,59999]
  let xo = v(p2)[40000,59999]
  let m_b_one14_n = length(xo)
  let m_b_one14_t0 = tt[0]
  let m_b_one14_t1 = tt[19999]
  let m_b_one14_f0_c = 2*mean(xo*cos(2*pi*19450000000.0*tt))
  let m_b_one14_f0_s = 2*mean(xo*sin(2*pi*19450000000.0*tt))
  let m_b_one14_fl_lo_c = 2*mean(xo*cos(2*pi*19400000000.0*tt))
  let m_b_one14_fl_lo_s = 2*mean(xo*sin(2*pi*19400000000.0*tt))
  let m_b_one14_fl_hi_c = 2*mean(xo*cos(2*pi*19500000000.0*tt))
  let m_b_one14_fl_hi_s = 2*mean(xo*sin(2*pi*19500000000.0*tt))
  print m_b_one14_n m_b_one14_t0 m_b_one14_t1 m_b_one14_f0_c m_b_one14_f0_s m_b_one14_fl_lo_c
  print m_b_one14_fl_lo_s m_b_one14_fl_hi_c m_b_one14_fl_hi_s
  * run b_one15: one-tone, available power -26 dBm per tone
  alterparam fq1 = 19450000000.0
  alterparam fq2 = 19450000000.0
  alterparam va1 = 0.0316978638492223
  alterparam va2 = 0.0
  reset
  tran 1e-12 6e-08 0 1e-12
  linearize v(p2)
  let tt = time[40000,59999]
  let xo = v(p2)[40000,59999]
  let m_b_one15_n = length(xo)
  let m_b_one15_t0 = tt[0]
  let m_b_one15_t1 = tt[19999]
  let m_b_one15_f0_c = 2*mean(xo*cos(2*pi*19450000000.0*tt))
  let m_b_one15_f0_s = 2*mean(xo*sin(2*pi*19450000000.0*tt))
  let m_b_one15_fl_lo_c = 2*mean(xo*cos(2*pi*19400000000.0*tt))
  let m_b_one15_fl_lo_s = 2*mean(xo*sin(2*pi*19400000000.0*tt))
  let m_b_one15_fl_hi_c = 2*mean(xo*cos(2*pi*19500000000.0*tt))
  let m_b_one15_fl_hi_s = 2*mean(xo*sin(2*pi*19500000000.0*tt))
  print m_b_one15_n m_b_one15_t0 m_b_one15_t1 m_b_one15_f0_c m_b_one15_f0_s m_b_one15_fl_lo_c
  print m_b_one15_fl_lo_s m_b_one15_fl_hi_c m_b_one15_fl_hi_s
  * run b_one16: one-tone, available power -24 dBm per tone
  alterparam fq1 = 19450000000.0
  alterparam fq2 = 19450000000.0
  alterparam va1 = 0.0399052462993776
  alterparam va2 = 0.0
  reset
  tran 1e-12 6e-08 0 1e-12
  linearize v(p2)
  let tt = time[40000,59999]
  let xo = v(p2)[40000,59999]
  let m_b_one16_n = length(xo)
  let m_b_one16_t0 = tt[0]
  let m_b_one16_t1 = tt[19999]
  let m_b_one16_f0_c = 2*mean(xo*cos(2*pi*19450000000.0*tt))
  let m_b_one16_f0_s = 2*mean(xo*sin(2*pi*19450000000.0*tt))
  let m_b_one16_fl_lo_c = 2*mean(xo*cos(2*pi*19400000000.0*tt))
  let m_b_one16_fl_lo_s = 2*mean(xo*sin(2*pi*19400000000.0*tt))
  let m_b_one16_fl_hi_c = 2*mean(xo*cos(2*pi*19500000000.0*tt))
  let m_b_one16_fl_hi_s = 2*mean(xo*sin(2*pi*19500000000.0*tt))
  print m_b_one16_n m_b_one16_t0 m_b_one16_t1 m_b_one16_f0_c m_b_one16_f0_s m_b_one16_fl_lo_c
  print m_b_one16_fl_lo_s m_b_one16_fl_hi_c m_b_one16_fl_hi_s
  * run b_one17: one-tone, available power -22 dBm per tone
  alterparam fq1 = 19450000000.0
  alterparam fq2 = 19450000000.0
  alterparam va1 = 0.0502377286301916
  alterparam va2 = 0.0
  reset
  tran 1e-12 6e-08 0 1e-12
  linearize v(p2)
  let tt = time[40000,59999]
  let xo = v(p2)[40000,59999]
  let m_b_one17_n = length(xo)
  let m_b_one17_t0 = tt[0]
  let m_b_one17_t1 = tt[19999]
  let m_b_one17_f0_c = 2*mean(xo*cos(2*pi*19450000000.0*tt))
  let m_b_one17_f0_s = 2*mean(xo*sin(2*pi*19450000000.0*tt))
  let m_b_one17_fl_lo_c = 2*mean(xo*cos(2*pi*19400000000.0*tt))
  let m_b_one17_fl_lo_s = 2*mean(xo*sin(2*pi*19400000000.0*tt))
  let m_b_one17_fl_hi_c = 2*mean(xo*cos(2*pi*19500000000.0*tt))
  let m_b_one17_fl_hi_s = 2*mean(xo*sin(2*pi*19500000000.0*tt))
  print m_b_one17_n m_b_one17_t0 m_b_one17_t1 m_b_one17_f0_c m_b_one17_f0_s m_b_one17_fl_lo_c
  print m_b_one17_fl_lo_s m_b_one17_fl_hi_c m_b_one17_fl_hi_s
  * run b_one18: one-tone, available power -20 dBm per tone
  alterparam fq1 = 19450000000.0
  alterparam fq2 = 19450000000.0
  alterparam va1 = 0.0632455532033676
  alterparam va2 = 0.0
  reset
  tran 1e-12 6e-08 0 1e-12
  linearize v(p2)
  let tt = time[40000,59999]
  let xo = v(p2)[40000,59999]
  let m_b_one18_n = length(xo)
  let m_b_one18_t0 = tt[0]
  let m_b_one18_t1 = tt[19999]
  let m_b_one18_f0_c = 2*mean(xo*cos(2*pi*19450000000.0*tt))
  let m_b_one18_f0_s = 2*mean(xo*sin(2*pi*19450000000.0*tt))
  let m_b_one18_fl_lo_c = 2*mean(xo*cos(2*pi*19400000000.0*tt))
  let m_b_one18_fl_lo_s = 2*mean(xo*sin(2*pi*19400000000.0*tt))
  let m_b_one18_fl_hi_c = 2*mean(xo*cos(2*pi*19500000000.0*tt))
  let m_b_one18_fl_hi_s = 2*mean(xo*sin(2*pi*19500000000.0*tt))
  print m_b_one18_n m_b_one18_t0 m_b_one18_t1 m_b_one18_f0_c m_b_one18_f0_s m_b_one18_fl_lo_c
  print m_b_one18_fl_lo_s m_b_one18_fl_hi_c m_b_one18_fl_hi_s
  * run b_one19: one-tone, available power -18 dBm per tone
  alterparam fq1 = 19450000000.0
  alterparam fq2 = 19450000000.0
  alterparam va1 = 0.0796214341106995
  alterparam va2 = 0.0
  reset
  tran 1e-12 6e-08 0 1e-12
  linearize v(p2)
  let tt = time[40000,59999]
  let xo = v(p2)[40000,59999]
  let m_b_one19_n = length(xo)
  let m_b_one19_t0 = tt[0]
  let m_b_one19_t1 = tt[19999]
  let m_b_one19_f0_c = 2*mean(xo*cos(2*pi*19450000000.0*tt))
  let m_b_one19_f0_s = 2*mean(xo*sin(2*pi*19450000000.0*tt))
  let m_b_one19_fl_lo_c = 2*mean(xo*cos(2*pi*19400000000.0*tt))
  let m_b_one19_fl_lo_s = 2*mean(xo*sin(2*pi*19400000000.0*tt))
  let m_b_one19_fl_hi_c = 2*mean(xo*cos(2*pi*19500000000.0*tt))
  let m_b_one19_fl_hi_s = 2*mean(xo*sin(2*pi*19500000000.0*tt))
  print m_b_one19_n m_b_one19_t0 m_b_one19_t1 m_b_one19_f0_c m_b_one19_f0_s m_b_one19_fl_lo_c
  print m_b_one19_fl_lo_s m_b_one19_fl_hi_c m_b_one19_fl_hi_s
  * run b_one20: one-tone, available power -16 dBm per tone
  alterparam fq1 = 19450000000.0
  alterparam fq2 = 19450000000.0
  alterparam va1 = 0.100237446725454
  alterparam va2 = 0.0
  reset
  tran 1e-12 6e-08 0 1e-12
  linearize v(p2)
  let tt = time[40000,59999]
  let xo = v(p2)[40000,59999]
  let m_b_one20_n = length(xo)
  let m_b_one20_t0 = tt[0]
  let m_b_one20_t1 = tt[19999]
  let m_b_one20_f0_c = 2*mean(xo*cos(2*pi*19450000000.0*tt))
  let m_b_one20_f0_s = 2*mean(xo*sin(2*pi*19450000000.0*tt))
  let m_b_one20_fl_lo_c = 2*mean(xo*cos(2*pi*19400000000.0*tt))
  let m_b_one20_fl_lo_s = 2*mean(xo*sin(2*pi*19400000000.0*tt))
  let m_b_one20_fl_hi_c = 2*mean(xo*cos(2*pi*19500000000.0*tt))
  let m_b_one20_fl_hi_s = 2*mean(xo*sin(2*pi*19500000000.0*tt))
  print m_b_one20_n m_b_one20_t0 m_b_one20_t1 m_b_one20_f0_c m_b_one20_f0_s m_b_one20_fl_lo_c
  print m_b_one20_fl_lo_s m_b_one20_fl_hi_c m_b_one20_fl_hi_s
  echo LNLIN_DONE
.endc
