* lna-linearity control_two -- GENERATED by sim/lna-linearity/run.py, do not edit
.param z0=50
.param va1=0 va2=0

Rin p1 0 {z0}
Bamp ya 0 V = 10.0*v(p1) + -2000.0*v(p1)*v(p1)*v(p1)
Rout ya p2 {z0}
.options reltol=1e-07 trtol=1.0
.param fq1=1e10 fq2=1e10
Bs n2 0 V = (time<5e-09 ? 0.5*(1-cos(pi*time/5e-09)) : 1)*({va1}*sin(2*pi*{fq1}*time) + {va2}*sin(2*pi*{fq2}*time))
Rs n2 p1 {z0}
RL p2 0 {z0}

.control
set numdgt=12
set noaskquit
  * run b_two00: two-tone, available power -56 dBm per tone
  alterparam fq1 = 19400000000.0
  alterparam fq2 = 19500000000.0
  alterparam va1 = 0.00100237446725455
  alterparam va2 = 0.00100237446725455
  reset
  tran 1e-12 6e-08 0 1e-12
  linearize v(p2)
  let tt = time[40000,59999]
  let xo = v(p2)[40000,59999]
  let m_b_two00_n = length(xo)
  let m_b_two00_t0 = tt[0]
  let m_b_two00_t1 = tt[19999]
  let m_b_two00_f1_c = 2*mean(xo*cos(2*pi*19400000000.0*tt))
  let m_b_two00_f1_s = 2*mean(xo*sin(2*pi*19400000000.0*tt))
  let m_b_two00_f2_c = 2*mean(xo*cos(2*pi*19500000000.0*tt))
  let m_b_two00_f2_s = 2*mean(xo*sin(2*pi*19500000000.0*tt))
  let m_b_two00_im3l_c = 2*mean(xo*cos(2*pi*19300000000.0*tt))
  let m_b_two00_im3l_s = 2*mean(xo*sin(2*pi*19300000000.0*tt))
  let m_b_two00_im3h_c = 2*mean(xo*cos(2*pi*19600000000.0*tt))
  let m_b_two00_im3h_s = 2*mean(xo*sin(2*pi*19600000000.0*tt))
  let m_b_two00_fl_lo_c = 2*mean(xo*cos(2*pi*19250000000.0*tt))
  let m_b_two00_fl_lo_s = 2*mean(xo*sin(2*pi*19250000000.0*tt))
  let m_b_two00_fl_hi_c = 2*mean(xo*cos(2*pi*19650000000.0*tt))
  let m_b_two00_fl_hi_s = 2*mean(xo*sin(2*pi*19650000000.0*tt))
  print m_b_two00_n m_b_two00_t0 m_b_two00_t1 m_b_two00_f1_c m_b_two00_f1_s m_b_two00_f2_c
  print m_b_two00_f2_s m_b_two00_im3l_c m_b_two00_im3l_s m_b_two00_im3h_c m_b_two00_im3h_s m_b_two00_fl_lo_c
  print m_b_two00_fl_lo_s m_b_two00_fl_hi_c m_b_two00_fl_hi_s
  * run b_two01: two-tone, available power -55 dBm per tone
  alterparam fq1 = 19400000000.0
  alterparam fq2 = 19500000000.0
  alterparam va1 = 0.0011246826503807
  alterparam va2 = 0.0011246826503807
  reset
  tran 1e-12 6e-08 0 1e-12
  linearize v(p2)
  let tt = time[40000,59999]
  let xo = v(p2)[40000,59999]
  let m_b_two01_n = length(xo)
  let m_b_two01_t0 = tt[0]
  let m_b_two01_t1 = tt[19999]
  let m_b_two01_f1_c = 2*mean(xo*cos(2*pi*19400000000.0*tt))
  let m_b_two01_f1_s = 2*mean(xo*sin(2*pi*19400000000.0*tt))
  let m_b_two01_f2_c = 2*mean(xo*cos(2*pi*19500000000.0*tt))
  let m_b_two01_f2_s = 2*mean(xo*sin(2*pi*19500000000.0*tt))
  let m_b_two01_im3l_c = 2*mean(xo*cos(2*pi*19300000000.0*tt))
  let m_b_two01_im3l_s = 2*mean(xo*sin(2*pi*19300000000.0*tt))
  let m_b_two01_im3h_c = 2*mean(xo*cos(2*pi*19600000000.0*tt))
  let m_b_two01_im3h_s = 2*mean(xo*sin(2*pi*19600000000.0*tt))
  let m_b_two01_fl_lo_c = 2*mean(xo*cos(2*pi*19250000000.0*tt))
  let m_b_two01_fl_lo_s = 2*mean(xo*sin(2*pi*19250000000.0*tt))
  let m_b_two01_fl_hi_c = 2*mean(xo*cos(2*pi*19650000000.0*tt))
  let m_b_two01_fl_hi_s = 2*mean(xo*sin(2*pi*19650000000.0*tt))
  print m_b_two01_n m_b_two01_t0 m_b_two01_t1 m_b_two01_f1_c m_b_two01_f1_s m_b_two01_f2_c
  print m_b_two01_f2_s m_b_two01_im3l_c m_b_two01_im3l_s m_b_two01_im3h_c m_b_two01_im3h_s m_b_two01_fl_lo_c
  print m_b_two01_fl_lo_s m_b_two01_fl_hi_c m_b_two01_fl_hi_s
  * run b_two02: two-tone, available power -54 dBm per tone
  alterparam fq1 = 19400000000.0
  alterparam fq2 = 19500000000.0
  alterparam va1 = 0.00126191468896039
  alterparam va2 = 0.00126191468896039
  reset
  tran 1e-12 6e-08 0 1e-12
  linearize v(p2)
  let tt = time[40000,59999]
  let xo = v(p2)[40000,59999]
  let m_b_two02_n = length(xo)
  let m_b_two02_t0 = tt[0]
  let m_b_two02_t1 = tt[19999]
  let m_b_two02_f1_c = 2*mean(xo*cos(2*pi*19400000000.0*tt))
  let m_b_two02_f1_s = 2*mean(xo*sin(2*pi*19400000000.0*tt))
  let m_b_two02_f2_c = 2*mean(xo*cos(2*pi*19500000000.0*tt))
  let m_b_two02_f2_s = 2*mean(xo*sin(2*pi*19500000000.0*tt))
  let m_b_two02_im3l_c = 2*mean(xo*cos(2*pi*19300000000.0*tt))
  let m_b_two02_im3l_s = 2*mean(xo*sin(2*pi*19300000000.0*tt))
  let m_b_two02_im3h_c = 2*mean(xo*cos(2*pi*19600000000.0*tt))
  let m_b_two02_im3h_s = 2*mean(xo*sin(2*pi*19600000000.0*tt))
  let m_b_two02_fl_lo_c = 2*mean(xo*cos(2*pi*19250000000.0*tt))
  let m_b_two02_fl_lo_s = 2*mean(xo*sin(2*pi*19250000000.0*tt))
  let m_b_two02_fl_hi_c = 2*mean(xo*cos(2*pi*19650000000.0*tt))
  let m_b_two02_fl_hi_s = 2*mean(xo*sin(2*pi*19650000000.0*tt))
  print m_b_two02_n m_b_two02_t0 m_b_two02_t1 m_b_two02_f1_c m_b_two02_f1_s m_b_two02_f2_c
  print m_b_two02_f2_s m_b_two02_im3l_c m_b_two02_im3l_s m_b_two02_im3h_c m_b_two02_im3h_s m_b_two02_fl_lo_c
  print m_b_two02_fl_lo_s m_b_two02_fl_hi_c m_b_two02_fl_hi_s
  * run b_two03: two-tone, available power -53 dBm per tone
  alterparam fq1 = 19400000000.0
  alterparam fq2 = 19500000000.0
  alterparam va1 = 0.00141589156876828
  alterparam va2 = 0.00141589156876828
  reset
  tran 1e-12 6e-08 0 1e-12
  linearize v(p2)
  let tt = time[40000,59999]
  let xo = v(p2)[40000,59999]
  let m_b_two03_n = length(xo)
  let m_b_two03_t0 = tt[0]
  let m_b_two03_t1 = tt[19999]
  let m_b_two03_f1_c = 2*mean(xo*cos(2*pi*19400000000.0*tt))
  let m_b_two03_f1_s = 2*mean(xo*sin(2*pi*19400000000.0*tt))
  let m_b_two03_f2_c = 2*mean(xo*cos(2*pi*19500000000.0*tt))
  let m_b_two03_f2_s = 2*mean(xo*sin(2*pi*19500000000.0*tt))
  let m_b_two03_im3l_c = 2*mean(xo*cos(2*pi*19300000000.0*tt))
  let m_b_two03_im3l_s = 2*mean(xo*sin(2*pi*19300000000.0*tt))
  let m_b_two03_im3h_c = 2*mean(xo*cos(2*pi*19600000000.0*tt))
  let m_b_two03_im3h_s = 2*mean(xo*sin(2*pi*19600000000.0*tt))
  let m_b_two03_fl_lo_c = 2*mean(xo*cos(2*pi*19250000000.0*tt))
  let m_b_two03_fl_lo_s = 2*mean(xo*sin(2*pi*19250000000.0*tt))
  let m_b_two03_fl_hi_c = 2*mean(xo*cos(2*pi*19650000000.0*tt))
  let m_b_two03_fl_hi_s = 2*mean(xo*sin(2*pi*19650000000.0*tt))
  print m_b_two03_n m_b_two03_t0 m_b_two03_t1 m_b_two03_f1_c m_b_two03_f1_s m_b_two03_f2_c
  print m_b_two03_f2_s m_b_two03_im3l_c m_b_two03_im3l_s m_b_two03_im3h_c m_b_two03_im3h_s m_b_two03_fl_lo_c
  print m_b_two03_fl_lo_s m_b_two03_fl_hi_c m_b_two03_fl_hi_s
  * run b_two04: two-tone, available power -52 dBm per tone
  alterparam fq1 = 19400000000.0
  alterparam fq2 = 19500000000.0
  alterparam va1 = 0.00158865646944856
  alterparam va2 = 0.00158865646944856
  reset
  tran 1e-12 6e-08 0 1e-12
  linearize v(p2)
  let tt = time[40000,59999]
  let xo = v(p2)[40000,59999]
  let m_b_two04_n = length(xo)
  let m_b_two04_t0 = tt[0]
  let m_b_two04_t1 = tt[19999]
  let m_b_two04_f1_c = 2*mean(xo*cos(2*pi*19400000000.0*tt))
  let m_b_two04_f1_s = 2*mean(xo*sin(2*pi*19400000000.0*tt))
  let m_b_two04_f2_c = 2*mean(xo*cos(2*pi*19500000000.0*tt))
  let m_b_two04_f2_s = 2*mean(xo*sin(2*pi*19500000000.0*tt))
  let m_b_two04_im3l_c = 2*mean(xo*cos(2*pi*19300000000.0*tt))
  let m_b_two04_im3l_s = 2*mean(xo*sin(2*pi*19300000000.0*tt))
  let m_b_two04_im3h_c = 2*mean(xo*cos(2*pi*19600000000.0*tt))
  let m_b_two04_im3h_s = 2*mean(xo*sin(2*pi*19600000000.0*tt))
  let m_b_two04_fl_lo_c = 2*mean(xo*cos(2*pi*19250000000.0*tt))
  let m_b_two04_fl_lo_s = 2*mean(xo*sin(2*pi*19250000000.0*tt))
  let m_b_two04_fl_hi_c = 2*mean(xo*cos(2*pi*19650000000.0*tt))
  let m_b_two04_fl_hi_s = 2*mean(xo*sin(2*pi*19650000000.0*tt))
  print m_b_two04_n m_b_two04_t0 m_b_two04_t1 m_b_two04_f1_c m_b_two04_f1_s m_b_two04_f2_c
  print m_b_two04_f2_s m_b_two04_im3l_c m_b_two04_im3l_s m_b_two04_im3h_c m_b_two04_im3h_s m_b_two04_fl_lo_c
  print m_b_two04_fl_lo_s m_b_two04_fl_hi_c m_b_two04_fl_hi_s
  * run b_two05: two-tone, available power -51 dBm per tone
  alterparam fq1 = 19400000000.0
  alterparam fq2 = 19500000000.0
  alterparam va1 = 0.00178250187626749
  alterparam va2 = 0.00178250187626749
  reset
  tran 1e-12 6e-08 0 1e-12
  linearize v(p2)
  let tt = time[40000,59999]
  let xo = v(p2)[40000,59999]
  let m_b_two05_n = length(xo)
  let m_b_two05_t0 = tt[0]
  let m_b_two05_t1 = tt[19999]
  let m_b_two05_f1_c = 2*mean(xo*cos(2*pi*19400000000.0*tt))
  let m_b_two05_f1_s = 2*mean(xo*sin(2*pi*19400000000.0*tt))
  let m_b_two05_f2_c = 2*mean(xo*cos(2*pi*19500000000.0*tt))
  let m_b_two05_f2_s = 2*mean(xo*sin(2*pi*19500000000.0*tt))
  let m_b_two05_im3l_c = 2*mean(xo*cos(2*pi*19300000000.0*tt))
  let m_b_two05_im3l_s = 2*mean(xo*sin(2*pi*19300000000.0*tt))
  let m_b_two05_im3h_c = 2*mean(xo*cos(2*pi*19600000000.0*tt))
  let m_b_two05_im3h_s = 2*mean(xo*sin(2*pi*19600000000.0*tt))
  let m_b_two05_fl_lo_c = 2*mean(xo*cos(2*pi*19250000000.0*tt))
  let m_b_two05_fl_lo_s = 2*mean(xo*sin(2*pi*19250000000.0*tt))
  let m_b_two05_fl_hi_c = 2*mean(xo*cos(2*pi*19650000000.0*tt))
  let m_b_two05_fl_hi_s = 2*mean(xo*sin(2*pi*19650000000.0*tt))
  print m_b_two05_n m_b_two05_t0 m_b_two05_t1 m_b_two05_f1_c m_b_two05_f1_s m_b_two05_f2_c
  print m_b_two05_f2_s m_b_two05_im3l_c m_b_two05_im3l_s m_b_two05_im3h_c m_b_two05_im3h_s m_b_two05_fl_lo_c
  print m_b_two05_fl_lo_s m_b_two05_fl_hi_c m_b_two05_fl_hi_s
  * run b_two06: two-tone, available power -50 dBm per tone
  alterparam fq1 = 19400000000.0
  alterparam fq2 = 19500000000.0
  alterparam va1 = 0.002
  alterparam va2 = 0.002
  reset
  tran 1e-12 6e-08 0 1e-12
  linearize v(p2)
  let tt = time[40000,59999]
  let xo = v(p2)[40000,59999]
  let m_b_two06_n = length(xo)
  let m_b_two06_t0 = tt[0]
  let m_b_two06_t1 = tt[19999]
  let m_b_two06_f1_c = 2*mean(xo*cos(2*pi*19400000000.0*tt))
  let m_b_two06_f1_s = 2*mean(xo*sin(2*pi*19400000000.0*tt))
  let m_b_two06_f2_c = 2*mean(xo*cos(2*pi*19500000000.0*tt))
  let m_b_two06_f2_s = 2*mean(xo*sin(2*pi*19500000000.0*tt))
  let m_b_two06_im3l_c = 2*mean(xo*cos(2*pi*19300000000.0*tt))
  let m_b_two06_im3l_s = 2*mean(xo*sin(2*pi*19300000000.0*tt))
  let m_b_two06_im3h_c = 2*mean(xo*cos(2*pi*19600000000.0*tt))
  let m_b_two06_im3h_s = 2*mean(xo*sin(2*pi*19600000000.0*tt))
  let m_b_two06_fl_lo_c = 2*mean(xo*cos(2*pi*19250000000.0*tt))
  let m_b_two06_fl_lo_s = 2*mean(xo*sin(2*pi*19250000000.0*tt))
  let m_b_two06_fl_hi_c = 2*mean(xo*cos(2*pi*19650000000.0*tt))
  let m_b_two06_fl_hi_s = 2*mean(xo*sin(2*pi*19650000000.0*tt))
  print m_b_two06_n m_b_two06_t0 m_b_two06_t1 m_b_two06_f1_c m_b_two06_f1_s m_b_two06_f2_c
  print m_b_two06_f2_s m_b_two06_im3l_c m_b_two06_im3l_s m_b_two06_im3h_c m_b_two06_im3h_s m_b_two06_fl_lo_c
  print m_b_two06_fl_lo_s m_b_two06_fl_hi_c m_b_two06_fl_hi_s
  * run b_two07: two-tone, available power -49 dBm per tone
  alterparam fq1 = 19400000000.0
  alterparam fq2 = 19500000000.0
  alterparam va1 = 0.00224403690860393
  alterparam va2 = 0.00224403690860393
  reset
  tran 1e-12 6e-08 0 1e-12
  linearize v(p2)
  let tt = time[40000,59999]
  let xo = v(p2)[40000,59999]
  let m_b_two07_n = length(xo)
  let m_b_two07_t0 = tt[0]
  let m_b_two07_t1 = tt[19999]
  let m_b_two07_f1_c = 2*mean(xo*cos(2*pi*19400000000.0*tt))
  let m_b_two07_f1_s = 2*mean(xo*sin(2*pi*19400000000.0*tt))
  let m_b_two07_f2_c = 2*mean(xo*cos(2*pi*19500000000.0*tt))
  let m_b_two07_f2_s = 2*mean(xo*sin(2*pi*19500000000.0*tt))
  let m_b_two07_im3l_c = 2*mean(xo*cos(2*pi*19300000000.0*tt))
  let m_b_two07_im3l_s = 2*mean(xo*sin(2*pi*19300000000.0*tt))
  let m_b_two07_im3h_c = 2*mean(xo*cos(2*pi*19600000000.0*tt))
  let m_b_two07_im3h_s = 2*mean(xo*sin(2*pi*19600000000.0*tt))
  let m_b_two07_fl_lo_c = 2*mean(xo*cos(2*pi*19250000000.0*tt))
  let m_b_two07_fl_lo_s = 2*mean(xo*sin(2*pi*19250000000.0*tt))
  let m_b_two07_fl_hi_c = 2*mean(xo*cos(2*pi*19650000000.0*tt))
  let m_b_two07_fl_hi_s = 2*mean(xo*sin(2*pi*19650000000.0*tt))
  print m_b_two07_n m_b_two07_t0 m_b_two07_t1 m_b_two07_f1_c m_b_two07_f1_s m_b_two07_f2_c
  print m_b_two07_f2_s m_b_two07_im3l_c m_b_two07_im3l_s m_b_two07_im3h_c m_b_two07_im3h_s m_b_two07_fl_lo_c
  print m_b_two07_fl_lo_s m_b_two07_fl_hi_c m_b_two07_fl_hi_s
  * run b_two08: two-tone, available power -48 dBm per tone
  alterparam fq1 = 19400000000.0
  alterparam fq2 = 19500000000.0
  alterparam va1 = 0.00251785082358833
  alterparam va2 = 0.00251785082358833
  reset
  tran 1e-12 6e-08 0 1e-12
  linearize v(p2)
  let tt = time[40000,59999]
  let xo = v(p2)[40000,59999]
  let m_b_two08_n = length(xo)
  let m_b_two08_t0 = tt[0]
  let m_b_two08_t1 = tt[19999]
  let m_b_two08_f1_c = 2*mean(xo*cos(2*pi*19400000000.0*tt))
  let m_b_two08_f1_s = 2*mean(xo*sin(2*pi*19400000000.0*tt))
  let m_b_two08_f2_c = 2*mean(xo*cos(2*pi*19500000000.0*tt))
  let m_b_two08_f2_s = 2*mean(xo*sin(2*pi*19500000000.0*tt))
  let m_b_two08_im3l_c = 2*mean(xo*cos(2*pi*19300000000.0*tt))
  let m_b_two08_im3l_s = 2*mean(xo*sin(2*pi*19300000000.0*tt))
  let m_b_two08_im3h_c = 2*mean(xo*cos(2*pi*19600000000.0*tt))
  let m_b_two08_im3h_s = 2*mean(xo*sin(2*pi*19600000000.0*tt))
  let m_b_two08_fl_lo_c = 2*mean(xo*cos(2*pi*19250000000.0*tt))
  let m_b_two08_fl_lo_s = 2*mean(xo*sin(2*pi*19250000000.0*tt))
  let m_b_two08_fl_hi_c = 2*mean(xo*cos(2*pi*19650000000.0*tt))
  let m_b_two08_fl_hi_s = 2*mean(xo*sin(2*pi*19650000000.0*tt))
  print m_b_two08_n m_b_two08_t0 m_b_two08_t1 m_b_two08_f1_c m_b_two08_f1_s m_b_two08_f2_c
  print m_b_two08_f2_s m_b_two08_im3l_c m_b_two08_im3l_s m_b_two08_im3h_c m_b_two08_im3h_s m_b_two08_fl_lo_c
  print m_b_two08_fl_lo_s m_b_two08_fl_hi_c m_b_two08_fl_hi_s
  * run b_two09: two-tone, available power -47 dBm per tone
  alterparam fq1 = 19400000000.0
  alterparam fq2 = 19500000000.0
  alterparam va1 = 0.00282507508924551
  alterparam va2 = 0.00282507508924551
  reset
  tran 1e-12 6e-08 0 1e-12
  linearize v(p2)
  let tt = time[40000,59999]
  let xo = v(p2)[40000,59999]
  let m_b_two09_n = length(xo)
  let m_b_two09_t0 = tt[0]
  let m_b_two09_t1 = tt[19999]
  let m_b_two09_f1_c = 2*mean(xo*cos(2*pi*19400000000.0*tt))
  let m_b_two09_f1_s = 2*mean(xo*sin(2*pi*19400000000.0*tt))
  let m_b_two09_f2_c = 2*mean(xo*cos(2*pi*19500000000.0*tt))
  let m_b_two09_f2_s = 2*mean(xo*sin(2*pi*19500000000.0*tt))
  let m_b_two09_im3l_c = 2*mean(xo*cos(2*pi*19300000000.0*tt))
  let m_b_two09_im3l_s = 2*mean(xo*sin(2*pi*19300000000.0*tt))
  let m_b_two09_im3h_c = 2*mean(xo*cos(2*pi*19600000000.0*tt))
  let m_b_two09_im3h_s = 2*mean(xo*sin(2*pi*19600000000.0*tt))
  let m_b_two09_fl_lo_c = 2*mean(xo*cos(2*pi*19250000000.0*tt))
  let m_b_two09_fl_lo_s = 2*mean(xo*sin(2*pi*19250000000.0*tt))
  let m_b_two09_fl_hi_c = 2*mean(xo*cos(2*pi*19650000000.0*tt))
  let m_b_two09_fl_hi_s = 2*mean(xo*sin(2*pi*19650000000.0*tt))
  print m_b_two09_n m_b_two09_t0 m_b_two09_t1 m_b_two09_f1_c m_b_two09_f1_s m_b_two09_f2_c
  print m_b_two09_f2_s m_b_two09_im3l_c m_b_two09_im3l_s m_b_two09_im3h_c m_b_two09_im3h_s m_b_two09_fl_lo_c
  print m_b_two09_fl_lo_s m_b_two09_fl_hi_c m_b_two09_fl_hi_s
  * run b_two10: two-tone, available power -46 dBm per tone
  alterparam fq1 = 19400000000.0
  alterparam fq2 = 19500000000.0
  alterparam va1 = 0.00316978638492223
  alterparam va2 = 0.00316978638492223
  reset
  tran 1e-12 6e-08 0 1e-12
  linearize v(p2)
  let tt = time[40000,59999]
  let xo = v(p2)[40000,59999]
  let m_b_two10_n = length(xo)
  let m_b_two10_t0 = tt[0]
  let m_b_two10_t1 = tt[19999]
  let m_b_two10_f1_c = 2*mean(xo*cos(2*pi*19400000000.0*tt))
  let m_b_two10_f1_s = 2*mean(xo*sin(2*pi*19400000000.0*tt))
  let m_b_two10_f2_c = 2*mean(xo*cos(2*pi*19500000000.0*tt))
  let m_b_two10_f2_s = 2*mean(xo*sin(2*pi*19500000000.0*tt))
  let m_b_two10_im3l_c = 2*mean(xo*cos(2*pi*19300000000.0*tt))
  let m_b_two10_im3l_s = 2*mean(xo*sin(2*pi*19300000000.0*tt))
  let m_b_two10_im3h_c = 2*mean(xo*cos(2*pi*19600000000.0*tt))
  let m_b_two10_im3h_s = 2*mean(xo*sin(2*pi*19600000000.0*tt))
  let m_b_two10_fl_lo_c = 2*mean(xo*cos(2*pi*19250000000.0*tt))
  let m_b_two10_fl_lo_s = 2*mean(xo*sin(2*pi*19250000000.0*tt))
  let m_b_two10_fl_hi_c = 2*mean(xo*cos(2*pi*19650000000.0*tt))
  let m_b_two10_fl_hi_s = 2*mean(xo*sin(2*pi*19650000000.0*tt))
  print m_b_two10_n m_b_two10_t0 m_b_two10_t1 m_b_two10_f1_c m_b_two10_f1_s m_b_two10_f2_c
  print m_b_two10_f2_s m_b_two10_im3l_c m_b_two10_im3l_s m_b_two10_im3h_c m_b_two10_im3h_s m_b_two10_fl_lo_c
  print m_b_two10_fl_lo_s m_b_two10_fl_hi_c m_b_two10_fl_hi_s
  * run b_two11: two-tone, available power -45 dBm per tone
  alterparam fq1 = 19400000000.0
  alterparam fq2 = 19500000000.0
  alterparam va1 = 0.00355655882007785
  alterparam va2 = 0.00355655882007785
  reset
  tran 1e-12 6e-08 0 1e-12
  linearize v(p2)
  let tt = time[40000,59999]
  let xo = v(p2)[40000,59999]
  let m_b_two11_n = length(xo)
  let m_b_two11_t0 = tt[0]
  let m_b_two11_t1 = tt[19999]
  let m_b_two11_f1_c = 2*mean(xo*cos(2*pi*19400000000.0*tt))
  let m_b_two11_f1_s = 2*mean(xo*sin(2*pi*19400000000.0*tt))
  let m_b_two11_f2_c = 2*mean(xo*cos(2*pi*19500000000.0*tt))
  let m_b_two11_f2_s = 2*mean(xo*sin(2*pi*19500000000.0*tt))
  let m_b_two11_im3l_c = 2*mean(xo*cos(2*pi*19300000000.0*tt))
  let m_b_two11_im3l_s = 2*mean(xo*sin(2*pi*19300000000.0*tt))
  let m_b_two11_im3h_c = 2*mean(xo*cos(2*pi*19600000000.0*tt))
  let m_b_two11_im3h_s = 2*mean(xo*sin(2*pi*19600000000.0*tt))
  let m_b_two11_fl_lo_c = 2*mean(xo*cos(2*pi*19250000000.0*tt))
  let m_b_two11_fl_lo_s = 2*mean(xo*sin(2*pi*19250000000.0*tt))
  let m_b_two11_fl_hi_c = 2*mean(xo*cos(2*pi*19650000000.0*tt))
  let m_b_two11_fl_hi_s = 2*mean(xo*sin(2*pi*19650000000.0*tt))
  print m_b_two11_n m_b_two11_t0 m_b_two11_t1 m_b_two11_f1_c m_b_two11_f1_s m_b_two11_f2_c
  print m_b_two11_f2_s m_b_two11_im3l_c m_b_two11_im3l_s m_b_two11_im3h_c m_b_two11_im3h_s m_b_two11_fl_lo_c
  print m_b_two11_fl_lo_s m_b_two11_fl_hi_c m_b_two11_fl_hi_s
  * run b_two12: two-tone, available power -44 dBm per tone
  alterparam fq1 = 19400000000.0
  alterparam fq2 = 19500000000.0
  alterparam va1 = 0.00399052462993776
  alterparam va2 = 0.00399052462993776
  reset
  tran 1e-12 6e-08 0 1e-12
  linearize v(p2)
  let tt = time[40000,59999]
  let xo = v(p2)[40000,59999]
  let m_b_two12_n = length(xo)
  let m_b_two12_t0 = tt[0]
  let m_b_two12_t1 = tt[19999]
  let m_b_two12_f1_c = 2*mean(xo*cos(2*pi*19400000000.0*tt))
  let m_b_two12_f1_s = 2*mean(xo*sin(2*pi*19400000000.0*tt))
  let m_b_two12_f2_c = 2*mean(xo*cos(2*pi*19500000000.0*tt))
  let m_b_two12_f2_s = 2*mean(xo*sin(2*pi*19500000000.0*tt))
  let m_b_two12_im3l_c = 2*mean(xo*cos(2*pi*19300000000.0*tt))
  let m_b_two12_im3l_s = 2*mean(xo*sin(2*pi*19300000000.0*tt))
  let m_b_two12_im3h_c = 2*mean(xo*cos(2*pi*19600000000.0*tt))
  let m_b_two12_im3h_s = 2*mean(xo*sin(2*pi*19600000000.0*tt))
  let m_b_two12_fl_lo_c = 2*mean(xo*cos(2*pi*19250000000.0*tt))
  let m_b_two12_fl_lo_s = 2*mean(xo*sin(2*pi*19250000000.0*tt))
  let m_b_two12_fl_hi_c = 2*mean(xo*cos(2*pi*19650000000.0*tt))
  let m_b_two12_fl_hi_s = 2*mean(xo*sin(2*pi*19650000000.0*tt))
  print m_b_two12_n m_b_two12_t0 m_b_two12_t1 m_b_two12_f1_c m_b_two12_f1_s m_b_two12_f2_c
  print m_b_two12_f2_s m_b_two12_im3l_c m_b_two12_im3l_s m_b_two12_im3h_c m_b_two12_im3h_s m_b_two12_fl_lo_c
  print m_b_two12_fl_lo_s m_b_two12_fl_hi_c m_b_two12_fl_hi_s
  * run b_two13: two-tone, available power -43 dBm per tone
  alterparam fq1 = 19400000000.0
  alterparam fq2 = 19500000000.0
  alterparam va1 = 0.00447744227713668
  alterparam va2 = 0.00447744227713668
  reset
  tran 1e-12 6e-08 0 1e-12
  linearize v(p2)
  let tt = time[40000,59999]
  let xo = v(p2)[40000,59999]
  let m_b_two13_n = length(xo)
  let m_b_two13_t0 = tt[0]
  let m_b_two13_t1 = tt[19999]
  let m_b_two13_f1_c = 2*mean(xo*cos(2*pi*19400000000.0*tt))
  let m_b_two13_f1_s = 2*mean(xo*sin(2*pi*19400000000.0*tt))
  let m_b_two13_f2_c = 2*mean(xo*cos(2*pi*19500000000.0*tt))
  let m_b_two13_f2_s = 2*mean(xo*sin(2*pi*19500000000.0*tt))
  let m_b_two13_im3l_c = 2*mean(xo*cos(2*pi*19300000000.0*tt))
  let m_b_two13_im3l_s = 2*mean(xo*sin(2*pi*19300000000.0*tt))
  let m_b_two13_im3h_c = 2*mean(xo*cos(2*pi*19600000000.0*tt))
  let m_b_two13_im3h_s = 2*mean(xo*sin(2*pi*19600000000.0*tt))
  let m_b_two13_fl_lo_c = 2*mean(xo*cos(2*pi*19250000000.0*tt))
  let m_b_two13_fl_lo_s = 2*mean(xo*sin(2*pi*19250000000.0*tt))
  let m_b_two13_fl_hi_c = 2*mean(xo*cos(2*pi*19650000000.0*tt))
  let m_b_two13_fl_hi_s = 2*mean(xo*sin(2*pi*19650000000.0*tt))
  print m_b_two13_n m_b_two13_t0 m_b_two13_t1 m_b_two13_f1_c m_b_two13_f1_s m_b_two13_f2_c
  print m_b_two13_f2_s m_b_two13_im3l_c m_b_two13_im3l_s m_b_two13_im3h_c m_b_two13_im3h_s m_b_two13_fl_lo_c
  print m_b_two13_fl_lo_s m_b_two13_fl_hi_c m_b_two13_fl_hi_s
  * run b_two14: two-tone, available power -42 dBm per tone
  alterparam fq1 = 19400000000.0
  alterparam fq2 = 19500000000.0
  alterparam va1 = 0.00502377286301916
  alterparam va2 = 0.00502377286301916
  reset
  tran 1e-12 6e-08 0 1e-12
  linearize v(p2)
  let tt = time[40000,59999]
  let xo = v(p2)[40000,59999]
  let m_b_two14_n = length(xo)
  let m_b_two14_t0 = tt[0]
  let m_b_two14_t1 = tt[19999]
  let m_b_two14_f1_c = 2*mean(xo*cos(2*pi*19400000000.0*tt))
  let m_b_two14_f1_s = 2*mean(xo*sin(2*pi*19400000000.0*tt))
  let m_b_two14_f2_c = 2*mean(xo*cos(2*pi*19500000000.0*tt))
  let m_b_two14_f2_s = 2*mean(xo*sin(2*pi*19500000000.0*tt))
  let m_b_two14_im3l_c = 2*mean(xo*cos(2*pi*19300000000.0*tt))
  let m_b_two14_im3l_s = 2*mean(xo*sin(2*pi*19300000000.0*tt))
  let m_b_two14_im3h_c = 2*mean(xo*cos(2*pi*19600000000.0*tt))
  let m_b_two14_im3h_s = 2*mean(xo*sin(2*pi*19600000000.0*tt))
  let m_b_two14_fl_lo_c = 2*mean(xo*cos(2*pi*19250000000.0*tt))
  let m_b_two14_fl_lo_s = 2*mean(xo*sin(2*pi*19250000000.0*tt))
  let m_b_two14_fl_hi_c = 2*mean(xo*cos(2*pi*19650000000.0*tt))
  let m_b_two14_fl_hi_s = 2*mean(xo*sin(2*pi*19650000000.0*tt))
  print m_b_two14_n m_b_two14_t0 m_b_two14_t1 m_b_two14_f1_c m_b_two14_f1_s m_b_two14_f2_c
  print m_b_two14_f2_s m_b_two14_im3l_c m_b_two14_im3l_s m_b_two14_im3h_c m_b_two14_im3h_s m_b_two14_fl_lo_c
  print m_b_two14_fl_lo_s m_b_two14_fl_hi_c m_b_two14_fl_hi_s
  * run b_two15: two-tone, available power -41 dBm per tone
  alterparam fq1 = 19400000000.0
  alterparam fq2 = 19500000000.0
  alterparam va1 = 0.00563676586252891
  alterparam va2 = 0.00563676586252891
  reset
  tran 1e-12 6e-08 0 1e-12
  linearize v(p2)
  let tt = time[40000,59999]
  let xo = v(p2)[40000,59999]
  let m_b_two15_n = length(xo)
  let m_b_two15_t0 = tt[0]
  let m_b_two15_t1 = tt[19999]
  let m_b_two15_f1_c = 2*mean(xo*cos(2*pi*19400000000.0*tt))
  let m_b_two15_f1_s = 2*mean(xo*sin(2*pi*19400000000.0*tt))
  let m_b_two15_f2_c = 2*mean(xo*cos(2*pi*19500000000.0*tt))
  let m_b_two15_f2_s = 2*mean(xo*sin(2*pi*19500000000.0*tt))
  let m_b_two15_im3l_c = 2*mean(xo*cos(2*pi*19300000000.0*tt))
  let m_b_two15_im3l_s = 2*mean(xo*sin(2*pi*19300000000.0*tt))
  let m_b_two15_im3h_c = 2*mean(xo*cos(2*pi*19600000000.0*tt))
  let m_b_two15_im3h_s = 2*mean(xo*sin(2*pi*19600000000.0*tt))
  let m_b_two15_fl_lo_c = 2*mean(xo*cos(2*pi*19250000000.0*tt))
  let m_b_two15_fl_lo_s = 2*mean(xo*sin(2*pi*19250000000.0*tt))
  let m_b_two15_fl_hi_c = 2*mean(xo*cos(2*pi*19650000000.0*tt))
  let m_b_two15_fl_hi_s = 2*mean(xo*sin(2*pi*19650000000.0*tt))
  print m_b_two15_n m_b_two15_t0 m_b_two15_t1 m_b_two15_f1_c m_b_two15_f1_s m_b_two15_f2_c
  print m_b_two15_f2_s m_b_two15_im3l_c m_b_two15_im3l_s m_b_two15_im3h_c m_b_two15_im3h_s m_b_two15_fl_lo_c
  print m_b_two15_fl_lo_s m_b_two15_fl_hi_c m_b_two15_fl_hi_s
  * run b_two16: two-tone, available power -40 dBm per tone
  alterparam fq1 = 19400000000.0
  alterparam fq2 = 19500000000.0
  alterparam va1 = 0.00632455532033676
  alterparam va2 = 0.00632455532033676
  reset
  tran 1e-12 6e-08 0 1e-12
  linearize v(p2)
  let tt = time[40000,59999]
  let xo = v(p2)[40000,59999]
  let m_b_two16_n = length(xo)
  let m_b_two16_t0 = tt[0]
  let m_b_two16_t1 = tt[19999]
  let m_b_two16_f1_c = 2*mean(xo*cos(2*pi*19400000000.0*tt))
  let m_b_two16_f1_s = 2*mean(xo*sin(2*pi*19400000000.0*tt))
  let m_b_two16_f2_c = 2*mean(xo*cos(2*pi*19500000000.0*tt))
  let m_b_two16_f2_s = 2*mean(xo*sin(2*pi*19500000000.0*tt))
  let m_b_two16_im3l_c = 2*mean(xo*cos(2*pi*19300000000.0*tt))
  let m_b_two16_im3l_s = 2*mean(xo*sin(2*pi*19300000000.0*tt))
  let m_b_two16_im3h_c = 2*mean(xo*cos(2*pi*19600000000.0*tt))
  let m_b_two16_im3h_s = 2*mean(xo*sin(2*pi*19600000000.0*tt))
  let m_b_two16_fl_lo_c = 2*mean(xo*cos(2*pi*19250000000.0*tt))
  let m_b_two16_fl_lo_s = 2*mean(xo*sin(2*pi*19250000000.0*tt))
  let m_b_two16_fl_hi_c = 2*mean(xo*cos(2*pi*19650000000.0*tt))
  let m_b_two16_fl_hi_s = 2*mean(xo*sin(2*pi*19650000000.0*tt))
  print m_b_two16_n m_b_two16_t0 m_b_two16_t1 m_b_two16_f1_c m_b_two16_f1_s m_b_two16_f2_c
  print m_b_two16_f2_s m_b_two16_im3l_c m_b_two16_im3l_s m_b_two16_im3h_c m_b_two16_im3h_s m_b_two16_fl_lo_c
  print m_b_two16_fl_lo_s m_b_two16_fl_hi_c m_b_two16_fl_hi_s
  * run b_two17: two-tone, available power -39 dBm per tone
  alterparam fq1 = 19400000000.0
  alterparam fq2 = 19500000000.0
  alterparam va1 = 0.00709626778467151
  alterparam va2 = 0.00709626778467151
  reset
  tran 1e-12 6e-08 0 1e-12
  linearize v(p2)
  let tt = time[40000,59999]
  let xo = v(p2)[40000,59999]
  let m_b_two17_n = length(xo)
  let m_b_two17_t0 = tt[0]
  let m_b_two17_t1 = tt[19999]
  let m_b_two17_f1_c = 2*mean(xo*cos(2*pi*19400000000.0*tt))
  let m_b_two17_f1_s = 2*mean(xo*sin(2*pi*19400000000.0*tt))
  let m_b_two17_f2_c = 2*mean(xo*cos(2*pi*19500000000.0*tt))
  let m_b_two17_f2_s = 2*mean(xo*sin(2*pi*19500000000.0*tt))
  let m_b_two17_im3l_c = 2*mean(xo*cos(2*pi*19300000000.0*tt))
  let m_b_two17_im3l_s = 2*mean(xo*sin(2*pi*19300000000.0*tt))
  let m_b_two17_im3h_c = 2*mean(xo*cos(2*pi*19600000000.0*tt))
  let m_b_two17_im3h_s = 2*mean(xo*sin(2*pi*19600000000.0*tt))
  let m_b_two17_fl_lo_c = 2*mean(xo*cos(2*pi*19250000000.0*tt))
  let m_b_two17_fl_lo_s = 2*mean(xo*sin(2*pi*19250000000.0*tt))
  let m_b_two17_fl_hi_c = 2*mean(xo*cos(2*pi*19650000000.0*tt))
  let m_b_two17_fl_hi_s = 2*mean(xo*sin(2*pi*19650000000.0*tt))
  print m_b_two17_n m_b_two17_t0 m_b_two17_t1 m_b_two17_f1_c m_b_two17_f1_s m_b_two17_f2_c
  print m_b_two17_f2_s m_b_two17_im3l_c m_b_two17_im3l_s m_b_two17_im3h_c m_b_two17_im3h_s m_b_two17_fl_lo_c
  print m_b_two17_fl_lo_s m_b_two17_fl_hi_c m_b_two17_fl_hi_s
  * run b_two18: two-tone, available power -38 dBm per tone
  alterparam fq1 = 19400000000.0
  alterparam fq2 = 19500000000.0
  alterparam va1 = 0.00796214341106995
  alterparam va2 = 0.00796214341106995
  reset
  tran 1e-12 6e-08 0 1e-12
  linearize v(p2)
  let tt = time[40000,59999]
  let xo = v(p2)[40000,59999]
  let m_b_two18_n = length(xo)
  let m_b_two18_t0 = tt[0]
  let m_b_two18_t1 = tt[19999]
  let m_b_two18_f1_c = 2*mean(xo*cos(2*pi*19400000000.0*tt))
  let m_b_two18_f1_s = 2*mean(xo*sin(2*pi*19400000000.0*tt))
  let m_b_two18_f2_c = 2*mean(xo*cos(2*pi*19500000000.0*tt))
  let m_b_two18_f2_s = 2*mean(xo*sin(2*pi*19500000000.0*tt))
  let m_b_two18_im3l_c = 2*mean(xo*cos(2*pi*19300000000.0*tt))
  let m_b_two18_im3l_s = 2*mean(xo*sin(2*pi*19300000000.0*tt))
  let m_b_two18_im3h_c = 2*mean(xo*cos(2*pi*19600000000.0*tt))
  let m_b_two18_im3h_s = 2*mean(xo*sin(2*pi*19600000000.0*tt))
  let m_b_two18_fl_lo_c = 2*mean(xo*cos(2*pi*19250000000.0*tt))
  let m_b_two18_fl_lo_s = 2*mean(xo*sin(2*pi*19250000000.0*tt))
  let m_b_two18_fl_hi_c = 2*mean(xo*cos(2*pi*19650000000.0*tt))
  let m_b_two18_fl_hi_s = 2*mean(xo*sin(2*pi*19650000000.0*tt))
  print m_b_two18_n m_b_two18_t0 m_b_two18_t1 m_b_two18_f1_c m_b_two18_f1_s m_b_two18_f2_c
  print m_b_two18_f2_s m_b_two18_im3l_c m_b_two18_im3l_s m_b_two18_im3h_c m_b_two18_im3h_s m_b_two18_fl_lo_c
  print m_b_two18_fl_lo_s m_b_two18_fl_hi_c m_b_two18_fl_hi_s
  * run b_two19: two-tone, available power -37 dBm per tone
  alterparam fq1 = 19400000000.0
  alterparam fq2 = 19500000000.0
  alterparam va1 = 0.00893367184301926
  alterparam va2 = 0.00893367184301926
  reset
  tran 1e-12 6e-08 0 1e-12
  linearize v(p2)
  let tt = time[40000,59999]
  let xo = v(p2)[40000,59999]
  let m_b_two19_n = length(xo)
  let m_b_two19_t0 = tt[0]
  let m_b_two19_t1 = tt[19999]
  let m_b_two19_f1_c = 2*mean(xo*cos(2*pi*19400000000.0*tt))
  let m_b_two19_f1_s = 2*mean(xo*sin(2*pi*19400000000.0*tt))
  let m_b_two19_f2_c = 2*mean(xo*cos(2*pi*19500000000.0*tt))
  let m_b_two19_f2_s = 2*mean(xo*sin(2*pi*19500000000.0*tt))
  let m_b_two19_im3l_c = 2*mean(xo*cos(2*pi*19300000000.0*tt))
  let m_b_two19_im3l_s = 2*mean(xo*sin(2*pi*19300000000.0*tt))
  let m_b_two19_im3h_c = 2*mean(xo*cos(2*pi*19600000000.0*tt))
  let m_b_two19_im3h_s = 2*mean(xo*sin(2*pi*19600000000.0*tt))
  let m_b_two19_fl_lo_c = 2*mean(xo*cos(2*pi*19250000000.0*tt))
  let m_b_two19_fl_lo_s = 2*mean(xo*sin(2*pi*19250000000.0*tt))
  let m_b_two19_fl_hi_c = 2*mean(xo*cos(2*pi*19650000000.0*tt))
  let m_b_two19_fl_hi_s = 2*mean(xo*sin(2*pi*19650000000.0*tt))
  print m_b_two19_n m_b_two19_t0 m_b_two19_t1 m_b_two19_f1_c m_b_two19_f1_s m_b_two19_f2_c
  print m_b_two19_f2_s m_b_two19_im3l_c m_b_two19_im3l_s m_b_two19_im3h_c m_b_two19_im3h_s m_b_two19_fl_lo_c
  print m_b_two19_fl_lo_s m_b_two19_fl_hi_c m_b_two19_fl_hi_s
  * run b_two20: two-tone, available power -36 dBm per tone
  alterparam fq1 = 19400000000.0
  alterparam fq2 = 19500000000.0
  alterparam va1 = 0.0100237446725454
  alterparam va2 = 0.0100237446725454
  reset
  tran 1e-12 6e-08 0 1e-12
  linearize v(p2)
  let tt = time[40000,59999]
  let xo = v(p2)[40000,59999]
  let m_b_two20_n = length(xo)
  let m_b_two20_t0 = tt[0]
  let m_b_two20_t1 = tt[19999]
  let m_b_two20_f1_c = 2*mean(xo*cos(2*pi*19400000000.0*tt))
  let m_b_two20_f1_s = 2*mean(xo*sin(2*pi*19400000000.0*tt))
  let m_b_two20_f2_c = 2*mean(xo*cos(2*pi*19500000000.0*tt))
  let m_b_two20_f2_s = 2*mean(xo*sin(2*pi*19500000000.0*tt))
  let m_b_two20_im3l_c = 2*mean(xo*cos(2*pi*19300000000.0*tt))
  let m_b_two20_im3l_s = 2*mean(xo*sin(2*pi*19300000000.0*tt))
  let m_b_two20_im3h_c = 2*mean(xo*cos(2*pi*19600000000.0*tt))
  let m_b_two20_im3h_s = 2*mean(xo*sin(2*pi*19600000000.0*tt))
  let m_b_two20_fl_lo_c = 2*mean(xo*cos(2*pi*19250000000.0*tt))
  let m_b_two20_fl_lo_s = 2*mean(xo*sin(2*pi*19250000000.0*tt))
  let m_b_two20_fl_hi_c = 2*mean(xo*cos(2*pi*19650000000.0*tt))
  let m_b_two20_fl_hi_s = 2*mean(xo*sin(2*pi*19650000000.0*tt))
  print m_b_two20_n m_b_two20_t0 m_b_two20_t1 m_b_two20_f1_c m_b_two20_f1_s m_b_two20_f2_c
  print m_b_two20_f2_s m_b_two20_im3l_c m_b_two20_im3l_s m_b_two20_im3h_c m_b_two20_im3h_s m_b_two20_fl_lo_c
  print m_b_two20_fl_lo_s m_b_two20_fl_hi_c m_b_two20_fl_hi_s
  echo LNLIN_DONE
.endc
