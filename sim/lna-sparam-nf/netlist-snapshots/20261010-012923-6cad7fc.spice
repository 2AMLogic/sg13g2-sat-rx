* Frozen netlist snapshot for record 20261010-012923-6cad7fc
* sha256     : b3ceba894c4bd8700ea54b733ec048cc0fa40a5a4a19c9505fd312465bef3f45
* This is a verbatim copy taken at record time. Do not edit.
* LNA first-stage (lna_stage1) S-parameter / noise-figure two-port fixture (issue #28).
*
* DUT: design/lna_stage1.sch -- npn13G2 cascode (Q1 common-emitter with a small
* emitter resistor, Q2 common-base), diode-mirror bias for Q1, divider bias for
* Q2, ideal lossless L/C input and output matching. Embedded below verbatim
* from design/netlist/lna_stage1.spice (xschem export).
*
* IDEAL / BEHAVIORAL MATCHING: Cshunt, Lin (input) and Lfeed, Cm (output) are
* ideal lossless ngspice L and C. No SG13G2 inductor model exists, so no loss,
* Q, self-resonance or layout parasitic is represented; every S11/S22/S21/NF
* number from this fixture is an upper bound for what a real passive match
* allows and is a FEASIBILITY figure only. Nothing here claims a spec row.
*
* Two-port test method: unchanged from lna_ce_placeholder.spice (power-wave
* injection through a Thevenin Z0 = 50 ohm source per port, forward/reverse by
* alterparam + reset, S = 2*V(port) - 1 for the driven port and 2*V(other)
* for the transmission term; Rs1 noiseless with the source noise added
* analytically at T0 = 300.15 K, issue #22). The DUT has its own DC blocks
* (Cblk_in, Cblk_out), so the ports connect directly.
*
* Ports: p1 = input, p2 = output, vdd = the PVT supply rail (vdd_val).

* ==== BEGIN design/netlist/lna_stage1.spice (verbatim; do not edit here) ====
* lna_stage1 subcircuit, exported by xschem from design/lna_stage1.sch via 'klt netlist --block'
* tools: XSCHEM V3.4.4; klt 0.7.0+g5e5b55992a7f; sources sha256 (lna_stage1.sch then lna_stage1.sym concatenated): c1a3c91f0ec775b4287c195dee05f305f8b1bf34e5b6ee27e83021a884ff46d4
* DERIVED FILE: regenerate with design/export_netlist.sh, never edit by hand.
* Matching elements (Cshunt, Lin, Lfeed, Cm) are IDEAL lossless L/C: no PDK inductor model exists.
** sch_path: design/lna_stage1.sch
.subckt lna_stage1 in out vdd gnd
*.ipin in
*.opin out
*.iopin vdd
*.iopin gnd
Rref vdd nr 8k m=1
Xqr nr nr er gnd npn13G2 Nx=1
Rer er gnd 24 m=1
Rbias nr b1 2k m=1
Lfeed vdd oc 0.962n m=1
Rd vdd oc 465 m=1
Xq2 oc b2 c1 gnd npn13G2 Nx=8
Xq1 c1 b1 e1 gnd npn13G2 Nx=8
Re1 e1 gnd 3 m=1
R1b vdd b2 1.5k m=1
R2b b2 gnd 7k m=1
Cb2 b2 gnd 10p m=1
Cshunt in gnd 170f m=1
Lin in in2 1.41n m=1
Cblk_in in2 b1 1n m=1
Cm oc out 57.8f m=1
.ends
* ==== END design/netlist/lna_stage1.spice ====

.param z0=50
.param mag1=1 mag2=0

Vdd vdd 0 DC {vdd_val}
Xdut p1 p2 vdd 0 lna_stage1

Vs1 s1n 0 DC 0 AC {mag1}
Rs1 s1n p1 {z0} noisy=0

Vs2 s2n 0 DC 0 AC {mag2}
Rs2 s2n p2 {z0}
