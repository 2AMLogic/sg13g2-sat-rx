* LNA first-stage (lna_stage1) S-parameter / noise-figure two-port fixture (issue #28).
*
* DUT: design/lna_stage1.sch -- npn13G2 cascode (Q1 common-emitter with a small
* emitter resistor, Q2 common-base), diode-mirror bias for Q1, divider bias for
* Q2, ideal lossless L/C input and output matching. Embedded below verbatim
* from design/netlist/lna_stage1.spice (xschem export).
*
* IDEAL / BEHAVIORAL MATCHING: Cshunt, Lin (input) and Lfeed, Cm (output) are
* ideal lossless ngspice L and C. No SG13G2 inductor model exists, so no loss,
* Q, self-resonance or layout parasitic is represented; every S11/S22/S21/NF
* number from this fixture is an upper bound for what a real passive match
* allows and is a FEASIBILITY figure only. Nothing here claims a spec row.
*
* Two-port test method: unchanged from lna_ce_placeholder.spice (power-wave
* injection through a Thevenin Z0 = 50 ohm source per port, forward/reverse by
* alterparam + reset, S = 2*V(port) - 1 for the driven port and 2*V(other)
* for the transmission term; Rs1 noiseless with the source noise added
* analytically at T0 = 300.15 K, issue #22). The DUT has its own DC blocks
* (Cblk_in, Cblk_out), so the ports connect directly.
*
* Ports: p1 = input, p2 = output, vdd = the PVT supply rail (vdd_val).

* ==== BEGIN design/netlist/lna_stage1.spice (verbatim; do not edit here) ====
* lna_stage1 subcircuit, exported by xschem from design/lna_stage1.sch via 'klt netlist --block'
* tools: XSCHEM V3.4.7; klt 0.9.2.dev1022+g2a9c52b27ce7; sources sha256 (lna_stage1.sch then lna_stage1.sym concatenated): c6c82d72a0e711158ae6fc75a4d4f7e6293eba6b75819432d08b29b52eda64c2
* DERIVED FILE: regenerate with design/export_netlist.sh, never edit by hand.
* Matching elements (Cshunt, Lin, Lfeed, Cm) and the emitter-degeneration inductor Le1 are IDEAL lossless L/C: no PDK inductor model exists.
** klt-netlist-inputs: {"pdk_variant": "ihp-sg13cmos5l", "rcfile": "xschemrc", "xschem_version": "3.4.7"}
** sch_path: design/lna_stage1.sch
.subckt lna_stage1 in out vdd gnd
*.ipin in
*.opin out
*.iopin vdd
*.iopin gnd
Rref vdd nr 8k m=1
Xqr nr br er gnd npn13G2 Nx=1
Rbr nr br 60.9k m=1
Rer er gnd 24 m=1
Rbias nr b1 10k m=1
Lfeed vdd oc 0.962n m=1
Rd vdd oc 465 m=1
Xq2 oc b2 c1 gnd npn13G2 Nx=8
Xq1 c1 b1 e1 gnd npn13G2 Nx=8
Le1 e1 e1d 67p m=1
Re1 e1d gnd 3 m=1
R1b vdd b2 1.5k m=1
R2b b2 gnd 7k m=1
Cb2 b2 gnd 10p m=1
Cshunt in gnd 170f m=1
Lin in in2 1.41n m=1
Cblk_in in2 b1 1n m=1
Cm oc out 57.8f m=1
.ends
* ==== END design/netlist/lna_stage1.spice ====

.param z0=50
.param mag1=1 mag2=0

Vdd vdd 0 DC {vdd_val}
Xdut p1 p2 vdd 0 lna_stage1

Vs1 s1n 0 DC 0 AC {mag1}
Rs1 s1n p1 {z0} noisy=0

Vs2 s2n 0 DC 0 AC {mag2}
Rs2 s2n p2 {z0}
